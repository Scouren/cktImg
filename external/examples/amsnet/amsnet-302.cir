* official Analog Canvas netlist; PDK X cards rewritten by convert.py
.model nch nmos

.subckt dut VDD VSS Vin Vout
CB X Vin 1p
IB VDD VG DC 1m
M1 Vout X VSS VSS nch l=0.15 w=1 nf=1 m=1
MB net0 net0 VSS VSS nch l=0.15 w=1 nf=1 m=1
MC VG VG net0 VSS nch l=0.15 w=1 nf=1 m=1
MR net0 VG X VSS nch l=0.15 w=1 nf=1 m=1
RD VDD Vout 1k
.ends dut
