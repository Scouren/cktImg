* official Analog Canvas netlist; PDK X cards rewritten by convert.py
.model nch nmos

.subckt dut VDD VSS Vin Vb
I1 VDD VSS DC 1m
M1 net0 Vin VSS VSS nch l=0.15 w=1 nf=1 m=1
M2 VSS Vb net0 VSS nch l=0.15 w=1 nf=1 m=1
rO1 net0 VSS 1k
rO2 VSS net0 1k
.ends dut
