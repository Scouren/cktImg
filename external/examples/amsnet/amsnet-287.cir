* official Analog Canvas netlist; PDK X cards rewritten by convert.py
.model nch nmos
.model pch pmos

.subckt dut VDD VSS VinCM Vout
M1 F VinCM P VSS nch l=0.15 w=1 nf=1 m=1
M2 Vout VinCM P VSS nch l=0.15 w=1 nf=1 m=1
M3 F F VDD VDD pch l=0.15 w=1 nf=1 m=1
M4 Vout F VDD VDD pch l=0.15 w=1 nf=1 m=1
RSS P VSS 1k
.ends dut
