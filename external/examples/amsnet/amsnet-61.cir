* official Analog Canvas netlist; PDK X cards rewritten by convert.py
.model nch nmos
.model pch pmos

.subckt dut VDD VSS VG
M1 net1 VG net0 VDD pch l=0.15 w=1 nf=1 m=1
M2 net1 VG VSS VSS nch l=0.15 w=1 nf=1 m=1
Vx net0 VSS DC 1
.ends dut
