* official Analog Canvas netlist; PDK X cards rewritten by convert.py
.model nch nmos

.subckt dut VDD VSS Vout2
M1 net0 net2 net1 VSS nch l=0.15 w=1 nf=1 m=1
M2 Vout2 VSS net1 VSS nch l=0.15 w=1 nf=1 m=1
RD1 VDD net0 1k
RD2 VDD Vout2 1k
Vin1 net2 VSS DC 1
.ends dut
