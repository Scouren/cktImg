* official Analog Canvas netlist; PDK X cards rewritten by convert.py
.model nch nmos
.model pch pmos

.subckt dut VDD VSS Vin1 Vin2 Vout1 Vout2 Vb1 Vb2 Vb3
CC1 net0 Vout1 1p
CC2 Vout2 net2 1p
CL1 Vout1 VSS 1p
CL2 Vout2 VSS 1p
I1 Vout1 VSS DC 1m
I2 Vout2 VSS DC 1m
ISS net3 VSS DC 1m
M1 net0 Vin1 net3 VSS nch l=0.15 w=1 nf=1 m=1
M10 Vout1 Y VDD VDD pch l=0.15 w=1 nf=1 m=1
M2 net2 Vin2 net3 VSS nch l=0.15 w=1 nf=1 m=1
M3 Y Vb3 net0 VSS nch l=0.15 w=1 nf=1 m=1
M4 X Vb3 net2 VSS nch l=0.15 w=1 nf=1 m=1
M5 Y Vb2 net4 VDD pch l=0.15 w=1 nf=1 m=1
M6 X Vb2 net1 VDD pch l=0.15 w=1 nf=1 m=1
M7 net4 Vb1 VDD VDD pch l=0.15 w=1 nf=1 m=1
M8 net1 Vb1 VDD VDD pch l=0.15 w=1 nf=1 m=1
M9 Vout2 X VDD VDD pch l=0.15 w=1 nf=1 m=1
.ends dut
