* official Analog Canvas netlist; PDK X cards rewritten by convert.py
.model nch nmos

.subckt dut VDD VSS Vin Vout VX
M1 Vout Vin VX VSS nch l=0.15 w=1 nf=1 m=1
R1 VDD Vout 1k
.ends dut
