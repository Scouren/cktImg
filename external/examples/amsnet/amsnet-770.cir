* official Analog Canvas netlist; PDK X cards rewritten by convert.py
.model pch pmos

.global VDD

.subckt dut VSS
IREF net0 VSS DC 1m
M1 net2 net0 net1 VDD pch l=0.15 w=1 nf=1 m=1
M2 net1 net2 VDD VDD pch l=0.15 w=1 nf=1 m=1
R net2 net0 1k
.ends dut
