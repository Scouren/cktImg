* official Analog Canvas netlist; PDK X cards rewritten by convert.py
.model nch nmos

.subckt dut VDD VSS Vn_out Vin
CL Vn_out VSS 1p
M1 Vn_out net0 VSS VSS nch l=0.15 w=1 nf=1 m=1
RD VDD Vn_out 1k
Vn_M1 net0 Vin DC 1
.ends dut
