* official Analog Canvas netlist; PDK X cards rewritten by convert.py
.model nch nmos
.model pch pmos

.subckt dut VDD VSS Vin1 Vin2 Vb3 Vb2 Vb1 Vb4 Vout1 Vout2 Vb5
M1 net1 Vin1 net0 VSS nch l=0.15 w=1 nf=1 m=1
M10 net3 Vb4 VSS VSS nch l=0.15 w=1 nf=1 m=1
M11 net0 Vb5 VSS VSS nch l=0.15 w=1 nf=1 m=1
M2 net4 Vin2 net0 VSS nch l=0.15 w=1 nf=1 m=1
M3 Vout1 Vb1 net2 VSS nch l=0.15 w=1 nf=1 m=1
M4 Vout2 Vb1 net3 VSS nch l=0.15 w=1 nf=1 m=1
M5 Vout1 Vb2 net1 VDD pch l=0.15 w=1 nf=1 m=1
M6 Vout2 Vb2 net4 VDD pch l=0.15 w=1 nf=1 m=1
M7 net1 Vb3 VDD VDD pch l=0.15 w=1 nf=1 m=1
M8 net4 Vb3 VDD VDD pch l=0.15 w=1 nf=1 m=1
M9 net2 Vb4 VSS VSS nch l=0.15 w=1 nf=1 m=1
.ends dut
