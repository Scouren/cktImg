* official Analog Canvas netlist; PDK X cards rewritten by convert.py

.subckt dut P N
CGS net1 P 1p
CL net0 net1 1p
R1 net0 N 1k
.ends dut
