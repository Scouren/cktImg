* official Analog Canvas netlist; PDK X cards rewritten by convert.py
.model nch nmos
.model pch pmos

.subckt dut VDD VSS Vin Vout
I1 net2 VSS DC 1m
M1 net1 Vin net2 VSS nch l=0.15 w=1 nf=1 m=1
M2 Vout net0 net2 VSS nch l=0.15 w=1 nf=1 m=1
M3 net1 net1 VDD VDD pch l=0.15 w=1 nf=1 m=1
M4 Vout net1 VDD VDD pch l=0.15 w=1 nf=1 m=1
R1 Vout net0 1k
R2 net0 VSS 1k
.ends dut
