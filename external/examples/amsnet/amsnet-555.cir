* official Analog Canvas netlist; PDK X cards rewritten by convert.py
.model nch nmos

.subckt dut VDD VSS Vout Vin
C1 Vout P 1p
C2 P VSS 1p
I1 Vin VSS DC 1m
M1 Vout P Vin VSS nch l=0.15 w=1 nf=1 m=1
RD VDD Vout 1k
.ends dut
