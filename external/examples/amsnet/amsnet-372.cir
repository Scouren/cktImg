* official Analog Canvas netlist; PDK X cards rewritten by convert.py
.model nch nmos

.subckt dut VDD VSS Vin
CGS Vin net0 1p
CL net0 VSS 1p
M1 VDD Vin net0 VSS nch l=0.15 w=1 nf=1 m=1
.ends dut
