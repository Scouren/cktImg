* official Analog Canvas netlist; PDK X cards rewritten by convert.py
.model nch nmos

.subckt dut VDD VSS X Y Vin_CM P
M1 X Vin_CM P VSS nch l=0.15 w=1 nf=1 m=1
M2 Y Vin_CM P VSS nch l=0.15 w=1 nf=1 m=1
RD1 VDD X 1k
RD2 VDD Y 1k
RSS P VSS 1k
.ends dut
