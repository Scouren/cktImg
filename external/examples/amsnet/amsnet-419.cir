* official Analog Canvas netlist; PDK X cards rewritten by convert.py
.model nch nmos
.model pch pmos

.subckt dut VDD VSS Vb Vin Vout
C1 Vout net0 1p
C2 net1 VSS 1p
M1 net2 Vin VSS VSS nch l=0.15 w=1 nf=1 m=1
M2 Vout net0 net2 VSS nch l=0.15 w=1 nf=1 m=1
M3 Vout net1 VDD VDD pch l=0.15 w=1 nf=1 m=1
R1 net0 Vb 1k
R2 Vout net1 1k
.ends dut
