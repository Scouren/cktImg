* official Analog Canvas netlist; PDK X cards rewritten by convert.py
.model nch nmos

.subckt dut VSS
Iin VSS net0 DC 1m
M1 VSS net0 VSS VSS nch l=0.15 w=1 nf=1 m=1
RF VSS net0 1k
.ends dut
