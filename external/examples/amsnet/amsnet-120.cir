* official Analog Canvas netlist; PDK X cards rewritten by convert.py
.model nch nmos

.subckt dut VDD VSS Vb
I1 VDD net0 DC 1m
M1 net0 Vb net1 VSS nch l=0.15 w=1 nf=1 m=1
rO net0 net1 1k
VX net1 VSS DC 1
.ends dut
