* official Analog Canvas netlist; PDK X cards rewritten by convert.py
.model nch nmos

.subckt dut VSS Vb1 Vb2
C1 Y Vb1 1p
M1 Y Vb1 X VSS nch l=0.15 w=1 nf=1 m=1
M2 X Vb2 VSS VSS nch l=0.15 w=1 nf=1 m=1
.ends dut
