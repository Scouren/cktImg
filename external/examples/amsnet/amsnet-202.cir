* official Analog Canvas netlist; PDK X cards rewritten by convert.py
.model nch nmos

.subckt dut VSS P Iout1 Iout2
IT P VSS DC 1m
M1 Iout1 net1 P VSS nch l=0.15 w=1 nf=1 m=1
M2 Iout2 net0 P VSS nch l=0.15 w=1 nf=1 m=1
Vin1 net1 VSS DC 1
Vin2 net0 VSS DC 1
.ends dut
