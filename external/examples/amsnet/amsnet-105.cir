* official Analog Canvas netlist; PDK X cards rewritten by convert.py
.model nch nmos
.model pch pmos

.subckt dut VDD VSS Vin Vout
M1 VDD Vin Vout VSS nch l=0.15 w=1 nf=1 m=1
M2 VSS VSS Vout VDD pch l=0.15 w=1 nf=1 m=1
.ends dut
