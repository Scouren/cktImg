* official Analog Canvas netlist; PDK X cards rewritten by convert.py
.model nch nmos
.model pch pmos

.subckt dut VDD VSS
M1 net0 VSS net1 VSS nch l=0.15 w=1 nf=1 m=1
M2 net2 VSS net1 VSS nch l=0.15 w=1 nf=1 m=1
M3 net0 net0 VDD VDD pch l=0.15 w=1 nf=1 m=1
M4 net2 net0 VDD VDD pch l=0.15 w=1 nf=1 m=1
VX net2 VSS DC 1
.ends dut
