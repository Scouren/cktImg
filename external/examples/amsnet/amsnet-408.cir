* official Analog Canvas netlist; PDK X cards rewritten by convert.py
.model nch nmos

.subckt dut VDD VSS Vin
C1 net0 net1 1p
C2 net1 VSS 1p
I1 VDD net0 DC 1m
M1 net0 net1 Vin VSS nch l=0.15 w=1 nf=1 m=1
.ends dut
