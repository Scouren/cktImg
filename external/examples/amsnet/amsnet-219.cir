* official Analog Canvas netlist; PDK X cards rewritten by convert.py
.model nch nmos

.subckt dut VDD VSS A B X Vout P Vin1 Vin2
CP P VSS 1p
ISS1 net0 VSS DC 1m
ISS2 P VSS DC 1m
M1 A Vin1 net0 VSS nch l=0.15 w=1 nf=1 m=1
M2 B Vin2 net0 VSS nch l=0.15 w=1 nf=1 m=1
M3 X B P VSS nch l=0.15 w=1 nf=1 m=1
M4 Vout A P VSS nch l=0.15 w=1 nf=1 m=1
RD1 VDD A 1k
RD2 VDD B 1k
RD3 VDD X 1k
RD4 VDD Vout 1k
.ends dut
