* official Analog Canvas netlist; PDK X cards rewritten by convert.py
.model nch nmos

.subckt dut VDD VSS X Y
C1 X net0 1p
M1 Y X VSS VSS nch l=0.15 w=1 nf=1 m=1
M2 X X net0 VSS nch l=0.15 w=1 nf=1 m=1
R1a VDD X 1k
R1b VDD Y 1k
.ends dut
