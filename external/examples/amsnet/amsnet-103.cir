* official Analog Canvas netlist; PDK X cards rewritten by convert.py

.subckt dut VSS Vout
R1 Vout net0 1k
R2 Vout VSS 1k
Vin net0 VSS DC 1
.ends dut
