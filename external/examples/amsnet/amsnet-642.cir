* official Analog Canvas netlist; PDK X cards rewritten by convert.py
.model nch nmos
.model pch pmos

.subckt dut VDD VSS X Y Vb1 Vb2 Vb3 Vb4 Vin1 Vin2
C1 net0 Vin1 1p
C2 net1 Vin2 1p
I1 net8 VSS DC 1m
M1 net4 net3 net8 VSS nch l=0.15 w=1 nf=1 m=1
M10 net5 Vb1 VDD VDD pch l=0.15 w=1 nf=1 m=1
M2 net5 net2 net8 VSS nch l=0.15 w=1 nf=1 m=1
M3 X Vb2 net4 VDD pch l=0.15 w=1 nf=1 m=1
M4 Y Vb2 net5 VDD pch l=0.15 w=1 nf=1 m=1
M5 X Vb3 net6 VSS nch l=0.15 w=1 nf=1 m=1
M6 Y Vb3 net7 VSS nch l=0.15 w=1 nf=1 m=1
M7 net6 Vb4 VSS VSS nch l=0.15 w=1 nf=1 m=1
M8 net7 Vb4 VSS VSS nch l=0.15 w=1 nf=1 m=1
M9 net4 Vb1 VDD VDD pch l=0.15 w=1 nf=1 m=1
R1 net3 net0 1k
R2 net2 net1 1k
R3 net3 X 1k
R4 Y net2 1k
.ends dut
