* official Analog Canvas netlist; PDK X cards rewritten by convert.py
.model nch nmos

.subckt dut VDD VSS Vout2
M2 Vout2 VSS net0 VSS nch l=0.15 w=1 nf=1 m=1
RD2 VDD Vout2 1k
RT net0 net1 1k
VT net1 VSS DC 1
.ends dut
