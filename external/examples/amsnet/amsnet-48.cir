* official Analog Canvas netlist; PDK X cards rewritten by convert.py
.model nch nmos

.subckt dut VSS +2V VX
C1 VX net0 1p
C2 net0 VSS 1p
M1 VX +2V net0 VSS nch l=0.15 w=1 nf=1 m=1
.ends dut
