* official Analog Canvas netlist; PDK X cards rewritten by convert.py
.model nch nmos
.model pch pmos

.subckt dut VDD VSS Vin Vout
C1 VSS net0 1p
Cin X Vin 1p
I1 VDD net0 DC 1m
M1 Vout X VSS VSS nch l=0.15 w=1 nf=1 m=1
M2 Vout X net0 VDD pch l=0.15 w=1 nf=1 m=1
RF Vout X 1k
.ends dut
