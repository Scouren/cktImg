* official Analog Canvas netlist; PDK X cards rewritten by convert.py
.model nch nmos

.subckt dut VDD VSS G B D S
CDB B D 1p
CGB B G 1p
CGD D G 1p
CGS S G 1p
CSB B S 1p
M1 D G S VSS nch l=0.15 w=1 nf=1 m=1
.ends dut
