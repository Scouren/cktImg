* official Analog Canvas netlist; PDK X cards rewritten by convert.py

.subckt dut VSS Vin Vout
CH Vout VSS 1p
Ron Vout Vin 1k
.ends dut
