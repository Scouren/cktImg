* official Analog Canvas netlist; PDK X cards rewritten by convert.py
.model nch nmos
.model pch pmos

.subckt dut VDD VSS Vb Vin Vout
CL1 VX VSS 1p
CL2 Vout VSS 1p
M1 VX Vin VSS VSS nch l=0.15 w=1 nf=1 m=1
M2 VX Vb VDD VDD pch l=0.15 w=1 nf=1 m=1
M3 Vout VX VSS VSS nch l=0.15 w=1 nf=1 m=1
M4 Vout Vb VDD VDD pch l=0.15 w=1 nf=1 m=1
.ends dut
