* official Analog Canvas netlist; PDK X cards rewritten by convert.py
.model nch nmos

.subckt dut VDD VSS Vin Vout Vb
M1 VDD X Vout VSS nch l=0.15 w=1 nf=1 m=1
M2 Vout Vb VSS VSS nch l=0.15 w=1 nf=1 m=1
M3 X Vin VSS VSS nch l=0.15 w=1 nf=1 m=1
RD VDD X 1k
.ends dut
