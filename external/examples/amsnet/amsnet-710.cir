* official Analog Canvas netlist; PDK X cards rewritten by convert.py
.model nch nmos
.model pch pmos

.subckt dut VDD VSS Vin1 Vin2 Vb3 Vb2 Vb1 Vb4 Vout1 Vout2 Vb5
M1 net5 Vin1 net4 VSS nch l=0.15 w=1 nf=1 m=1
M10 net1 Vb4 VSS VSS nch l=0.15 w=1 nf=1 m=1
M11 net4 Vb5 VSS VSS nch l=0.15 w=1 nf=1 m=1
M2 net0 Vin2 net4 VSS nch l=0.15 w=1 nf=1 m=1
M3 Vout1 Vb1 net3 VSS nch l=0.15 w=1 nf=1 m=1
M4 Vout2 Vb1 net1 VSS nch l=0.15 w=1 nf=1 m=1
M5 Vout1 Vb2 net5 VDD pch l=0.15 w=1 nf=1 m=1
M6 Vout2 Vb2 net0 VDD pch l=0.15 w=1 nf=1 m=1
M7 net5 net2 VDD VDD pch l=0.15 w=1 nf=1 m=1
M8 net0 Vb3 VDD VDD pch l=0.15 w=1 nf=1 m=1
M9 net3 Vb4 VSS VSS nch l=0.15 w=1 nf=1 m=1
V1 net2 VSS DC 1
.ends dut
