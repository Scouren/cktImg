* official Analog Canvas netlist; PDK X cards rewritten by convert.py
.model nch nmos

.subckt dut VDD VSS Vb
IREF VDD X DC 1m
M0 X Vb A VSS nch l=0.15 w=1 nf=1 m=1
M1 A X VSS VSS nch l=0.15 w=1 nf=1 m=1
.ends dut
