* official Analog Canvas netlist; PDK X cards rewritten by convert.py
.model nch nmos
.model pch pmos

.subckt dut VDD VSS Vb Vin1 Vin2 Vout1 Vout2
ISS net2 VSS DC 1m
M1 net1 Vin1 net2 VSS nch l=0.15 w=1 nf=1 m=1
M2 net0 Vin2 net2 VSS nch l=0.15 w=1 nf=1 m=1
M3 net1 Vb VDD VDD pch l=0.15 w=1 nf=1 m=1
M4 net0 Vb VDD VDD pch l=0.15 w=1 nf=1 m=1
M5 Vout1 net1 VDD VDD pch l=0.15 w=1 nf=1 m=1
M6 Vout2 net0 VDD VDD pch l=0.15 w=1 nf=1 m=1
M7 Vout1 Vb VSS VSS nch l=0.15 w=1 nf=1 m=1
M8 Vout2 Vb VSS VSS nch l=0.15 w=1 nf=1 m=1
.ends dut
