* official Analog Canvas netlist; PDK X cards rewritten by convert.py
.model nch nmos

.subckt dut VSS Vout1 P Vout2
M7 P Vout1 VSS VSS nch l=0.15 w=1 nf=1 m=1
M8 P Vout2 VSS VSS nch l=0.15 w=1 nf=1 m=1
.ends dut
