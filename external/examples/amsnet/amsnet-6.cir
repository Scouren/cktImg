* official Analog Canvas netlist; PDK X cards rewritten by convert.py

.subckt dut VSS Iout
I1 Iout VSS DC 1m
.ends dut
