* official Analog Canvas netlist; PDK X cards rewritten by convert.py
.model nch nmos

.subckt dut VDD VSS Vout2+ Vout2- Vin1 Vin2 Vcont2
G2 net0 VSS Vcont2 VSS 1m
M3 Vout2- Vin1 net0 VSS nch l=0.15 w=1 nf=1 m=1
M4 Vout2+ Vin2 net0 VSS nch l=0.15 w=1 nf=1 m=1
RD1 VDD Vout2- 1k
RD2 VDD Vout2+ 1k
.ends dut
