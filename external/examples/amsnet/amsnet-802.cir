* official Analog Canvas netlist; PDK X cards rewritten by convert.py
.model nch nmos

.subckt dut VSS Vin Vout CK
C1 Vout VSS 1p
M1 Vout CK Vin VSS nch l=0.15 w=1 nf=1 m=1
.ends dut
