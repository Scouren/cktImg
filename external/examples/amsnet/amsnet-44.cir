* official Analog Canvas netlist; PDK X cards rewritten by convert.py
.model nch nmos

.subckt dut VSS Vb VX
C1 VX VSS 1p
I1 net0 VSS DC 1m
M1 VX Vb net0 VSS nch l=0.15 w=1 nf=1 m=1
.ends dut
