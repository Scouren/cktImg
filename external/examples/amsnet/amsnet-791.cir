* official Analog Canvas netlist; PDK X cards rewritten by convert.py

.subckt dut VSS
C1 net1 VSS 1p
C2 net0 net1 1p
Cin net1 VSS 1p
CL net0 VSS 1p
R1 net0 VSS 1k
.ends dut
