* official Analog Canvas netlist; PDK X cards rewritten by convert.py
.model nch nmos

.subckt dut VDD VSS X Y
ISS net3 VSS DC 1m
M1 X net0 net2 VSS nch l=0.15 w=1 nf=1 m=1
M2 Y net1 net4 VSS nch l=0.15 w=1 nf=1 m=1
RD1 VDD X 1k
RD2 VDD Y 1k
RS1 net3 net2 1k
RS2 net4 net3 1k
Vin1 net0 VSS DC 1
Vin2 net1 VSS DC 1
.ends dut
