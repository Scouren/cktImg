* official Analog Canvas netlist; PDK X cards rewritten by convert.py
.model nch nmos

.subckt dut VDD VSS Vin Vb Vout1 Vout2
I1 VDD Vout1 DC 1m
ISS net0 VSS DC 1m
M1 Vout1 Vin net0 VSS nch l=0.15 w=1 nf=1 m=1
M2 Vout2 Vb net0 VSS nch l=0.15 w=1 nf=1 m=1
R1 VDD Vout2 1k
.ends dut
