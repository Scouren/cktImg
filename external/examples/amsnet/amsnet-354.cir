* official Analog Canvas netlist; PDK X cards rewritten by convert.py
.model nch nmos
.model pch pmos

.subckt dut VDD VSS Vin V1 Vout X P
CL Vout VSS 1p
ISS P VSS DC 1m
M1 X Vin P VSS nch l=0.15 w=1 nf=1 m=1
M2 Vout V1 P VSS nch l=0.15 w=1 nf=1 m=1
M3 X X VDD VDD pch l=0.15 w=1 nf=1 m=1
M4 Vout X VDD VDD pch l=0.15 w=1 nf=1 m=1
.ends dut
