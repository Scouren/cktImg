* official Analog Canvas netlist; PDK X cards rewritten by convert.py
.model nch nmos

.subckt dut VDD VSS Vb Vin
M1 net0 Vb Vin VSS nch l=0.15 w=1 nf=1 m=1
RD VDD net0 1k
rO net0 Vin 1k
.ends dut
