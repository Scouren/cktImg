* official Analog Canvas netlist; PDK X cards rewritten by convert.py
.model pch pmos

.subckt dut VDD VSS +1V Vout
M1 Vout +1V net0 VDD pch l=0.15 w=1 nf=1 m=1
R1 Vout VSS 1k
Vin net0 VSS DC 1
.ends dut
