* official Analog Canvas netlist; PDK X cards rewritten by convert.py
.model nch nmos

.subckt dut VSS VX
C1 net1 net0 1p
C2 VX net0 1p
M1 VX net0 net1 VSS nch l=0.15 w=1 nf=1 m=1
Vin net1 VSS DC 1
.ends dut
