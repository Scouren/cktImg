* official Analog Canvas netlist; PDK X cards rewritten by convert.py
.model nch nmos
.model pch pmos

.subckt dut VDD VSS Vb Vin1 Vin2 Vout1 Vout2
C1 net2 net3 1p
C2 VDD net1 1p
ISS net0 VSS DC 1m
M1 net4 Vin1 net0 VSS nch l=0.15 w=1 nf=1 m=1
M2 net2 Vin2 net0 VSS nch l=0.15 w=1 nf=1 m=1
M3 Vout1 net1 VDD VDD pch l=0.15 w=1 nf=1 m=1
M4 Vout2 net1 VDD VDD pch l=0.15 w=1 nf=1 m=1
M5 Vout2 Vb net2 VSS nch l=0.15 w=1 nf=1 m=1
M6 Vout1 Vb net4 VSS nch l=0.15 w=1 nf=1 m=1
R1 net3 net4 1k
R2a net1 Vout1 1k
R2b Vout2 net1 1k
.ends dut
