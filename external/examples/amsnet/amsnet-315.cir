* official Analog Canvas netlist; PDK X cards rewritten by convert.py
.model nch nmos

.subckt dut VDD VSS Vin Vout
IB VDD net0 DC 1m
M1 VDD Vin Vout VSS nch l=0.15 w=1 nf=1 m=1
M2 Vout net0 VSS VSS nch l=0.15 w=1 nf=1 m=1
MB net0 net0 VSS VSS nch l=0.15 w=1 nf=1 m=1
.ends dut
