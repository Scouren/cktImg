* official Analog Canvas netlist; PDK X cards rewritten by convert.py
.model pch pmos

.subckt dut VDD VSS +1V
M1 net1 +1V net0 VDD pch l=0.15 w=1 nf=1 m=1
V1 net1 VSS DC 1.9V
VX net0 VSS DC 1
.ends dut
