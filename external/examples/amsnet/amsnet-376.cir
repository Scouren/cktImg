* official Analog Canvas netlist; PDK X cards rewritten by convert.py
.model nch nmos

.subckt dut VDD VSS Vout
CGS2 net0 Vout 1p
M2 VDD net0 Vout VSS nch l=0.15 w=1 nf=1 m=1
RS net0 VDD 1k
.ends dut
