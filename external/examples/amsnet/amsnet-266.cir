* official Analog Canvas netlist; PDK X cards rewritten by convert.py
.model nch nmos

.subckt dut VDD VSS X
I1 VDD Vb DC 1m
M0 X Vb A VSS nch l=0.15 w=1 nf=1 m=1
M1 A X VSS VSS nch l=0.15 w=1 nf=1 m=1
M6 net0 Vb VSS VSS nch l=0.15 w=1 nf=1 m=1
M7 Vb Vb net0 VSS nch l=0.15 w=1 nf=1 m=1
.ends dut
