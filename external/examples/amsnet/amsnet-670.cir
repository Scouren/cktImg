* official Analog Canvas netlist; PDK X cards rewritten by convert.py
.model nch nmos
.model pch pmos

.subckt dut VDD VSS Vb Vout_CM
G1 net2 VSS Vout_CM VSS 1m
M1 net1 VSS net0 VSS nch l=0.15 w=1 nf=1 m=1
M5 Vout_CM VSS net1 VDD pch l=0.15 w=1 nf=1 m=1
M9 net0 Vb net2 VSS nch l=0.15 w=1 nf=1 m=1
R1 VSS net1 1k
R2 net2 VSS 1k
R3 Vout_CM VSS 1k
.ends dut
