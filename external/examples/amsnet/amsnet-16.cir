* official Analog Canvas netlist; PDK X cards rewritten by convert.py
.model nch nmos

.subckt dut VSS VD
M1 VD net0 VSS VSS nch l=0.15 w=1 nf=1 m=1
VG net0 VSS DC 1
.ends dut
