* official Analog Canvas netlist; PDK X cards rewritten by convert.py
.model nch nmos

.subckt dut VSS
M1 VSS net1 net0 VSS nch l=0.15 w=1 nf=1 m=1
R1 net0 VSS 1k
Vn net1 VSS DC 1
.ends dut
