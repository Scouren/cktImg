* official Analog Canvas netlist; PDK X cards rewritten by convert.py
.model nch nmos

.subckt dut VSS VG
M1 net0 VG VSS VSS nch l=0.15 w=1 nf=1 m=1
VD net0 VSS DC 1
.ends dut
