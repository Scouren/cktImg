* official Analog Canvas netlist; PDK X cards rewritten by convert.py
.model nch nmos
.model pch pmos

.global VDD

.subckt dut VSS Vb3 Vb2 Vb1 Vout Vin
M1 Vout Vb1 Vin VSS nch l=0.15 w=1 nf=1 m=1
M2 Vout Vb2 net0 VDD pch l=0.15 w=1 nf=1 m=1
M3 net0 Vb3 VDD VDD pch l=0.15 w=1 nf=1 m=1
.ends dut
