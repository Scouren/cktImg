* official Analog Canvas netlist; PDK X cards rewritten by convert.py
.model nch nmos
.model pch pmos

.subckt dut VDD VSS IREF2 IREF1 Vb1 Vout1 Vout2 Vb2 Vin1 Vin2
M1 net3 Vin1 net0 VSS nch l=0.15 w=1 nf=1 m=1
M2 net4 Vin2 net0 VSS nch l=0.15 w=1 nf=1 m=1
M3 Vout1 Vb2 net3 VSS nch l=0.15 w=1 nf=1 m=1
M4 Vout2 Vb2 net4 VSS nch l=0.15 w=1 nf=1 m=1
M5 Vout1 Vb1 net2 VDD pch l=0.15 w=1 nf=1 m=1
M6 Vout2 Vb1 net1 VDD pch l=0.15 w=1 nf=1 m=1
M7 net2 IREF2 VDD VDD pch l=0.15 w=1 nf=1 m=1
M8 net1 IREF2 VDD VDD pch l=0.15 w=1 nf=1 m=1
M9 net0 IREF1 VSS VSS nch l=0.15 w=1 nf=1 m=1
Mb1 IREF1 IREF1 VSS VSS nch l=0.15 w=1 nf=1 m=1
Mb2 IREF2 IREF2 VDD VDD pch l=0.15 w=1 nf=1 m=1
.ends dut
