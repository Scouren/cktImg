* official Analog Canvas netlist; PDK X cards rewritten by convert.py
.model nch nmos
.model pch pmos

.subckt dut VDD VSS
VB1 net1 VSS DC 1
IB net0 VSS DC 1m
ISS net2 VSS DC 1m
M1 X net1 net2 VSS nch l=0.15 w=1 nf=1 m=1
M2 Y net1 net2 VSS nch l=0.15 w=1 nf=1 m=1
M3 X net0 VDD VDD pch l=0.15 w=1 nf=1 m=1
M4 Y net0 VDD VDD pch l=0.15 w=1 nf=1 m=1
M5 net0 net0 VDD VDD pch l=0.15 w=1 nf=1 m=1
.ends dut
