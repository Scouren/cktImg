* official Analog Canvas netlist; PDK X cards rewritten by convert.py
.model nch nmos

.subckt dut VDD VSS Vb Vn_out X
In2 Vn_out X DC 1m
M2 Vn_out Vb X VSS nch l=0.15 w=1 nf=1 m=1
RD VDD Vn_out 1k
.ends dut
