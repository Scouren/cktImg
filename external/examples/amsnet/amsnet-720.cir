* official Analog Canvas netlist; PDK X cards rewritten by convert.py
.model nch nmos
.model pch pmos

.subckt dut VDD VSS Vb3 Vb2 Vb1 Vin1 Vin2 Vout1 Vout2
ISS net0 VSS DC 1m
M1 X Vin1 net0 VSS nch l=0.15 w=1 nf=1 m=1
M2 Y Vin2 net0 VSS nch l=0.15 w=1 nf=1 m=1
M3 Vout1 Vb1 X VSS nch l=0.15 w=1 nf=1 m=1
M4 Vout2 Vb1 Y VSS nch l=0.15 w=1 nf=1 m=1
M5 Vout1 Vb2 N VDD pch l=0.15 w=1 nf=1 m=1
M6 Vout2 Vb2 K VDD pch l=0.15 w=1 nf=1 m=1
M7 N Vb3 VDD VDD pch l=0.15 w=1 nf=1 m=1
M8 K Vb3 VDD VDD pch l=0.15 w=1 nf=1 m=1
.ends dut
