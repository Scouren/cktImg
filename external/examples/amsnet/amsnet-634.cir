* official Analog Canvas netlist; PDK X cards rewritten by convert.py
.model pch pmos

.subckt dut VDD VSS Vin Vb Vout
I1 Vout VSS DC 1m
M1 net0 Vin VDD VDD pch l=0.15 w=1 nf=1 m=1
M2 Vout Vb net0 VDD pch l=0.15 w=1 nf=1 m=1
.ends dut
