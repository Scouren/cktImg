* official Analog Canvas netlist; PDK X cards rewritten by convert.py
.model nch nmos

.subckt dut VDD VSS ID1 ID2
ID VDD net0 DC 1m
M0 net0 net0 VSS VSS nch l=0.15 w=1 nf=1 m=1
M1 ID1 net0 VSS VSS nch l=0.15 w=1 nf=1 m=1
M2 ID2 net0 VSS VSS nch l=0.15 w=1 nf=1 m=1
.ends dut
