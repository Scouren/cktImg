* official Analog Canvas netlist; PDK X cards rewritten by convert.py
.model nch nmos
.model pch pmos

.subckt dut VDD VSS X
M2 net0 X net1 VSS nch l=0.15 w=1 nf=1 m=1
M4 X net0 VDD VDD pch l=0.15 w=1 nf=1 m=1
R1 X VSS 1k
R3 VDD net0 1k
rO2 net0 net1 1k
rO4 VDD X 1k
RS net1 VSS 1k
VDD VDD VSS DC 1
.ends dut
