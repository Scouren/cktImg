* official Analog Canvas netlist; PDK X cards rewritten by convert.py
.model nch nmos

.subckt dut VDD VSS
C1 net0 P 1p
C2 P VSS 1p
M1 net0 VSS net1 VSS nch l=0.15 w=1 nf=1 m=1
M2 net1 P VSS VSS nch l=0.15 w=1 nf=1 m=1
RD VDD net0 1k
RS net1 VSS 1k
VX net0 VSS DC 1
.ends dut
