* official Analog Canvas netlist; PDK X cards rewritten by convert.py
.model nch nmos
.model pch pmos

.subckt dut VDD VSS Vin Vout
CB net2 Vin 1p
IB1 VDD net1 DC 1m
IB2 net0 VSS DC 1m
M1 Vout net2 VSS VSS nch l=0.15 w=1 nf=1 m=1
M2 Vout net0 VDD VDD pch l=0.15 w=1 nf=1 m=1
M5 net0 net0 VDD VDD pch l=0.15 w=1 nf=1 m=1
MB net1 net1 VSS VSS nch l=0.15 w=1 nf=1 m=1
R1 net2 net1 1k
.ends dut
