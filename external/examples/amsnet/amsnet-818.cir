* official Analog Canvas netlist; PDK X cards rewritten by convert.py
.model nch nmos

.subckt dut VDD VSS Vout
CL Vout VSS 1p
M1 Vout Vout VSS VSS nch l=0.15 w=1 nf=1 m=1
RD VDD Vout 1k
.ends dut
