* official Analog Canvas netlist; PDK X cards rewritten by convert.py
.model nch nmos

.subckt dut VDD VSS Vout1 Vout2
I2 VDD Vout2 DC 1m
M1 Vout1 VSS Vout2 VSS nch l=0.15 w=1 nf=1 m=1
RD VDD Vout1 1k
RS Vout2 VSS 1k
.ends dut
