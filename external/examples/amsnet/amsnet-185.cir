* official Analog Canvas netlist; PDK X cards rewritten by convert.py
.model nch nmos

.subckt dut M1_D M2_D M1_S M2_G M1_G M2_B M1_B
M1 M1_D M1_G M1_S M1_B nch l=0.15 w=1 nf=1 m=1
M2 M2_D M2_G M1_D M2_B nch l=0.15 w=1 nf=1 m=1
.ends dut
