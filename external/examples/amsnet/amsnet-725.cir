* official Analog Canvas netlist; PDK X cards rewritten by convert.py
.model pch pmos

.subckt dut VDD VSS Vb Vin Vout
CC Vout X 1p
CE VDD Vin 1p
M1 X Vb Vin VDD pch l=0.15 w=1 nf=1 m=1
M9 Vout Vin VDD VDD pch l=0.15 w=1 nf=1 m=1
R1 Vout VSS 1k
.ends dut
