* official Analog Canvas netlist; PDK X cards rewritten by convert.py

.subckt dut VSS Vout
CGD Vout net0 1p
CGS net0 net1 1p
CL Vout VSS 1p
G1 Vout net1 net0 net1 1m
RD Vout VSS 1k
RG net0 VSS 1k
RS net1 net2 1k
Vin net2 VSS DC 1
.ends dut
