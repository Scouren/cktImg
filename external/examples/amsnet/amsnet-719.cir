* official Analog Canvas netlist; PDK X cards rewritten by convert.py
.model nch nmos
.model pch pmos

.subckt dut VDD VSS Vb2 Vb1 Vin1 Vin2 Vout
CL Vout VSS 1p
ISS net0 VSS DC 1m
M1 X Vin1 net0 VSS nch l=0.15 w=1 nf=1 m=1
M2 Y Vin2 net0 VSS nch l=0.15 w=1 nf=1 m=1
M3 A Vb1 X VSS nch l=0.15 w=1 nf=1 m=1
M4 Vout Vb1 Y VSS nch l=0.15 w=1 nf=1 m=1
M5 A A VDD VDD pch l=0.15 w=1 nf=1 m=1
M6 N A VDD VDD pch l=0.15 w=1 nf=1 m=1
M7 Vout Vb2 N VDD pch l=0.15 w=1 nf=1 m=1
.ends dut
