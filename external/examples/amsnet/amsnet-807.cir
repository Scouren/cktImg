* official Analog Canvas netlist; PDK X cards rewritten by convert.py
.model nch nmos

.subckt dut VDD VSS Vout1 Vout2
M3 VDD VDD Vout1 VSS nch l=0.15 w=1 nf=1 m=1
M4 VDD VDD Vout2 VSS nch l=0.15 w=1 nf=1 m=1
.ends dut
