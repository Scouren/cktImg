* official Analog Canvas netlist; PDK X cards rewritten by convert.py

.subckt dut VSS
R1 net0 net1 1k
R2 net0 VSS 1k
VThev2 net1 VSS DC 1
.ends dut
