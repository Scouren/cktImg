* official Analog Canvas netlist; PDK X cards rewritten by convert.py
.model nch nmos

.subckt dut VDD VSS A N B
IREF VDD N DC 1m
M0 N N A VSS nch l=0.15 w=1 nf=1 m=1
M1 A A VSS VSS nch l=0.15 w=1 nf=1 m=1
M2 B A VSS VSS nch l=0.15 w=1 nf=1 m=1
M3 net0 N B VSS nch l=0.15 w=1 nf=1 m=1
VX net0 VSS DC 1
.ends dut
