* official Analog Canvas netlist; PDK X cards rewritten by convert.py
.model nch nmos
.model pch pmos

.subckt dut VDD VSS Vb3 Vb2 Vb1 Vin1 Vin2 Vout1 Vout2
ISS net4 VSS DC 1m
M1 net3 Vin1 net4 VSS nch l=0.15 w=1 nf=1 m=1
M2 net1 Vin2 net4 VSS nch l=0.15 w=1 nf=1 m=1
M3 Vout1 Vb1 net3 VSS nch l=0.15 w=1 nf=1 m=1
M4 Vout2 Vb1 net1 VSS nch l=0.15 w=1 nf=1 m=1
M5 Vout1 Vb2 net2 VDD pch l=0.15 w=1 nf=1 m=1
M6 Vout2 Vb2 net0 VDD pch l=0.15 w=1 nf=1 m=1
M7 net2 Vb3 VDD VDD pch l=0.15 w=1 nf=1 m=1
M8 net0 Vb3 VDD VDD pch l=0.15 w=1 nf=1 m=1
.ends dut
