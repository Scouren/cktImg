* official Analog Canvas netlist; PDK X cards rewritten by convert.py
.model nch nmos

.subckt dut VDD VSS Vout1 Vout2 Vcont Vin1 Vin2
ISS net1 VSS DC 1m
M2 Vout2 Vcont net2 VSS nch l=0.15 w=1 nf=1 m=1
M4 Vout1 Vcont net0 VSS nch l=0.15 w=1 nf=1 m=1
M5 net2 Vin1 net1 VSS nch l=0.15 w=1 nf=1 m=1
M6 net0 Vin2 net1 VSS nch l=0.15 w=1 nf=1 m=1
RD1 VDD Vout1 1k
RD2 VDD Vout2 1k
.ends dut
