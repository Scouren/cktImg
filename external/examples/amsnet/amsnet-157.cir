* official Analog Canvas netlist; PDK X cards rewritten by convert.py
.model nch nmos
.model pch pmos

.subckt dut VDD VSS Vin Vb1 Vb2 Vout
M1 net0 Vb2 VSS VSS nch l=0.15 w=1 nf=1 m=1
M2 Vout Vb1 net0 VSS nch l=0.15 w=1 nf=1 m=1
M3 Vout Vin VDD VDD pch l=0.15 w=1 nf=1 m=1
.ends dut
