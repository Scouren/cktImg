* official Analog Canvas netlist; PDK X cards rewritten by convert.py
.model nch nmos

.subckt dut VDD VSS Vb Vn1_out
In1 Vn1_out VSS DC 1m
InRD VDD Vn1_out DC 1m
M1 Vn1_out Vb VSS VSS nch l=0.15 w=1 nf=1 m=1
RD VDD Vn1_out 1k
.ends dut
