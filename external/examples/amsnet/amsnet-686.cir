* official Analog Canvas netlist; PDK X cards rewritten by convert.py
.model nch nmos
.model pch pmos

.subckt dut VDD VSS Vin Vout
CL Vout VSS 1p
ISS net1 VSS DC 1m
M1 net0 Vin net1 VSS nch l=0.15 w=1 nf=1 m=1
M2 Vout X net1 VSS nch l=0.15 w=1 nf=1 m=1
M3 net0 net0 VDD VDD pch l=0.15 w=1 nf=1 m=1
M4 Vout net0 VDD VDD pch l=0.15 w=1 nf=1 m=1
R1 Vout X 1k
R2 X VSS 1k
.ends dut
