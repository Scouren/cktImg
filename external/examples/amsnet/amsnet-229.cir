* official Analog Canvas netlist; PDK X cards rewritten by convert.py
.model nch nmos

.subckt dut VDD VSS Vout1+ Vout1- Vin1 Vin2 Vcont1
G1 net0 VSS Vcont1 VSS 1m
M1 Vout1+ Vin1 net0 VSS nch l=0.15 w=1 nf=1 m=1
M2 Vout1- Vin2 net0 VSS nch l=0.15 w=1 nf=1 m=1
RD1 VDD Vout1+ 1k
RD2 VDD Vout1- 1k
.ends dut
