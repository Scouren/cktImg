* official Analog Canvas netlist; PDK X cards rewritten by convert.py
.model nch nmos

.subckt dut VDD VSS Vb Vout X
I1 X VSS DC 1m
M1 Vout Vb X VSS nch l=0.15 w=1 nf=1 m=1
RD VDD Vout 1k
RS X net0 1k
Vin net0 VSS DC 1
.ends dut
