* official Analog Canvas netlist; PDK X cards rewritten by convert.py
.model nch nmos
.model pch pmos

.subckt dut VDD VSS Vin1 Vin2 Vout1 Vout2 P
ISS P VSS DC 1m
M1 Vout1 Vin1 P VSS nch l=0.15 w=1 nf=1 m=1
M2 Vout2 Vin2 P VSS nch l=0.15 w=1 nf=1 m=1
M3 Vout1 Vout2 VDD VDD pch l=0.15 w=1 nf=1 m=1
M4 Vout2 Vout1 VDD VDD pch l=0.15 w=1 nf=1 m=1
M5 Vout1 Vout1 VDD VDD pch l=0.15 w=1 nf=1 m=1
M6 Vout2 Vout2 VDD VDD pch l=0.15 w=1 nf=1 m=1
.ends dut
