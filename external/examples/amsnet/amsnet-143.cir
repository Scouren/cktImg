* official Analog Canvas netlist; PDK X cards rewritten by convert.py
.model nch nmos
.model pch pmos

.subckt dut VDD VSS Vin Vb3 Vb Vout
M1 net0 Vin VDD VDD pch l=0.15 w=1 nf=1 m=1
M2 Vout Vb net0 VSS nch l=0.15 w=1 nf=1 m=1
M3 net0 Vb3 VSS VSS nch l=0.15 w=1 nf=1 m=1
.ends dut
