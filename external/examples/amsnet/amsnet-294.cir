* official Analog Canvas netlist; PDK X cards rewritten by convert.py
.model nch nmos
.model pch pmos

.subckt dut VDD VSS Vb Vin_CM Vout1 Vout2
M1 Vout1 Vin_CM P VSS nch l=0.15 w=1 nf=1 m=1
M2 Vout2 Vin_CM P VSS nch l=0.15 w=1 nf=1 m=1
M3 Vout1 Vb VDD VDD pch l=0.15 w=1 nf=1 m=1
M4 Vout2 Vb VDD VDD pch l=0.15 w=1 nf=1 m=1
RSS P VSS 1k
.ends dut
