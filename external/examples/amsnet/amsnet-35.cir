* official Analog Canvas netlist; PDK X cards rewritten by convert.py
.model nch nmos

.subckt dut VSS +2V Vout
M1 Vout +2V net0 VSS nch l=0.15 w=1 nf=1 m=1
R1 Vout VSS 1k
Vin net0 VSS DC 1
.ends dut
