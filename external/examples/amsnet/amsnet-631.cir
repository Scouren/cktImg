* official Analog Canvas netlist; PDK X cards rewritten by convert.py
.model nch nmos

.subckt dut VDD VSS Vout1 Vout2 Vin1 Vin2
I1 VDD Vb1 DC 1m
ISS P VSS DC 1m
M1 net1 Vin1 P VSS nch l=0.15 w=1 nf=1 m=1
M2 net0 Vin2 P VSS nch l=0.15 w=1 nf=1 m=1
M3 Vout1 Vb1 net1 VSS nch l=0.15 w=1 nf=1 m=1
M4 Vout2 Vb1 net0 VSS nch l=0.15 w=1 nf=1 m=1
Mb1 Vb1 Vb1 P VSS nch l=0.15 w=1 nf=1 m=1
.ends dut
