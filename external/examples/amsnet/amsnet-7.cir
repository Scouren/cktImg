* official Analog Canvas netlist; PDK X cards rewritten by convert.py
.model pch pmos

.global VDD

.subckt dut Vb Iout
M1 Iout Vb VDD VDD pch l=0.15 w=1 nf=1 m=1
.ends dut
