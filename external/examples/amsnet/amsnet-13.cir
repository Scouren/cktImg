* official Analog Canvas netlist; PDK X cards rewritten by convert.py
.model nch nmos

.subckt dut VDD VSS A B E F N
M1 E A C VSS nch l=0.15 w=1 nf=1 m=1
M2 C B N VSS nch l=0.15 w=1 nf=1 m=1
M3 F C N VSS nch l=0.15 w=1 nf=1 m=1
.ends dut
