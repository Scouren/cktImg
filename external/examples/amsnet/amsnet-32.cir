* official Analog Canvas netlist; PDK X cards rewritten by convert.py
.model nch nmos

.subckt dut VSS +2V
I1 net1 VSS DC 1m
M1 +2V net0 net1 VSS nch l=0.15 w=1 nf=1 m=1
R1 net0 net1 1k
VX net0 VSS DC 1
.ends dut
