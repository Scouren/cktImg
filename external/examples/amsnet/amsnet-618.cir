* official Analog Canvas netlist; PDK X cards rewritten by convert.py
.model nch nmos

.subckt dut VDD VSS Vin Vout
M1 net0 Vin net1 VSS nch l=0.15 w=1 nf=1 m=1
M2 Vout net0 VSS VSS nch l=0.15 w=1 nf=1 m=1
RD1 VDD net0 1k
RD2 VDD Vout 1k
RF1 Vout net1 1k
RF2 Vout net0 1k
RS1 net1 VSS 1k
.ends dut
