* official Analog Canvas netlist; PDK X cards rewritten by convert.py
.model nch nmos

.subckt dut VSS Vin1 Vin2 Vout1 Vout2 CK
CH1 VSS Vout1 1p
CH2 Vout2 VSS 1p
M1 Vin1 CK Vout1 VSS nch l=0.15 w=1 nf=1 m=1
M2 Vin2 CK Vout2 VSS nch l=0.15 w=1 nf=1 m=1
.ends dut
