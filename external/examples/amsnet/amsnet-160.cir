* official Analog Canvas netlist; PDK X cards rewritten by convert.py
.model pch pmos

.subckt dut VDD VSS
M2 net1 net0 VDD VDD pch l=0.15 w=1 nf=1 m=1
R1 VDD net0 1k
R2 net1 net0 1k
VX net1 VSS DC 1
.ends dut
