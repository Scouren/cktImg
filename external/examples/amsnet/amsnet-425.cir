* official Analog Canvas netlist; PDK X cards rewritten by convert.py
.model nch nmos

.subckt dut VDD VSS VX
C1 net0 VSS 1p
I1 net0 VSS DC 1m
M1 VX net0 VSS VSS nch l=0.15 w=1 nf=1 m=1
M2 VDD VX net0 VSS nch l=0.15 w=1 nf=1 m=1
RD VDD VX 1k
.ends dut
