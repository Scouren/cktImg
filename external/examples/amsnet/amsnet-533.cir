* official Analog Canvas netlist; PDK X cards rewritten by convert.py
.model nch nmos

.subckt dut VDD VSS Vin Vout
CL Vout VSS 1p
M1 net0 Vin VSS VSS nch l=0.15 w=1 nf=1 m=1
RD VDD net0 1k
RP Vout net0 1k
.ends dut
