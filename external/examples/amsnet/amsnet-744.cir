* official Analog Canvas netlist; PDK X cards rewritten by convert.py
.model nch nmos
.model pch pmos

.subckt dut VDD VSS Vout1 Vout2 Vb4 Vb1 Vb2 Vin1 Vin2 Vb3 Vb5
I1 net1 VSS DC 1m
M1 Q Vin1 net1 VSS nch l=0.15 w=1 nf=1 m=1
M10 net2 Vb4 VSS VSS nch l=0.15 w=1 nf=1 m=1
M2 P Vin2 net1 VSS nch l=0.15 w=1 nf=1 m=1
M3 Vout1 Vb5 net0 VSS nch l=0.15 w=1 nf=1 m=1
M4 Vout2 Vb5 net2 VSS nch l=0.15 w=1 nf=1 m=1
M5 Vout1 Vb3 P VDD pch l=0.15 w=1 nf=1 m=1
M6 Vout2 Vb3 Q VDD pch l=0.15 w=1 nf=1 m=1
M7 P Vb1 VDD VDD pch l=0.15 w=1 nf=1 m=1
M8 Q Vb2 VDD VDD pch l=0.15 w=1 nf=1 m=1
M9 net0 Vb4 VSS VSS nch l=0.15 w=1 nf=1 m=1
.ends dut
