* official Analog Canvas netlist; PDK X cards rewritten by convert.py
.model nch nmos
.model pch pmos

.subckt dut VDD VSS Vin1 Vin2 Vb Vout X
ISS net4 VSS DC 1m
M1 net2 Vin1 net4 VSS nch l=0.15 w=1 nf=1 m=1
M2 net3 Vin2 net4 VSS nch l=0.15 w=1 nf=1 m=1
M3 X Vb net2 VSS nch l=0.15 w=1 nf=1 m=1
M4 Vout Vb net3 VSS nch l=0.15 w=1 nf=1 m=1
M5 X X net0 VDD pch l=0.15 w=1 nf=1 m=1
M6 Vout X net1 VDD pch l=0.15 w=1 nf=1 m=1
M7 net0 net0 VDD VDD pch l=0.15 w=1 nf=1 m=1
M8 net1 net0 VDD VDD pch l=0.15 w=1 nf=1 m=1
.ends dut
