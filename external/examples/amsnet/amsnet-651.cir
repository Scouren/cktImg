* official Analog Canvas netlist; PDK X cards rewritten by convert.py
.model nch nmos

.global VDD

.subckt dut VSS Vin Vout P G
I1 VDD G DC 1m
I2 VDD Vout DC 1m
M1 P Vin VSS VSS nch l=0.15 w=1 nf=1 m=1
M2 Vout G P VSS nch l=0.15 w=1 nf=1 m=1
M3 G P VSS VSS nch l=0.15 w=1 nf=1 m=1
.ends dut
