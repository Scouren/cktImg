* official Analog Canvas netlist; PDK X cards rewritten by convert.py
.model nch nmos

.subckt dut VSS VG D
M1 D VG net0 VSS nch l=0.15 w=1 nf=1 m=1
V1 net0 VSS DC 1V
.ends dut
