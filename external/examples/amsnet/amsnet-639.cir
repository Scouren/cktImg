* official Analog Canvas netlist; PDK X cards rewritten by convert.py
.model nch nmos
.model pch pmos

.subckt dut VDD VSS Vb3 Vb2 Vb1 Vin Vout
M1 X Vin VSS VDD pch l=0.15 w=1 nf=1 m=1
M3 Vout Vb1 X VSS nch l=0.15 w=1 nf=1 m=1
M7 Vout Vb2 net0 VDD pch l=0.15 w=1 nf=1 m=1
M9 net0 Vb3 VDD VDD pch l=0.15 w=1 nf=1 m=1
R1 X VSS 1k
.ends dut
