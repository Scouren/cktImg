* official Analog Canvas netlist; PDK X cards rewritten by convert.py
.model nch nmos
.model pch pmos

.subckt dut VDD VSS Vb Vin Vout
C1 net1 VSS 1p
C2 net0 net2 1p
M1 net2 net1 VSS VSS nch l=0.15 w=1 nf=1 m=1
M2 Vout Vin net2 VSS nch l=0.15 w=1 nf=1 m=1
M3 Vout net0 VDD VDD pch l=0.15 w=1 nf=1 m=1
R1 net2 net1 1k
R2 Vb net0 1k
.ends dut
