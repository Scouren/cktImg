* official Analog Canvas netlist; PDK X cards rewritten by convert.py
.model nch nmos

.subckt dut VDD VSS Vb
I6 VDD net1 DC 1m
M5 net0 net0 VSS VSS nch l=0.15 w=1 nf=1 m=1
M6 Vb net1 net0 VSS nch l=0.15 w=1 nf=1 m=1
R6 net1 Vb 1k
.ends dut
