* official Analog Canvas netlist; PDK X cards rewritten by convert.py
.model nch nmos
.model pch pmos

.subckt dut VDD VSS Vout1 Vout2 Vin1 Vin2
ISS net0 VSS DC 1m
M1 Vout1 Vin1 net0 VSS nch l=0.15 w=1 nf=1 m=1
M2 Vout2 Vin2 net0 VSS nch l=0.15 w=1 nf=1 m=1
M3 Vout1 N VDD VDD pch l=0.15 w=1 nf=1 m=1
M4 Vout2 N VDD VDD pch l=0.15 w=1 nf=1 m=1
R1 N Vout1 1k
R2 Vout2 N 1k
.ends dut
