* official Analog Canvas netlist; PDK X cards rewritten by convert.py
.model nch nmos
.model pch pmos

.subckt dut VDD VSS Vb Vin Vout
C1 net0 VSS 1p
M1 Vout net1 VSS VSS nch l=0.15 w=1 nf=1 m=1
M2 Vout Vb VDD VDD pch l=0.15 w=1 nf=1 m=1
R1 net1 Vin 1k
R2 net0 net1 1k
R3 Vout net0 1k
.ends dut
