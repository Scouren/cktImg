* official Analog Canvas netlist; PDK X cards rewritten by convert.py
.model nch nmos

.subckt dut VSS Vb Vout
M2 Vout Vb net0 VSS nch l=0.15 w=1 nf=1 m=1
R1 net0 VSS 1k
.ends dut
