* official Analog Canvas netlist; PDK X cards rewritten by convert.py
.model nch nmos

.subckt dut VSS +1.9V +1.5V
M1 +1.5V +1.9V net0 net1 nch l=0.15 w=1 nf=1 m=1
V1 net0 VSS DC 1V
VX net1 VSS DC 1
.ends dut
