* official Analog Canvas netlist; PDK X cards rewritten by convert.py
.model nch nmos

.subckt dut VSS dV1 dV2
M1 dV1 VSS net0 VSS nch l=0.15 w=1 nf=1 m=1
rO dV2 net0 1k
RS net0 VSS 1k
.ends dut
