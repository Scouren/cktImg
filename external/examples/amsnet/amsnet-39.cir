* official Analog Canvas netlist; PDK X cards rewritten by convert.py
.model nch nmos

.subckt dut VDD VSS +2V Vout
M1 Vout +2V net0 net1 nch l=0.15 w=1 nf=1 m=1
R1 VDD Vout 1k
V1 net0 VSS DC 1V
Vin net1 VSS DC 1
.ends dut
