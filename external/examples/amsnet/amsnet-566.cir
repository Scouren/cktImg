* official Analog Canvas netlist; PDK X cards rewritten by convert.py
.model nch nmos

.subckt dut VDD VSS Vin Vout
M1 net0 Vin VF VSS nch l=0.15 w=1 nf=1 m=1
M2 Vout net0 VSS VSS nch l=0.15 w=1 nf=1 m=1
R1 Vout VF 1k
R2 VF VSS 1k
RD1 VDD net0 1k
RD2 VDD Vout 1k
.ends dut
