* official Analog Canvas netlist; PDK X cards rewritten by convert.py
.model nch nmos

.subckt dut VDD VSS Vb1 Vin1 Vin2 Vb Vout1 Vout2
M1 net0 Vin1 net1 VSS nch l=0.15 w=1 nf=1 m=1
M2 net2 Vin2 net1 VSS nch l=0.15 w=1 nf=1 m=1
M3 Vout1 Vb1 net0 VSS nch l=0.15 w=1 nf=1 m=1
M4 Vout2 Vb1 net2 VSS nch l=0.15 w=1 nf=1 m=1
M5 net1 Vb VSS VSS nch l=0.15 w=1 nf=1 m=1
RD1 VDD Vout1 1k
RD2 VDD Vout2 1k
RP Vout2 net0 1k
.ends dut
