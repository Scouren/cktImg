* official Analog Canvas netlist; PDK X cards rewritten by convert.py
.model nch nmos

.subckt dut VDD VSS Vout
I1 net0 Vout DC 1m
M2 net1 net0 VSS VSS nch l=0.15 w=1 nf=1 m=1
R1 net1 Vout 1k
R2 Vout VSS 1k
RD1 VDD net0 1k
RD2 VDD net1 1k
.ends dut
