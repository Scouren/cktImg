* official Analog Canvas netlist; PDK X cards rewritten by convert.py
.model nch nmos
.model pch pmos

.subckt dut VDD VSS Vin Vb1 Vb2 Vout
M1 Vout Vb2 VSS VSS nch l=0.15 w=1 nf=1 m=1
M2 net0 Vb1 Vout VSS nch l=0.15 w=1 nf=1 m=1
M3 net0 Vin VDD VDD pch l=0.15 w=1 nf=1 m=1
.ends dut
