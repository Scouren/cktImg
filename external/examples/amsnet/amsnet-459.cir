* official Analog Canvas netlist; PDK X cards rewritten by convert.py
.model nch nmos
.model pch pmos

.subckt dut VDD VSS Vb Vin Vn_out
In1 Vn_out VSS DC 1m
In2 VDD Vn_out DC 1m
M1 Vn_out Vin VSS VSS nch l=0.15 w=1 nf=1 m=1
M2 Vn_out Vb VDD VDD pch l=0.15 w=1 nf=1 m=1
R1 Vn_out VSS 1k
.ends dut
