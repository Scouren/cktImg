* official Analog Canvas netlist; PDK X cards rewritten by convert.py
.model nch nmos

.subckt dut VDD VSS G S D
M1 D net0 S VSS nch l=0.15 w=1 nf=1 m=1
RG G net0 1k
.ends dut
