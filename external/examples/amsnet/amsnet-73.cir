* official Analog Canvas netlist; PDK X cards rewritten by convert.py
.model nch nmos

.subckt dut VDD VSS
M1 VDD VDD net0 VSS nch l=0.15 w=1 nf=1 m=1
Vx net0 VSS DC 1
.ends dut
