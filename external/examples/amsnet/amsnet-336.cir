* official Analog Canvas netlist; PDK X cards rewritten by convert.py
.model nch nmos

.subckt dut VDD VSS Vb X A B
IREF VDD X DC 1m
M1 B X VSS VSS nch l=0.15 w=1 nf=1 m=1
M2 A X VSS VSS nch l=0.15 w=1 nf=1 m=1
M3 VDD Vb B VSS nch l=0.15 w=1 nf=1 m=1
M4 X Vb A VSS nch l=0.15 w=1 nf=1 m=1
.ends dut
