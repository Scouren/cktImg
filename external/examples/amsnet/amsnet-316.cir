* official Analog Canvas netlist; PDK X cards rewritten by convert.py
.model nch nmos

.subckt dut VDD VSS Vin Vout
Cin net0 Vin 1p
IB VDD net1 DC 1m
M1 VDD net0 Vout VSS nch l=0.15 w=1 nf=1 m=1
M2 Vout net1 VSS VSS nch l=0.15 w=1 nf=1 m=1
MB net1 net1 VSS VSS nch l=0.15 w=1 nf=1 m=1
Rin VDD net0 1k
.ends dut
