* official Analog Canvas netlist; PDK X cards rewritten by convert.py
.model nch nmos

.subckt dut VDD VSS P1 P2
M1 P1 P1 P2 VSS nch l=0.15 w=1 nf=1 m=1
.ends dut
