* official Analog Canvas netlist; PDK X cards rewritten by convert.py
.model nch nmos

.subckt dut VDD VSS Vin1 Vin2
I1 VDD net1 DC 1m
I2 VDD net0 DC 1m
I3 net2 VSS DC 1m
M1 net1 Vin1 net2 VSS nch l=0.15 w=1 nf=1 m=1
M2 net0 Vin2 net2 VSS nch l=0.15 w=1 nf=1 m=1
.ends dut
