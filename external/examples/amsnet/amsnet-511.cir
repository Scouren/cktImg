* official Analog Canvas netlist; PDK X cards rewritten by convert.py
.model nch nmos
.model pch pmos

.subckt dut VDD VSS Vin Vb Vout
M1 net0 Vin VSS VSS nch l=0.15 w=1 nf=1 m=1
M2 Vout Vb net0 VDD pch l=0.15 w=1 nf=1 m=1
RD Vout VSS 1k
RS VDD net0 1k
.ends dut
