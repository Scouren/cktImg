* official Analog Canvas netlist; PDK X cards rewritten by convert.py
.model nch nmos

.subckt dut VDD VSS Vb VX
C1 VX VSS 1p
M1 VDD Vb VX VSS nch l=0.15 w=1 nf=1 m=1
.ends dut
