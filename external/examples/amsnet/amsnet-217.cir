* official Analog Canvas netlist; PDK X cards rewritten by convert.py
.model nch nmos

.subckt dut VDD VSS Vout1 Vout2 Vin_CM P
M1 Vout1 Vin_CM P VSS nch l=0.15 w=1 nf=1 m=1
M2 Vout2 Vin_CM P VSS nch l=0.15 w=1 nf=1 m=1
RD1 VDD Vout1 1k
RD2 VDD Vout2 1k
RSS P VSS 1k
.ends dut
