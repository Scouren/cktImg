* official Analog Canvas netlist; PDK X cards rewritten by convert.py
.model nch nmos

.subckt dut VDD VSS Vout+ Vout- Vin+ Vin- Vcont1 Vcont2
ISS net2 VSS DC 1m
M1 Vout+ Vin+ net1 VSS nch l=0.15 w=1 nf=1 m=1
M2 Vout- Vin- net1 VSS nch l=0.15 w=1 nf=1 m=1
M3 Vout- Vin+ net0 VSS nch l=0.15 w=1 nf=1 m=1
M4 Vout+ Vin- net0 VSS nch l=0.15 w=1 nf=1 m=1
M5 net1 Vcont1 net2 VSS nch l=0.15 w=1 nf=1 m=1
M6 net0 Vcont2 net2 VSS nch l=0.15 w=1 nf=1 m=1
RD1 VDD Vout+ 1k
RD2 VDD Vout- 1k
.ends dut
