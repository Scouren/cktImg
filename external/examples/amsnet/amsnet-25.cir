* official Analog Canvas netlist; PDK X cards rewritten by convert.py
.model nch nmos

.subckt dut VSS +1.9V
M1 net0 +1.9V net1 VSS nch l=0.15 w=1 nf=1 m=1
V1 net1 VSS DC 1V
VX net0 VSS DC 1
.ends dut
