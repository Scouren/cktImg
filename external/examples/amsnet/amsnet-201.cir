* official Analog Canvas netlist; PDK X cards rewritten by convert.py
.model nch nmos

.subckt dut VDD VSS Vin1 Vin2 Vout2 Vout1
ISS net0 VSS DC 1m
M1 Vout2 Vin1 net0 VSS nch l=0.15 w=1 nf=1 m=1
M2 Vout1 Vin2 net0 VSS nch l=0.15 w=1 nf=1 m=1
RD1 VDD Vout2 1k
RD2 VDD Vout1 1k
.ends dut
