* official Analog Canvas netlist; PDK X cards rewritten by convert.py
.model nch nmos

.subckt dut VDD VSS Vout
I1 Vout VSS DC 1m
M1 VDD VDD Vout net0 nch l=0.15 w=1 nf=1 m=1
Vin net0 VSS DC 1
.ends dut
