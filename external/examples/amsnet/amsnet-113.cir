* official Analog Canvas netlist; PDK X cards rewritten by convert.py
.model nch nmos

.subckt dut VDD VSS Vb Vout
C1 net0 net1 1p
I1 net0 VSS DC 1m
M1 Vout Vb net0 VSS nch l=0.15 w=1 nf=1 m=1
RD VDD Vout 1k
Vin net1 VSS DC 1
.ends dut
