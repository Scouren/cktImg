* official Analog Canvas netlist; PDK X cards rewritten by convert.py
.model nch nmos

.subckt dut VSS +3V Vin Vout
CH Vout VSS 1pF
M1 Vin +3V Vout VSS nch l=0.15 w=1 nf=1 m=1
.ends dut
