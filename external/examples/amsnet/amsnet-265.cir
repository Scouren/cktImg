* official Analog Canvas netlist; PDK X cards rewritten by convert.py
.model nch nmos

.subckt dut VDD VSS X
I1 VDD net1 DC 1m
M0 X Vb A VSS nch l=0.15 w=1 nf=1 m=1
M1 A X VSS VSS nch l=0.15 w=1 nf=1 m=1
M5 net0 net0 VSS VSS nch l=0.15 w=1 nf=1 m=1
M6 Vb net1 net0 VSS nch l=0.15 w=1 nf=1 m=1
Rb net1 Vb 1k
.ends dut
