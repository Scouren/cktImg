* official Analog Canvas netlist; PDK X cards rewritten by convert.py
.model nch nmos

.subckt dut VDD VSS Vout
CDB Vout VSS 1p
CGD Vout net0 1p
M1 Vout net0 VSS VSS nch l=0.15 w=1 nf=1 m=1
RD VDD Vout 1k
VX net0 VSS DC 1
.ends dut
