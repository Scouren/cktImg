* official Analog Canvas netlist; PDK X cards rewritten by convert.py
.model nch nmos
.model pch pmos

.subckt dut VDD VSS Vb1 Vin Vb2 Vout
I1 net0 VSS DC 1m
M1 net1 Vin net0 VSS nch l=0.15 w=1 nf=1 m=1
M2 net1 Vb1 VDD VDD pch l=0.15 w=1 nf=1 m=1
M3 Vout net1 VDD VDD pch l=0.15 w=1 nf=1 m=1
M4 VDD net2 net0 VSS nch l=0.15 w=1 nf=1 m=1
RD2 Vout VSS 1k
RF Vout net2 1k
RS1 net2 Vb2 1k
.ends dut
