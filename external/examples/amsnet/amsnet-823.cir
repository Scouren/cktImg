* official Analog Canvas netlist; PDK X cards rewritten by convert.py
.model nch nmos

.subckt dut VDD VSS V1 V2 P Vb
M1 net1 V1 P VSS nch l=0.15 w=1 nf=1 m=1
M2 net0 V2 P VSS nch l=0.15 w=1 nf=1 m=1
M3 P Vb VSS VSS nch l=0.15 w=1 nf=1 m=1
RP1 VDD net1 1k
RP2 VDD net0 1k
.ends dut
