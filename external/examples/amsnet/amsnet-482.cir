* official Analog Canvas netlist; PDK X cards rewritten by convert.py
.model nch nmos

.subckt dut VDD VSS Vn_out1 Vn_out2
In1 Vn_out1 net1 DC 1m
M1 Vn_out1 net0 net1 VSS nch l=0.15 w=1 nf=1 m=1
M2 Vn_out2 net0 net1 VSS nch l=0.15 w=1 nf=1 m=1
RD1 VDD Vn_out1 1k
RD2 VDD Vn_out2 1k
.ends dut
