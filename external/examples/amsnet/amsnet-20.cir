* official Analog Canvas netlist; PDK X cards rewritten by convert.py
.model nch nmos

.subckt dut VDD VSS G S D
M1 D net1 S VSS nch l=0.15 w=1 nf=1 m=1
M2 D net0 S VSS nch l=0.15 w=1 nf=1 m=1
R1 G net1 {RG/2}
R2 G net0 {RG/2}
.ends dut
