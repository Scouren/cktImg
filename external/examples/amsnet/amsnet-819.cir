* official Analog Canvas netlist; PDK X cards rewritten by convert.py
.model nch nmos

.subckt dut VDD VSS Vout E
CL1 E VSS 1p
CL2 Vout VSS 1p
M1 E Vout VSS VSS nch l=0.15 w=1 nf=1 m=1
M2 Vout E VSS VSS nch l=0.15 w=1 nf=1 m=1
RD1 VDD E 1k
RD2 VDD Vout 1k
.ends dut
