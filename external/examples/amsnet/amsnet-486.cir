* official Analog Canvas netlist; PDK X cards rewritten by convert.py
.model nch nmos
.model pch pmos

.subckt dut VDD VSS Vb A B
I1 net0 VSS DC 1m
M1 A A net0 VSS nch l=0.15 w=1 nf=1 m=1
M2 B B net0 VSS nch l=0.15 w=1 nf=1 m=1
M3 A Vb VDD VDD pch l=0.15 w=1 nf=1 m=1
M4 B Vb VDD VDD pch l=0.15 w=1 nf=1 m=1
.ends dut
