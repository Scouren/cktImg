* official Analog Canvas netlist; PDK X cards rewritten by convert.py
.model nch nmos

.subckt dut VDD VSS VinCM Vout
M1 Vout VinCM net0 VSS nch l=0.15 w=1 nf=1 m=1
R1 VDD Vout 1k
R2 Vout net0 1k
RSS net0 VSS 1k
.ends dut
