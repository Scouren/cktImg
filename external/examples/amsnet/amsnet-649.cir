* official Analog Canvas netlist; PDK X cards rewritten by convert.py

.subckt dut VSS
R1 net0 net1 1k
RS net1 VSS 1k
VX net0 VSS DC 1
.ends dut
