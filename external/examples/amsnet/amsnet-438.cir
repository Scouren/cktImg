* official Analog Canvas netlist; PDK X cards rewritten by convert.py
.model nch nmos

.subckt dut VDD VSS Vn_out
In_RD VDD Vn_out DC 1m
In1 Vn_out VSS DC 1m
M1 Vn_out VSS VSS VSS nch l=0.15 w=1 nf=1 m=1
RD VDD Vn_out 1k
.ends dut
