* official Analog Canvas netlist; PDK X cards rewritten by convert.py
.model nch nmos

.subckt dut VSS VG
M1 VSS VG VSS VSS nch l=0.15 w=1 nf=1 m=1
.ends dut
