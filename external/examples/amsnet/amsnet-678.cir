* official Analog Canvas netlist; PDK X cards rewritten by convert.py
.model nch nmos

.subckt dut VSS Vin_CM Vout_CM
G1 P VSS Vout_CM VSS 1m
M1 Vout_CM Vin_CM P VSS nch l=0.15 w=1 nf=1 m=1
R1 VSS Vout_CM 1k
Rtail P VSS 1k
.ends dut
