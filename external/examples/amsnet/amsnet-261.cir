* official Analog Canvas netlist; PDK X cards rewritten by convert.py
.model nch nmos

.subckt dut VDD VSS Vb
I6 VDD Vb DC 1m
M5 net0 net0 VSS VSS nch l=0.15 w=1 nf=1 m=1
R6 Vb net0 1k
.ends dut
