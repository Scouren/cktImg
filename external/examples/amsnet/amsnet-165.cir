* official Analog Canvas netlist; PDK X cards rewritten by convert.py
.model nch nmos
.model pch pmos

.global VDD

.subckt dut VSS
M1 net1 net0 VSS VSS nch l=0.15 w=1 nf=1 m=1
M2 net1 net0 VDD VDD pch l=0.15 w=1 nf=1 m=1
R1 net1 net0 1k
VX net1 VSS DC 1
.ends dut
