* official Analog Canvas netlist; PDK X cards rewritten by convert.py
.model nch nmos

.subckt dut VDD VSS Vout
M1 X net1 VSS VSS nch l=0.15 w=1 nf=1 m=1
M2 VDD X Vout VSS nch l=0.15 w=1 nf=1 m=1
R1 net1 net0 1k
R2 Vout net1 1k
RD VDD X 1k
RS Vout VSS 1k
Vin net0 VSS DC 1
.ends dut
