* official Analog Canvas netlist; PDK X cards rewritten by convert.py
.model nch nmos
.model pch pmos

.subckt dut VDD VSS Vout Vin1 Vin2 Vb
M1 F Vin1 P VSS nch l=0.15 w=1 nf=1 m=1
M2 Vout Vin2 P VSS nch l=0.15 w=1 nf=1 m=1
M3 F F VDD VDD pch l=0.15 w=1 nf=1 m=1
M4 Vout F VDD VDD pch l=0.15 w=1 nf=1 m=1
M5 P Vb VSS VSS nch l=0.15 w=1 nf=1 m=1
.ends dut
