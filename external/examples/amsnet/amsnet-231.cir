* official Analog Canvas netlist; PDK X cards rewritten by convert.py
.model nch nmos

.subckt dut VDD VSS Vout+ Vout- Vin1 Vin2 Vcont1 Vcont2
G1 net1 VSS Vcont1 VSS 1m
G2 net0 VSS Vcont2 VSS 1m
M1 Vout+ Vin1 net1 VSS nch l=0.15 w=1 nf=1 m=1
M2 Vout- Vin2 net1 VSS nch l=0.15 w=1 nf=1 m=1
M3 Vout- Vin1 net0 VSS nch l=0.15 w=1 nf=1 m=1
M4 Vout+ Vin2 net0 VSS nch l=0.15 w=1 nf=1 m=1
RD1 VDD Vout+ 1k
RD2 VDD Vout- 1k
.ends dut
