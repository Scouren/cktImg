* official Analog Canvas netlist; PDK X cards rewritten by convert.py
.model nch nmos
.model pch pmos

.subckt dut VDD VSS Vb Vin Vout
M1 net0 Vin net1 VSS nch l=0.15 w=1 nf=1 m=1
M2 Vout net0 VSS VSS nch l=0.15 w=1 nf=1 m=1
M3 net0 Vb VDD VDD pch l=0.15 w=1 nf=1 m=1
M4 Vout Vb VDD VDD pch l=0.15 w=1 nf=1 m=1
R1 net1 VSS 1k
R2 Vout net1 1k
.ends dut
