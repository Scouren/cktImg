* official Analog Canvas netlist; PDK X cards rewritten by convert.py
.model nch nmos

.subckt dut VDD VSS Vb2 Vout Vin
CGD1 net0 Vin 1p
CL Vout VSS 1p
I1 VDD Vout DC 1m
M1 net0 Vin VSS VSS nch l=0.15 w=1 nf=1 m=1
M2 Vout Vb2 net0 VSS nch l=0.15 w=1 nf=1 m=1
.ends dut
