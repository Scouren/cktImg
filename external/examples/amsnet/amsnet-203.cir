* official Analog Canvas netlist; PDK X cards rewritten by convert.py
.model nch nmos

.subckt dut VDD VSS P Vout1 Vout2
ISS P VSS DC 1m
M1 Vout1 net0 P VSS nch l=0.15 w=1 nf=1 m=1
M2 Vout2 net1 P VSS nch l=0.15 w=1 nf=1 m=1
RD1 VDD Vout1 1k
RD2 VDD Vout2 1k
V1 net0 VSS DC 1
V2 net1 VSS DC 1
.ends dut
