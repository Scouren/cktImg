* official Analog Canvas netlist; PDK X cards rewritten by convert.py
.model nch nmos

.subckt dut VDD VSS Vb Vout VX
C1 VSS P 1p
C2 P VSS 1p
M1 Vout Vb VX VSS nch l=0.15 w=1 nf=1 m=1
M2 VX P VSS VSS nch l=0.15 w=1 nf=1 m=1
RD VDD Vout 1k
.ends dut
