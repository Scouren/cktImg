* official Analog Canvas netlist; PDK X cards rewritten by convert.py
.model nch nmos

.subckt dut VDD VSS Vb Y X
I1 VDD Y DC 1m
M1 Y Vb X VSS nch l=0.15 w=1 nf=1 m=1
R1 VSS Y {rO/(1-1/Av)}
R2 VSS X {rO/(1-Av)}
.ends dut
