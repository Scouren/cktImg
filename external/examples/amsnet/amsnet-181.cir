* official Analog Canvas netlist; PDK X cards rewritten by convert.py
.model nch nmos

.subckt dut VDD VSS Vb1 Vb2
C1 VDD Y 1p
M1 VDD Vb1 X VSS nch l=0.15 w=1 nf=1 m=1
M2 X Vb2 Y VSS nch l=0.15 w=1 nf=1 m=1
.ends dut
