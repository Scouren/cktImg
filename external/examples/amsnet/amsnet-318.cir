* official Analog Canvas netlist; PDK X cards rewritten by convert.py
.model nch nmos

.subckt dut VDD VSS Vin Vout Vb
CC net0 X 1p
M1 VDD net0 Vout VSS nch l=0.15 w=1 nf=1 m=1
M2 Vout Vb VSS VSS nch l=0.15 w=1 nf=1 m=1
M3 X Vin VSS VSS nch l=0.15 w=1 nf=1 m=1
RB VDD net0 1k
RD VDD X 1k
.ends dut
