* official Analog Canvas netlist; PDK X cards rewritten by convert.py
.model nch nmos

.subckt dut VDD VSS Vout2 Vout1 Vcont Vin1 Vin2
ISS net2 VSS DC 1m
M1 Vout1 Vcont net1 VSS nch l=0.15 w=1 nf=1 m=1
M3 Vout2 Vcont net0 VSS nch l=0.15 w=1 nf=1 m=1
M5 net1 Vin1 net2 VSS nch l=0.15 w=1 nf=1 m=1
M6 net0 Vin2 net2 VSS nch l=0.15 w=1 nf=1 m=1
RD1 VDD Vout1 1k
RD2 VDD Vout2 1k
.ends dut
