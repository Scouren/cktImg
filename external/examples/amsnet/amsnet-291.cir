* official Analog Canvas netlist; PDK X cards rewritten by convert.py
.model pch pmos

.subckt dut VDD VSS Vout
I1 F VSS DC 1m
I2 Vout VSS DC 1m
M3 F F VDD VDD pch l=0.15 w=1 nf=1 m=1
M4 Vout F VDD VDD pch l=0.15 w=1 nf=1 m=1
rO3 VDD F 1k
rO4 VDD Vout 1k
.ends dut
