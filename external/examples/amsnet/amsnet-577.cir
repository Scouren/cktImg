* official Analog Canvas netlist; PDK X cards rewritten by convert.py
.model nch nmos
.model pch pmos

.subckt dut VDD VSS Vin RS2_1
M1 X Vin net0 VSS nch l=0.15 w=1 nf=1 m=1
M2 Y X VDD VDD pch l=0.15 w=1 nf=1 m=1
R1 VDD X 1k
RD2 Y VSS 1k
RF1 VSS net0 1k
RF2 Y RS2_1 1k
RS1 net0 VSS 1k
RS2 RS2_1 VSS 1k
.ends dut
