* official Analog Canvas netlist; PDK X cards rewritten by convert.py
.model nch nmos
.model pch pmos

.subckt dut VDD VSS Vin Vout
CC X Vout 1p
I1 Vout VSS DC 1m
ISS net0 VSS DC 1m
M1 X Vin net0 VSS nch l=0.15 w=1 nf=1 m=1
M5 Vout X VDD VDD pch l=0.15 w=1 nf=1 m=1
.ends dut
