* official Analog Canvas netlist; PDK X cards rewritten by convert.py
.model nch nmos

.subckt dut VDD VSS Vn2_out
Cin net0 VSS 1p
In_in VSS net0 DC 1m
M1 Vn2_out net0 VSS VSS nch l=0.15 w=1 nf=1 m=1
RD VDD Vn2_out 1k
.ends dut
