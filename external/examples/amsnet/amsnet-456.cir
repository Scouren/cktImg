* official Analog Canvas netlist; PDK X cards rewritten by convert.py
.model nch nmos

.subckt dut VSS
M1 net1 net2 net0 VSS nch l=0.15 w=1 nf=1 m=1
R1 VSS net1 1k
R2 net0 VSS 1k
Vn net2 VSS DC 1
.ends dut
