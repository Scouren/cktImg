* official Analog Canvas netlist; PDK X cards rewritten by convert.py
.model nch nmos

.subckt dut VDD VSS Vb Y X
C1 net1 VSS 1p
IREF VDD net0 DC 1m
M1 X net0 net1 VSS nch l=0.15 w=1 nf=1 m=1
M2 net0 net0 VSS VSS nch l=0.15 w=1 nf=1 m=1
M3 Y Vb X VSS nch l=0.15 w=1 nf=1 m=1
R1 VDD Y 1k
.ends dut
