* official Analog Canvas netlist; PDK X cards rewritten by convert.py
.model nch nmos

.global VDD

.subckt dut VSS Vb Vin Vout
M1 Vout Vb Vin VSS nch l=0.15 w=1 nf=1 m=1
R1 Vout Vin 1k
R2 VDD Vout 1k
.ends dut
