* official Analog Canvas netlist; PDK X cards rewritten by convert.py
.model nch nmos
.model pch pmos

.subckt dut VDD VSS Vb1 Vb2
M10 Y Vb1 VDD VDD pch l=0.15 w=1 nf=1 m=1
M11 VDD VDD X VSS nch l=0.15 w=1 nf=1 m=1
M12 VDD VDD Y VSS nch l=0.15 w=1 nf=1 m=1
M3 NC0002 Vb2 X VDD pch l=0.15 w=1 nf=1 m=1
M4 NC0001 Vb2 Y VDD pch l=0.15 w=1 nf=1 m=1
M9 X Vb1 VDD VDD pch l=0.15 w=1 nf=1 m=1
.ends dut
