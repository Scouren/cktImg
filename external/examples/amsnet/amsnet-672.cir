* official Analog Canvas netlist; PDK X cards rewritten by convert.py
.model nch nmos
.model pch pmos

.subckt dut VDD VSS VREF Vin1 Vin2 Vout1 Vout2 Vb1 Vb2 Vb3
I1 VDD Vb DC 1m
M1 net5 Vin1 net2 VSS nch l=0.15 w=1 nf=1 m=1
M10 net0 Vb3 VSS VSS nch l=0.15 w=1 nf=1 m=1
M11 net3 Vb3 VSS VSS nch l=0.15 w=1 nf=1 m=1
M12 Vout1 Vb2 net0 VSS nch l=0.15 w=1 nf=1 m=1
M13 Vout2 Vb2 net3 VSS nch l=0.15 w=1 nf=1 m=1
M15 net1 Vb net4 VSS nch l=0.15 w=1 nf=1 m=1
M16 net4 VREF VSS VSS nch l=0.15 w=1 nf=1 m=1
M17 Vb Vb VSS VSS nch l=0.15 w=1 nf=1 m=1
M18 net1 net1 VDD VDD pch l=0.15 w=1 nf=1 m=1
M2 net7 Vin2 net2 VSS nch l=0.15 w=1 nf=1 m=1
M3 net7 net1 VDD VDD pch l=0.15 w=1 nf=1 m=1
M4 net5 net1 VDD VDD pch l=0.15 w=1 nf=1 m=1
M5 Vout2 Vb1 net7 VDD pch l=0.15 w=1 nf=1 m=1
M6 Vout1 Vb1 net5 VDD pch l=0.15 w=1 nf=1 m=1
M7 net6 Vout2 VSS VSS nch l=0.15 w=1 nf=1 m=1
M8 net6 Vout1 VSS VSS nch l=0.15 w=1 nf=1 m=1
M9 net2 Vb net6 VSS nch l=0.15 w=1 nf=1 m=1
.ends dut
