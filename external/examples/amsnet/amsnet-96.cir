* official Analog Canvas netlist; PDK X cards rewritten by convert.py
.model nch nmos

.subckt dut VDD VSS Vin Vout
I0 VDD Vout DC 1m
M1 Vout Vin net0 VSS nch l=0.15 w=1 nf=1 m=1
RS net0 VSS 1k
.ends dut
