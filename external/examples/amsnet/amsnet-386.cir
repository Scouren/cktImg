* official Analog Canvas netlist; PDK X cards rewritten by convert.py
.model nch nmos

.subckt dut VDD VSS Vin_CM Vout1 Vout2
CL1 Vout1 VSS 1p
CL2 Vout2 VSS 1p
CP P VSS 1p
M1 Vout1 Vin_CM P VSS nch l=0.15 w=1 nf=1 m=1
M2 Vout2 Vin_CM P VSS nch l=0.15 w=1 nf=1 m=1
RD1 VDD Vout1 1k
RD2 VDD Vout2 1k
rO3 P VSS 1k
.ends dut
