* official Analog Canvas netlist; PDK X cards rewritten by convert.py
.model nch nmos

.subckt dut VDD VSS Vout
CF Vout X 1p
CL Vout VSS 1p
I1 VDD Vout DC 1m
ISS VDD X DC 1m
Mout Vout X VSS VSS nch l=0.15 w=1 nf=1 m=1
.ends dut
