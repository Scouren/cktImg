* official Analog Canvas netlist; PDK X cards rewritten by convert.py
.model nch nmos
.model pch pmos

.subckt dut VDD VSS Vb Vout N P Vin1 Vin2
M1 N Vin1 P VSS nch l=0.15 w=1 nf=1 m=1
M2 Vout Vin2 P VSS nch l=0.15 w=1 nf=1 m=1
M3 N N VDD VDD pch l=0.15 w=1 nf=1 m=1
M4 Vout N VDD VDD pch l=0.15 w=1 nf=1 m=1
M5 P Vb VSS VSS nch l=0.15 w=1 nf=1 m=1
.ends dut
