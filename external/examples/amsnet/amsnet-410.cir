* official Analog Canvas netlist; PDK X cards rewritten by convert.py
.model nch nmos

.subckt dut VDD VSS Vin Vb Vout
I1 VDD net0 DC 1m
I2 VDD Vout DC 1m
M1 net0 Vb net1 VSS nch l=0.15 w=1 nf=1 m=1
M2 Vout net0 VSS VSS nch l=0.15 w=1 nf=1 m=1
RS net1 Vin 1k
.ends dut
