* official Analog Canvas netlist; PDK X cards rewritten by convert.py
.model nch nmos

.subckt dut VSS Vin Vout CK
CH Vout VSS 1p
M1 Vin CK Vout VSS nch l=0.15 w=1 nf=1 m=1
.ends dut
