* official Analog Canvas netlist; PDK X cards rewritten by convert.py
.model nch nmos
.model pch pmos

.subckt dut VDD VSS Vin1 Vin2 Vb Vout1 Vout2 Vb1 Vb2 Vb3 Vb4
M1 net5 Vin1 net1 VSS nch l=0.15 w=1 nf=1 m=1
M10 net3 Vb4 VSS VSS nch l=0.15 w=1 nf=1 m=1
M11 net2 Vb4 VSS VSS nch l=0.15 w=1 nf=1 m=1
M12 Vout1 Vb3 net3 VSS nch l=0.15 w=1 nf=1 m=1
M13 Vout2 Vb3 net2 VSS nch l=0.15 w=1 nf=1 m=1
M2 net4 Vin2 net1 VSS nch l=0.15 w=1 nf=1 m=1
M3 net5 Vb1 VDD VDD pch l=0.15 w=1 nf=1 m=1
M4 net4 Vb1 VDD VDD pch l=0.15 w=1 nf=1 m=1
M5 Vout1 Vb2 net5 VDD pch l=0.15 w=1 nf=1 m=1
M6 Vout2 Vb2 net4 VDD pch l=0.15 w=1 nf=1 m=1
M7 net0 Vout2 VSS VSS nch l=0.15 w=1 nf=1 m=1
M8 net0 Vout1 VSS VSS nch l=0.15 w=1 nf=1 m=1
M9 net1 Vb net0 VSS nch l=0.15 w=1 nf=1 m=1
.ends dut
