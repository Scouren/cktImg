* official Analog Canvas netlist; PDK X cards rewritten by convert.py
.model nch nmos
.model pch pmos

.subckt dut VDD VSS Vin Vout
CC Vout net3 1p
CE VDD Vin 1p
CL Vout VSS 1p
M11 Vout net2 VSS VSS nch l=0.15 w=1 nf=1 m=1
M9 Vout Vin VDD VDD pch l=0.15 w=1 nf=1 m=1
Mb1 net2 net2 VSS VSS nch l=0.15 w=1 nf=1 m=1
Mb2 net0 net2 VSS VSS nch l=0.15 w=1 nf=1 m=1
Mb3 net2 net0 VDD VDD pch l=0.15 w=1 nf=1 m=1
Mb4 net0 net0 net1 VDD pch l=0.15 w=1 nf=1 m=1
RS VDD net1 1k
RZ net3 Vin 1k
.ends dut
