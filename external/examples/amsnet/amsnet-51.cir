* official Analog Canvas netlist; PDK X cards rewritten by convert.py
.model nch nmos

.subckt dut VSS VX
C1 VX net0 1p
M1 VX net0 VSS VSS nch l=0.15 w=1 nf=1 m=1
Vin net0 VSS DC 1
.ends dut
