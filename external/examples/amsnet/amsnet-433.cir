* official Analog Canvas netlist; PDK X cards rewritten by convert.py
.model nch nmos

.subckt dut VDD VSS D S G
In D S DC 1m
M1 D G S VSS nch l=0.15 w=1 nf=1 m=1
.ends dut
