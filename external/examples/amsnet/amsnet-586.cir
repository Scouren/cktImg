* official Analog Canvas netlist; PDK X cards rewritten by convert.py

.subckt dut VDD VSS Vout VF
It Vout VSS DC 1m
RD VDD Vout 1k
RF Vout VF 1k
RS VF VSS 1k
.ends dut
