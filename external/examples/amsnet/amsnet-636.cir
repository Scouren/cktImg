* official Analog Canvas netlist; PDK X cards rewritten by convert.py
.model nch nmos

.subckt dut VDD VSS Vb1 Vin1 Vin2 Vout1 Vout2
I1 VDD Vout1 DC 1m
I2 VDD Vout2 DC 1m
ISS net2 VSS DC 1m
M1 net1 Vin1 net2 VSS nch l=0.15 w=1 nf=1 m=1
M2 net0 Vin2 net2 VSS nch l=0.15 w=1 nf=1 m=1
M3 Vout1 Vb1 net1 VSS nch l=0.15 w=1 nf=1 m=1
M4 Vout2 Vb1 net0 VSS nch l=0.15 w=1 nf=1 m=1
.ends dut
