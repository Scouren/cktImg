* official Analog Canvas netlist; PDK X cards rewritten by convert.py
.model nch nmos
.model pch pmos

.subckt dut VDD VSS Vb Vin1 Vin2 Vout1 Vout2
ISS net1 VSS DC 0.5mA
M1 net0 Vin1 net1 VSS nch l=0.15 w=1 nf=1 m=1
M2 net2 Vin2 net1 VSS nch l=0.15 w=1 nf=1 m=1
M3 net0 net0 VDD VDD pch l=0.15 w=1 nf=1 m=1
M4 net2 net2 VDD VDD pch l=0.15 w=1 nf=1 m=1
M5 Vout1 net0 VDD VDD pch l=0.15 w=1 nf=1 m=1
M6 Vout2 net2 VDD VDD pch l=0.15 w=1 nf=1 m=1
M7 Vout1 Vb VSS VSS nch l=0.15 w=1 nf=1 m=1
M8 Vout2 Vb VSS VSS nch l=0.15 w=1 nf=1 m=1
.ends dut
