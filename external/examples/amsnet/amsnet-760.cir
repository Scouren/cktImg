* official Analog Canvas netlist; PDK X cards rewritten by convert.py
.model nch nmos

.subckt dut VDD VSS ID2 ID3
IREF VDD net0 DC 1m
M1 net0 net0 VSS VSS nch l=0.15 w=1 nf=1 m=1
M2 ID2 net0 VSS VSS nch l=0.15 w=1 nf=1 m=1
M3 ID3 net0 VSS VSS nch l=0.15 w=1 nf=1 m=1
.ends dut
