* official Analog Canvas netlist; PDK X cards rewritten by convert.py
.model nch nmos

.subckt dut VDD VSS Vout
Iin VSS Vout DC 1m
M1 VDD net0 Vout VSS nch l=0.15 w=1 nf=1 m=1
M2 net0 Vout VSS VSS nch l=0.15 w=1 nf=1 m=1
RD VDD net0 1k
RS Vout VSS 1k
.ends dut
