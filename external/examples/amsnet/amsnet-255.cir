* official Analog Canvas netlist; PDK X cards rewritten by convert.py
.model nch nmos
.model pch pmos

.subckt dut VDD VSS X P Vin1 Vin2
IREF VDD X DC 1m
M0 X X VSS VSS nch l=0.15 w=1 nf=1 m=1
M1 net2 Vin1 P VSS nch l=0.15 w=1 nf=1 m=1
M2 net0 Vin2 P VSS nch l=0.15 w=1 nf=1 m=1
M3 net2 net2 VDD VDD pch l=0.15 w=1 nf=1 m=1
M4 net0 net0 VDD VDD pch l=0.15 w=1 nf=1 m=1
M5 net2 net1 VDD VDD pch l=0.15 w=1 nf=1 m=1
M6 net0 net1 VDD VDD pch l=0.15 w=1 nf=1 m=1
M7 net1 net1 VDD VDD pch l=0.15 w=1 nf=1 m=1
M8 net1 X VSS VSS nch l=0.15 w=1 nf=1 m=1
M9 P X VSS VSS nch l=0.15 w=1 nf=1 m=1
.ends dut
