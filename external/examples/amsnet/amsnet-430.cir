* official Analog Canvas netlist; PDK X cards rewritten by convert.py

.subckt dut P N
In P N DC 1m
R P N 1k
.ends dut
