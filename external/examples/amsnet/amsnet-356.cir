* official Analog Canvas netlist; PDK X cards rewritten by convert.py
.model nch nmos

.subckt dut VDD VSS Vin Vout Y
CF Y Vout 1p
I1 VDD Y DC 1m
M1 Y Vout VSS VSS nch l=0.15 w=1 nf=1 m=1
R1 Vout Vin 1k
.ends dut
