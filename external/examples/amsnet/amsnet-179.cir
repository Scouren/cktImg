* official Analog Canvas netlist; PDK X cards rewritten by convert.py
.model nch nmos
.model pch pmos

.global VDD

.subckt dut VSS Vb1 Vin Vout
M1 Vout Vin VSS VSS nch l=0.15 w=1 nf=1 m=1
M2 net0 Vb1 Vout VSS nch l=0.15 w=1 nf=1 m=1
M3 net0 Vout VDD VDD pch l=0.15 w=1 nf=1 m=1
.ends dut
