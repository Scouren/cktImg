* official Analog Canvas netlist; PDK X cards rewritten by convert.py
.model nch nmos

.subckt dut VSS Vb Vout
CX X VSS 1p
CY Vout VSS 1p
Iin X VSS DC 1m
M2 Vout Vb X VSS nch l=0.15 w=1 nf=1 m=1
rO2 Vout X 1k
.ends dut
