* official Analog Canvas netlist; PDK X cards rewritten by convert.py
.model nch nmos

.subckt dut VDD VSS Vb P X Y
IREF VDD X DC 1m
M1 X X VSS VSS nch l=0.15 w=1 nf=1 m=1
M2 Y X VSS VSS nch l=0.15 w=1 nf=1 m=1
M3 P Vb Y VSS nch l=0.15 w=1 nf=1 m=1
.ends dut
