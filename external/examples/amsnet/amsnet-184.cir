* official Analog Canvas netlist; PDK X cards rewritten by convert.py
.model nch nmos

.subckt dut VDD VSS Vin Vout1 Vout2
M1 Vout1 Vin Vout2 VSS nch l=0.15 w=1 nf=1 m=1
RD1 VDD Vout1 1k
RD2 Vout2 VSS 1k
.ends dut
