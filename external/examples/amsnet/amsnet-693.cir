* official Analog Canvas netlist; PDK X cards rewritten by convert.py
.model nch nmos
.model pch pmos

.subckt dut VDD VSS Vb1 Vb2 Vb Vin M2_S
CL1 net0 VSS 1p
CL2 net2 VSS 1p
ISS M2_S VSS DC 1m
M1 net1 Vin M2_S VSS nch l=0.15 w=1 nf=1 m=1
M3 net0 Vb net1 VSS nch l=0.15 w=1 nf=1 m=1
M5 net0 Vb2 net4 VDD pch l=0.15 w=1 nf=1 m=1
M6 net2 Vb2 net3 VDD pch l=0.15 w=1 nf=1 m=1
M7 net4 Vb1 VDD VDD pch l=0.15 w=1 nf=1 m=1
M8 net3 Vb1 VDD VDD pch l=0.15 w=1 nf=1 m=1
.ends dut
