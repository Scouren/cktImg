* official Analog Canvas netlist; PDK X cards rewritten by convert.py
.model nch nmos

.subckt dut VDD VSS Vb X Y P Vin1 Vin2
M1 net0 Y P VSS nch l=0.15 w=1 nf=1 m=1
M2 net1 X P VSS nch l=0.15 w=1 nf=1 m=1
M3 X Vin1 net2 VSS nch l=0.15 w=1 nf=1 m=1
M4 Y Vin2 net2 VSS nch l=0.15 w=1 nf=1 m=1
M5 net2 Vb VSS VSS nch l=0.15 w=1 nf=1 m=1
M6 P Vb VSS VSS nch l=0.15 w=1 nf=1 m=1
RP1 VDD X 1k
RP2 VDD Y 1k
RP3 VDD net0 1k
RP4 VDD net1 1k
.ends dut
