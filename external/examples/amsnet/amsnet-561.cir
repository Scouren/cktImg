* official Analog Canvas netlist; PDK X cards rewritten by convert.py
.model nch nmos

.subckt dut VDD VSS VF Vb
C1 net0 P 1p
C2 P VSS 1p
M1 VSS P VSS VSS nch l=0.15 w=1 nf=1 m=1
M2 VF Vb VSS VSS nch l=0.15 w=1 nf=1 m=1
RD VDD VF 1k
Vt net0 VSS DC 1
.ends dut
