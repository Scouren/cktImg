* official Analog Canvas netlist; PDK X cards rewritten by convert.py
.model nch nmos
.model pch pmos

.subckt dut VDD VSS Vin+ Vin-
CL1 net0 VSS 1p
CL2 net1 VSS 1p
M1 net0 Vin+ VSS VSS nch l=0.15 w=1 nf=1 m=1
M2 net0 X VDD VDD pch l=0.15 w=1 nf=1 m=1
M3a net1 Y VDD VDD pch l=0.15 w=1 nf=1 m=1
M3b net1 Vin- VSS VSS nch l=0.15 w=1 nf=1 m=1
M5 Y Vin+ VSS VSS nch l=0.15 w=1 nf=1 m=1
M6 X Vin- VSS VSS nch l=0.15 w=1 nf=1 m=1
M7 X X VDD VDD pch l=0.15 w=1 nf=1 m=1
M8 Y Y VDD VDD pch l=0.15 w=1 nf=1 m=1
.ends dut
