* official Analog Canvas netlist; PDK X cards rewritten by convert.py
.model nch nmos

.subckt dut VSS +2V +1V
M1 +1V +2V F VSS nch l=0.15 w=1 nf=1 m=1
VX F VSS DC 1
.ends dut
