* official Analog Canvas netlist; PDK X cards rewritten by convert.py
.model nch nmos

.global VDD

.subckt dut VSS Vb
M1 net0 Vb net1 VSS nch l=0.15 w=1 nf=1 m=1
RD VDD net0 1k
RS net1 VSS 1k
VX net1 VSS DC 1
.ends dut
