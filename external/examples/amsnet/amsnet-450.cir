* official Analog Canvas netlist; PDK X cards rewritten by convert.py
.model nch nmos

.subckt dut VDD VSS Vn_out Vin
In Vn_out net0 DC 1m
M1 Vn_out Vin net0 VSS nch l=0.15 w=1 nf=1 m=1
R1 VDD Vn_out 1k
R2 net0 VSS 1k
.ends dut
