* official Analog Canvas netlist; PDK X cards rewritten by convert.py
.model nch nmos

.subckt dut VDD VSS Vin1 Vout1
CDB Vout1 VSS 1p
CGD Vout1 Vin1 1p
CGS Vin1 VSS 1p
M1 Vout1 Vin1 VSS VSS nch l=0.15 w=1 nf=1 m=1
RD VDD Vout1 1k
.ends dut
