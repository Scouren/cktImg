* official Analog Canvas netlist; PDK X cards rewritten by convert.py
.model nch nmos

.subckt dut VDD VSS Vin1 VX
M1 VX Vin1 net0 VSS nch l=0.15 w=1 nf=1 m=1
RD1 VDD VX 1k
RS net0 VSS 1k
.ends dut
