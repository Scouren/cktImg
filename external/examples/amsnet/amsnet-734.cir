* official Analog Canvas netlist; PDK X cards rewritten by convert.py

.subckt dut VDD VSS Vout
CF Vout X 1p
CL Vout VSS 1p
I1 VDD Vout DC 1m
ISS X VSS DC 1m
.ends dut
