* official Analog Canvas netlist; PDK X cards rewritten by convert.py
.model nch nmos

.subckt dut VDD VSS X Y Vin1 Vin2
I1 net1 VSS DC 1m
I2 net0 VSS DC 1m
M1 X Vin1 net1 VSS nch l=0.15 w=1 nf=1 m=1
M2 Y Vin2 net0 VSS nch l=0.15 w=1 nf=1 m=1
RD1 VDD X 1k
RD2 VDD Y 1k
RS net0 net1 1k
.ends dut
