* official Analog Canvas netlist; PDK X cards rewritten by convert.py
.model nch nmos

.subckt dut VDD VSS Vin
CGS X Y 1p
I1 Y VSS DC 1m
M1 VDD X Y VSS nch l=0.15 w=1 nf=1 m=1
RS X Vin 1k
.ends dut
