* official Analog Canvas netlist; PDK X cards rewritten by convert.py
.model pch pmos

.subckt dut VDD VSS Iin
M1 VSS VSS Iin VDD pch l=0.15 w=1 nf=1 m=1
.ends dut
