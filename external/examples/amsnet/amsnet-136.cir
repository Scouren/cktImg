* official Analog Canvas netlist; PDK X cards rewritten by convert.py
.model nch nmos

.subckt dut VDD VSS Vb Vout
I1 VDD Vout DC 1m
M2 Vout Vb net1 VSS nch l=0.15 w=1 nf=1 m=1
rO1 net1 net0 1k
rO2 Vout net1 1k
V1 net0 VSS DC 1
.ends dut
