* official Analog Canvas netlist; PDK X cards rewritten by convert.py
.model nch nmos
.model pch pmos

.subckt dut VSS VB Vout
M1 Vout VB VSS VSS nch l=0.15 w=1 nf=1 m=1
M2 Vout VB net0 net0 pch l=0.15 w=1 nf=1 m=1
VDD net0 VSS DC 1
.ends dut
