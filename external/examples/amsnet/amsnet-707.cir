* official Analog Canvas netlist; PDK X cards rewritten by convert.py
.model nch nmos
.model pch pmos

.subckt dut VDD VSS Vin Vout
C1 Vout P 1p
C2 P VSS 1p
ISS net0 VSS DC 1m
M1 X Vin net0 VSS nch l=0.15 w=1 nf=1 m=1
M2 Vout P net0 VSS nch l=0.15 w=1 nf=1 m=1
M3 X X VDD VDD pch l=0.15 w=1 nf=1 m=1
M4 Vout X VDD VDD pch l=0.15 w=1 nf=1 m=1
.ends dut
