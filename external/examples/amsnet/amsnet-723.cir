* official Analog Canvas netlist; PDK X cards rewritten by convert.py
.model pch pmos

.subckt dut VDD VSS Vout
CE VDD Vout 1p
CL Vout VSS 1p
M9 Vout Vout VDD VDD pch l=0.15 w=1 nf=1 m=1
RL Vout VSS 1k
RS Vout VSS 1k
.ends dut
