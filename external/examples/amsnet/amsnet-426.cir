* official Analog Canvas netlist; PDK X cards rewritten by convert.py
.model nch nmos
.model pch pmos

.subckt dut VDD VSS Vin1 Vin2 Vout1 Vout2
C1 VDD net1 1p
C2 VDD net2 1p
ISS net0 VSS DC 1m
M1 Vout1 Vin1 net0 VSS nch l=0.15 w=1 nf=1 m=1
M2 Vout2 Vin2 net0 VSS nch l=0.15 w=1 nf=1 m=1
M3 Vout1 net1 VDD VDD pch l=0.15 w=1 nf=1 m=1
M4 Vout2 net2 VDD VDD pch l=0.15 w=1 nf=1 m=1
R1 Vout1 net1 1k
R2 net2 Vout2 1k
.ends dut
