* official Analog Canvas netlist; PDK X cards rewritten by convert.py
.model nch nmos
.model pch pmos

.subckt dut VDD VSS Vin1 Vin2
I1 net0 VSS DC 1m
M1 net1 Vin1 P VSS nch l=0.15 w=1 nf=1 m=1
M2 net2 Vin2 P VSS nch l=0.15 w=1 nf=1 m=1
M3 net1 net0 VDD VDD pch l=0.15 w=1 nf=1 m=1
M4 net2 net0 VDD VDD pch l=0.15 w=1 nf=1 m=1
M5 P net1 VSS VSS nch l=0.15 w=1 nf=1 m=1
M6 P net2 VSS VSS nch l=0.15 w=1 nf=1 m=1
M7 net0 net0 VDD VDD pch l=0.15 w=1 nf=1 m=1
.ends dut
