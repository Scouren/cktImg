* official Analog Canvas netlist; PDK X cards rewritten by convert.py
.model nch nmos
.model pch pmos

.subckt dut VDD VSS Vb1 X Vout
M1 X VSS VSS VDD pch l=0.15 w=1 nf=1 m=1
M3 Vout Vb1 X VSS nch l=0.15 w=1 nf=1 m=1
R1 X VSS 1k
ROP VSS Vout 1k
.ends dut
