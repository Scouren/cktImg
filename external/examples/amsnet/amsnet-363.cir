* official Analog Canvas netlist; PDK X cards rewritten by convert.py
.model nch nmos

.subckt dut VDD VSS
CDB net1 VSS 1p
CGD net1 net0 1p
CGS net0 VSS 1p
M1 net1 net0 VSS VSS nch l=0.15 w=1 nf=1 m=1
RD VDD net1 1k
.ends dut
