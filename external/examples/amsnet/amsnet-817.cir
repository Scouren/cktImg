* official Analog Canvas netlist; PDK X cards rewritten by convert.py
.model nch nmos

.subckt dut VDD VSS Vb Vin1 Vin2 Vout1 Vout2
I1 net2 VSS DC 1m
M1a Vout1 Vb net0 VSS nch l=0.15 w=1 nf=1 m=1
M1b net0 Vin1 net2 VSS nch l=0.15 w=1 nf=1 m=1
M2a Vout2 Vb net1 VSS nch l=0.15 w=1 nf=1 m=1
M2b net1 Vin2 net2 VSS nch l=0.15 w=1 nf=1 m=1
RD1 VDD Vout1 1k
RD2 VDD Vout2 1k
.ends dut
