* official Analog Canvas netlist; PDK X cards rewritten by convert.py
.model nch nmos
.model pch pmos

.global VDD

.subckt dut VSS Vb4 Vb3 Vb2 Vb1 Vin P X Vout
M1 X Vin VSS VSS nch l=0.15 w=1 nf=1 m=1
M11 P Vb3 net0 VDD pch l=0.15 w=1 nf=1 m=1
M13 net0 Vb4 VDD VDD pch l=0.15 w=1 nf=1 m=1
M3 Vout P X VSS nch l=0.15 w=1 nf=1 m=1
M5 net1 X VSS VDD pch l=0.15 w=1 nf=1 m=1
M7 P Vb2 net1 VSS nch l=0.15 w=1 nf=1 m=1
M9 net1 Vb1 VSS VSS nch l=0.15 w=1 nf=1 m=1
.ends dut
