* official Analog Canvas netlist; PDK X cards rewritten by convert.py
.model nch nmos

.subckt dut VDD VSS Vout
I1 Vout VSS DC 1m
M2 VDD VDD Vout VSS nch l=0.15 w=1 nf=1 m=1
.ends dut
