* official Analog Canvas netlist; PDK X cards rewritten by convert.py
.model nch nmos
.model pch pmos

.subckt dut VDD VSS +Vin/2 -Vin/2
ISS P VSS DC 1m
M1 F +Vin/2 P VSS nch l=0.15 w=1 nf=1 m=1
M2 VSS -Vin/2 P VSS nch l=0.15 w=1 nf=1 m=1
M3 F F VDD VDD pch l=0.15 w=1 nf=1 m=1
M4 VSS F VDD VDD pch l=0.15 w=1 nf=1 m=1
.ends dut
