* official Analog Canvas netlist; PDK X cards rewritten by convert.py
.model nch nmos

.subckt dut VDD VSS X Y
IREF VDD X DC 1m
M1 Y X VSS VSS nch l=0.15 w=1 nf=1 m=1
M2 X X net0 VSS nch l=0.15 w=1 nf=1 m=1
R1 VDD Y 1k
R2 Y X 1k
V1 net0 VSS DC 1
.ends dut
