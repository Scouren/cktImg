* official Analog Canvas netlist; PDK X cards rewritten by convert.py
.model nch nmos
.model pch pmos

.subckt dut VDD VSS Vin Vout Iout
CL Vout VSS 1p
M1 Vout Vin VSS VSS nch l=0.15 w=1 nf=1 m=1
M2 Vout Iout VDD VDD pch l=0.15 w=1 nf=1 m=1
M3 Iout Iout VDD VDD pch l=0.15 w=1 nf=1 m=1
.ends dut
