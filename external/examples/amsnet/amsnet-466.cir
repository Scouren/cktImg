* official Analog Canvas netlist; PDK X cards rewritten by convert.py
.model nch nmos

.subckt dut VDD VSS Vb Vn_out Vin
In1 Vn_out Vin DC 1m
InRD VDD Vn_out DC 1m
M1 Vn_out Vb Vin VSS nch l=0.15 w=1 nf=1 m=1
RD VDD Vn_out 1k
.ends dut
