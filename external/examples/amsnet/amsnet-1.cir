* official Analog Canvas netlist; PDK X cards rewritten by convert.py
.model pch pmos

.subckt dut -0.1V VSS
M1 -0.1V net0 VSS -0.1V pch l=0.15 w=1 nf=1 m=1
VG VSS net0 DC 1
.ends dut
