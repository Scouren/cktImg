* official Analog Canvas netlist; PDK X cards rewritten by convert.py
.model nch nmos
.model pch pmos

.subckt dut VDD VSS Vin Vout Vb
C1 Vout net2 1p
C2 net2 Vin 1p
I1 net1 VSS DC 1m
M1 Vout net2 net1 VSS nch l=0.15 w=1 nf=1 m=1
M2 net0 Vb net1 VSS nch l=0.15 w=1 nf=1 m=1
M3 net0 net0 VDD VDD pch l=0.15 w=1 nf=1 m=1
M4 Vout net0 VDD VDD pch l=0.15 w=1 nf=1 m=1
.ends dut
