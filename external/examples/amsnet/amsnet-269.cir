* official Analog Canvas netlist; PDK X cards rewritten by convert.py
.model nch nmos
.model pch pmos

.subckt dut VDD VSS Vin1 Vin2 Vout
I1 net0 VSS DC 1m
ISS P VSS DC 1m
M1 VDD Vin1 P VSS nch l=0.15 w=1 nf=1 m=1
M2 Vout Vin2 P VSS nch l=0.15 w=1 nf=1 m=1
M3 net0 net0 VDD VDD pch l=0.15 w=1 nf=1 m=1
M4 Vout net0 VDD VDD pch l=0.15 w=1 nf=1 m=1
.ends dut
