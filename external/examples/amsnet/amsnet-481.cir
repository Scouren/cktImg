* official Analog Canvas netlist; PDK X cards rewritten by convert.py
.model nch nmos

.subckt dut VDD VSS P
In_RD1 VDD net1 DC 1m
In_RD2 VDD net0 DC 1m
In1 net1 P DC 1m
In2 net0 P DC 1m
ISS P VSS DC 1m
M1 net1 net2 P VSS nch l=0.15 w=1 nf=1 m=1
M2 net0 net2 P VSS nch l=0.15 w=1 nf=1 m=1
RD1 VDD net1 1k
RD2 VDD net0 1k
.ends dut
