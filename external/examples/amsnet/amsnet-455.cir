* official Analog Canvas netlist; PDK X cards rewritten by convert.py

.subckt dut VSS
R1 net1 net0 1k
R2 net1 VSS 1k
VThev1 net0 VSS DC 1
.ends dut
