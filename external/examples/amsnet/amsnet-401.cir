* official Analog Canvas netlist; PDK X cards rewritten by convert.py
.model nch nmos

.subckt dut VDD VSS A B
CF B A 1p
M1 B A VSS VSS nch l=0.15 w=1 nf=1 m=1
RD VDD B 1k
RS A net0 1k
V1 B VSS DC 1
Vin net0 VSS DC 1
.ends dut
