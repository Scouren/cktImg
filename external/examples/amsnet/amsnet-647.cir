* official Analog Canvas netlist; PDK X cards rewritten by convert.py
.model nch nmos
.model pch pmos

.subckt dut VDD VSS Vb Vin1 Vin2 Vout
ISS net3 VSS DC 1m
M1 net1 Vin1 net3 VSS nch l=0.15 w=1 nf=1 m=1
M2 net2 Vin2 net3 VSS nch l=0.15 w=1 nf=1 m=1
M3 net1 Vb VDD VDD pch l=0.15 w=1 nf=1 m=1
M4 net2 Vb VDD VDD pch l=0.15 w=1 nf=1 m=1
M5 net0 net1 VDD VDD pch l=0.15 w=1 nf=1 m=1
M6 Vout net2 VDD VDD pch l=0.15 w=1 nf=1 m=1
M7 net0 net0 VSS VSS nch l=0.15 w=1 nf=1 m=1
M8 Vout net0 VSS VSS nch l=0.15 w=1 nf=1 m=1
.ends dut
