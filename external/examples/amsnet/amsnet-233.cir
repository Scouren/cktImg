* official Analog Canvas netlist; PDK X cards rewritten by convert.py
.model nch nmos

.subckt dut VDD VSS Vout1 Vout2 Vin+ Vin- Vcont+ Vcont-
ISS net0 VSS DC 1m
M1 Vout1 Vin+ A VSS nch l=0.15 w=1 nf=1 m=1
M2 Vout2 Vin- A VSS nch l=0.15 w=1 nf=1 m=1
M3 Vout2 Vin+ B VSS nch l=0.15 w=1 nf=1 m=1
M4 Vout1 Vin- B VSS nch l=0.15 w=1 nf=1 m=1
M5 A Vcont+ net0 VSS nch l=0.15 w=1 nf=1 m=1
M6 B Vcont- net0 VSS nch l=0.15 w=1 nf=1 m=1
RD1 VDD Vout1 1k
RD2 VDD Vout2 1k
.ends dut
