* official Analog Canvas netlist; PDK X cards rewritten by convert.py
.model nch nmos

.subckt dut VDD VSS Vout2 Vout1
M1 Vout1 net1 net2 VSS nch l=0.15 w=1 nf=1 m=1
M2 Vout2 net0 net2 VSS nch l=0.15 w=1 nf=1 m=1
RD1 VDD Vout1 1k
RD2 VDD Vout2 1k
RSS net2 VSS 1k
V1 net1 net0 DC 1
V2 net0 VSS DC 1
.ends dut
