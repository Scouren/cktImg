* official Analog Canvas netlist; PDK X cards rewritten by convert.py
.model nch nmos

.subckt dut VDD VSS Vout Vb
Cin X net3 1p
IB VDD net0 DC 1m
M1 Vout Vb X VSS nch l=0.15 w=1 nf=1 m=1
M2 X net0 VSS VSS nch l=0.15 w=1 nf=1 m=1
M3 net0 Vb net2 VSS nch l=0.15 w=1 nf=1 m=1
MB net2 net0 VSS VSS nch l=0.15 w=1 nf=1 m=1
R1 net3 net1 1k
RD VDD Vout 1k
Vin net1 VSS DC 1
.ends dut
