* official Analog Canvas netlist; PDK X cards rewritten by convert.py
.model nch nmos

.subckt dut VDD VSS
I1 VDD net1 DC 1m
M1 net1 net0 VSS VSS nch l=0.15 w=1 nf=1 m=1
R1 net1 net0 1k
VX net0 VSS DC 1
.ends dut
