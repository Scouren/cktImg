* official Analog Canvas netlist; PDK X cards rewritten by convert.py
.model nch nmos
.model pch pmos

.subckt dut VDD VSS Vin Vout
C1 net0 VSS 1p
I1 net0 VSS DC 1m
I2 X VSS DC 1m
M1 Vout X net0 VSS nch l=0.15 w=1 nf=1 m=1
M2 Vout Vout VDD VDD pch l=0.15 w=1 nf=1 m=1
M3 VDD Vin X VSS nch l=0.15 w=1 nf=1 m=1
.ends dut
