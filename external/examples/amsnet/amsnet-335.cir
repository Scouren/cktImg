* official Analog Canvas netlist; PDK X cards rewritten by convert.py
.model nch nmos
.model pch pmos

.subckt dut VDD VSS X Y
IREF VDD X DC 1m
M1 Y X VSS VSS nch l=0.15 w=1 nf=1 m=1
M2 X X VSS VSS nch l=0.15 w=1 nf=1 m=1
M3 Y Y VDD VDD pch l=0.15 w=1 nf=1 m=1
M4 X Y VDD VDD pch l=0.15 w=1 nf=1 m=1
.ends dut
