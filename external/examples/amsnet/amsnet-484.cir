* official Analog Canvas netlist; PDK X cards rewritten by convert.py
.model nch nmos

.subckt dut VDD VSS Vin
In1a net1 VSS DC 1m
In1b VSS net0 DC 1m
M1 net1 Vin net0 VSS nch l=0.15 w=1 nf=1 m=1
R1 net0 VSS 1k
RD1 VDD net1 1k
.ends dut
