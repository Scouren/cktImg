* official Analog Canvas netlist; PDK X cards rewritten by convert.py
.model nch nmos
.model pch pmos

.subckt dut VDD VSS Vout Vin1 Vin2
I1 net1 VSS DC 1m
ISS net0 VSS DC 1m
M1 VDD Vin1 net0 VSS nch l=0.15 w=1 nf=1 m=1
M2 Vout Vin2 net0 VSS nch l=0.15 w=1 nf=1 m=1
M3 net1 net1 VDD VDD pch l=0.15 w=1 nf=1 m=1
M4 Vout net1 VDD VDD pch l=0.15 w=1 nf=1 m=1
.ends dut
