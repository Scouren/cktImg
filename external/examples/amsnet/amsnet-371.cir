* official Analog Canvas netlist; PDK X cards rewritten by convert.py
.model nch nmos

.subckt dut VDD VSS
CGS X Y 1p
M1 VDD X Y VSS nch l=0.15 w=1 nf=1 m=1
R1 Y VSS 1k
VX X VSS DC 1
.ends dut
