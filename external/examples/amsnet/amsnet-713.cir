* official Analog Canvas netlist; PDK X cards rewritten by convert.py
.model nch nmos

.subckt dut VDD VSS Vin Vout
I1 VDD net0 DC 1m
I2 VDD Vout DC 1m
M1 X Vin VSS VSS nch l=0.15 w=1 nf=1 m=1
M2 Vout net0 X VSS nch l=0.15 w=1 nf=1 m=1
M3 net0 X VSS VSS nch l=0.15 w=1 nf=1 m=1
.ends dut
