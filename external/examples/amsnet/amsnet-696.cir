* official Analog Canvas netlist; PDK X cards rewritten by convert.py
.model nch nmos
.model pch pmos

.subckt dut VDD VSS Vb1 Vb2 Vin M2_S
ISS M2_S VSS DC 1m
M1 X Vin M2_S VSS nch l=0.15 w=1 nf=1 m=1
M3 NC0001 Vb2 X VDD pch l=0.15 w=1 nf=1 m=1
M9 X Vb1 VDD VDD pch l=0.15 w=1 nf=1 m=1
.ends dut
