* official Analog Canvas netlist; PDK X cards rewritten by convert.py
.model nch nmos
.model pch pmos

.subckt dut VDD VSS
VB1 VDD net1 DC 1
VB2 net0 VSS DC 1
ISS net2 VSS DC 1m
M1 X_Y net0 net2 VSS nch l=0.15 w=1 nf=1 m=1
M3 X_Y net1 VDD VDD pch l=0.15 w=1 nf=1 m=1
R1 VDD X_Y 1k
.ends dut
