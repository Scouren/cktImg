* official Analog Canvas netlist; PDK X cards rewritten by convert.py
.model nch nmos

.subckt dut VDD VSS Vout
M1 Vout net1 VSS VSS nch l=0.15 w=1 nf=1 m=1
RD VDD Vout 1k
RF Vout net1 1k
RS net1 net0 1k
Vin net0 VSS DC 1
.ends dut
