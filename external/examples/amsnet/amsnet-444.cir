* official Analog Canvas netlist; PDK X cards rewritten by convert.py
.model nch nmos

.subckt dut VDD VSS Vn2_out Vin
Cin Vin VSS 1p
In_in Vin VSS DC 1m
M1 Vn2_out Vin VSS VSS nch l=0.15 w=1 nf=1 m=1
RD VDD Vn2_out 1k
.ends dut
