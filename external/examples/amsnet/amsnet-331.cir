* official Analog Canvas netlist; PDK X cards rewritten by convert.py
.model nch nmos

.subckt dut VDD VSS X Y
IREF VDD X DC 1m
M1 Y X VSS VSS nch l=0.15 w=1 nf=1 m=1
M2 X X VSS VSS nch l=0.15 w=1 nf=1 m=1
M3 net0 Y X VSS nch l=0.15 w=1 nf=1 m=1
R1 net0 Y 1k
V1 net0 VSS DC 1
.ends dut
