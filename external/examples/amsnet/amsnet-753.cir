* official Analog Canvas netlist; PDK X cards rewritten by convert.py
.model nch nmos
.model pch pmos

.subckt dut VDD VSS Vb3 Vb2 Vb1 X Y Vin1 Vin2 Vb4
M1 net3 Vin1 P VSS nch l=0.04 w=45 nf=1 m=1
M2 net1 Vin2 P VSS nch l=0.04 w=45 nf=1 m=1
M3 X Vb1 net3 VSS nch l=0.08 w=90 nf=1 m=1
M4 Y Vb1 net1 VSS nch l=0.08 w=90 nf=1 m=1
M5 X Vb2 net0 net0 pch l=0.08 w=50 nf=1 m=1
M6 Y Vb2 net2 net2 pch l=0.08 w=50 nf=1 m=1
M7 net0 Vb3 VDD VDD pch l=0.08 w=50 nf=1 m=1
M8 net2 Vb3 VDD VDD pch l=0.08 w=50 nf=1 m=1
M9 P Vb4 VSS VSS nch l=0.08 w=180 nf=1 m=1
.ends dut
