* official Analog Canvas netlist; PDK X cards rewritten by convert.py

.subckt dut VSS Vout
G1 Vout VSS V1 VSS 1m
r0 Vout VSS 1k
RD Vout VSS 1k
Vin V1 VSS DC 1
.ends dut
