* official Analog Canvas netlist; PDK X cards rewritten by convert.py

.global VDD

.subckt dut Iout
I2 VDD Iout DC 1m
.ends dut
