* official Analog Canvas netlist; PDK X cards rewritten by convert.py
.model nch nmos
.model pch pmos

.global VDD

.subckt dut VSS Vb3 Vb1 Vb2
M1 net1 Vb2 VSS VSS nch l=0.15 w=1 nf=1 m=1
M2 net0 Vb1 net1 VSS nch l=0.15 w=1 nf=1 m=1
M3 net0 Vb3 VDD VDD pch l=0.15 w=1 nf=1 m=1
VX net1 VSS DC 1
.ends dut
