* official Analog Canvas netlist; PDK X cards rewritten by convert.py
.model nch nmos

.subckt dut VSS VX
C1 VX VSS 1p
C2 net0 VSS 1p
I1 VX net0 DC 1m
M1 VX net0 VSS VSS nch l=0.15 w=1 nf=1 m=1
.ends dut
