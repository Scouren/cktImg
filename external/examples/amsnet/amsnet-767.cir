* official Analog Canvas netlist; PDK X cards rewritten by convert.py

.global VDD

.subckt dut VSS
I1 net0 VSS DC 1m
I2 net0 VSS DC 1m
R1 VDD net0 1k
.ends dut
