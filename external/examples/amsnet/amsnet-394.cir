* official Analog Canvas netlist; PDK X cards rewritten by convert.py
.model nch nmos
.model pch pmos

.subckt dut VDD VSS Vin1 Vout1
C1 VDD X 1p
CGD5 X Vout1 1p
CL Vout1 VSS 1p
M1 X net0 VSS VSS nch l=0.15 w=1 nf=1 m=1
M5 Vout1 X VDD VDD pch l=0.15 w=1 nf=1 m=1
R1 VDD X 1k
RD Vout1 VSS 1k
RS net0 Vin1 1k
.ends dut
