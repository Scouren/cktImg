* official Analog Canvas netlist; PDK X cards rewritten by convert.py
.model nch nmos
.model pch pmos

.global VDD

.subckt dut VSS Vin Vout
M1 Vout Vout VSS VSS nch l=0.15 w=1 nf=1 m=1
M2 net0 Vin Vout VSS nch l=0.15 w=1 nf=1 m=1
M3 net0 net0 VDD VDD pch l=0.15 w=1 nf=1 m=1
.ends dut
