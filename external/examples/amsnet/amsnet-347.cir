* official Analog Canvas netlist; PDK X cards rewritten by convert.py
.model nch nmos
.model pch pmos

.subckt dut VDD VSS Vin
C1 net0 VSS 1p
I1 Vin VSS DC 1m
M1 net0 Vin VSS VSS nch l=0.15 w=1 nf=1 m=1
M2 Vin net0 VDD VDD pch l=0.15 w=1 nf=1 m=1
M3 net0 net0 VDD VDD pch l=0.15 w=1 nf=1 m=1
.ends dut
