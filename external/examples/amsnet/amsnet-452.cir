* official Analog Canvas netlist; PDK X cards rewritten by convert.py
.model nch nmos

.subckt dut VSS
In VSS net0 DC 1m
M1 VSS VSS net0 VSS nch l=0.15 w=1 nf=1 m=1
R1 net0 VSS 1k
.ends dut
