* official Analog Canvas netlist; PDK X cards rewritten by convert.py
.model nch nmos
.model pch pmos

.subckt dut VDD VSS X Y
C1 net0 net1 1p
M1 Y X VSS net1 nch l=0.15 w=1 nf=1 m=1
M2 X Y VDD VDD pch l=0.15 w=1 nf=1 m=1
M3 Y Y VDD net0 pch l=0.15 w=1 nf=1 m=1
.ends dut
