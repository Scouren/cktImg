* official Analog Canvas netlist; PDK X cards rewritten by convert.py
.model pch pmos

.subckt dut VDD VSS Vout
M1 VSS net0 Vout VDD pch l=0.15 w=1 nf=1 m=1
rO1 Vout VSS 1k
Vin net0 VSS DC 1
.ends dut
