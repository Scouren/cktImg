* official Analog Canvas netlist; PDK X cards rewritten by convert.py
.model nch nmos

.subckt dut VDD VSS Vout
CGS net0 Vout 1p
CL Vout VSS 1p
M1 VDD net0 Vout VSS nch l=0.15 w=1 nf=1 m=1
R1 Vout VSS 1k
VX net0 VSS DC 1
.ends dut
