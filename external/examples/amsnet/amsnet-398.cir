* official Analog Canvas netlist; PDK X cards rewritten by convert.py
.model nch nmos

.subckt dut VDD VSS Vout
CF Vout A 1p
M1 Vout A VSS VSS nch l=0.15 w=1 nf=1 m=1
RD VDD Vout 1k
RS A net0 1k
Vin net0 VSS DC 1
.ends dut
