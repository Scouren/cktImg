* official Analog Canvas netlist; PDK X cards rewritten by convert.py
.model nch nmos

.global VDD

.subckt dut VSS Vin VB Vout
CB X Vin 1p
M1 Vout X VSS VSS nch l=0.15 w=1 nf=1 m=1
RB X VB 1k
RD VDD Vout 1k
.ends dut
