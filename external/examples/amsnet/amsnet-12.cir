* official Analog Canvas netlist; PDK X cards rewritten by convert.py
.model nch nmos

.global VDD

.subckt dut VSS Vin Vout
I1 Vout VSS DC 1m
M1 VDD Vin Vout VSS nch l=0.15 w=1 nf=1 m=1
.ends dut
