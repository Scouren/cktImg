* official Analog Canvas netlist; PDK X cards rewritten by convert.py
.model nch nmos

.subckt dut VDD VSS Vn1_out
Cin VSS VSS 1p
M1 Vn1_out VSS VSS VSS nch l=0.15 w=1 nf=1 m=1
RD VDD Vn1_out 1k
.ends dut
