* official Analog Canvas netlist; PDK X cards rewritten by convert.py
.model nch nmos

.subckt dut VDD VSS VX
C1 VX net0 1p
M1 VDD net0 VX VSS nch l=0.15 w=1 nf=1 m=1
Vin net0 VSS DC 1
.ends dut
