* official Analog Canvas netlist; PDK X cards rewritten by convert.py
.model nch nmos
.model pch pmos

.subckt dut VDD VSS +1.5V Vb Vout
M1 F +1.5V P VSS nch l=0.15 w=1 nf=1 m=1
M2 Vout +1.5V P VSS nch l=0.15 w=1 nf=1 m=1
M3 F F VDD VDD pch l=0.15 w=1 nf=1 m=1
M4 Vout F VDD VDD pch l=0.15 w=1 nf=1 m=1
M5 P Vb VSS VSS nch l=0.15 w=1 nf=1 m=1
.ends dut
