* official Analog Canvas netlist; PDK X cards rewritten by convert.py
.model nch nmos

.subckt dut VSS Vin1 Vout1
CGD1 Vout1 Vin1 1p
CL Vout1 VSS 1p
M1 Vout1 Vin1 VSS VSS nch l=0.15 w=1 nf=1 m=1
R1 Vout1 VSS 1k
.ends dut
