* official Analog Canvas netlist; PDK X cards rewritten by convert.py
.model nch nmos
.model pch pmos

.subckt dut VDD VSS Vout Vin1 Vin2
I1 G VSS DC 1m
ISS net0 VSS DC 1m
M1 F Vin1 net0 VSS nch l=0.15 w=1 nf=1 m=1
M2 Vout Vin2 net0 VSS nch l=0.15 w=1 nf=1 m=1
M3 F G VDD VDD pch l=0.15 w=1 nf=1 m=1
M4 Vout G VDD VDD pch l=0.15 w=1 nf=1 m=1
R1 G F 1k
.ends dut
