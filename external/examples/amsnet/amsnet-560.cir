* official Analog Canvas netlist; PDK X cards rewritten by convert.py
.model nch nmos

.subckt dut VDD VSS Vb Vout
C1 Vout P 1p
C2 P VSS 1p
M1 net0 P VSS VSS nch l=0.15 w=1 nf=1 m=1
M2 Vout Vb net0 VSS nch l=0.15 w=1 nf=1 m=1
RD VDD Vout 1k
Vin net0 VSS DC 1
.ends dut
