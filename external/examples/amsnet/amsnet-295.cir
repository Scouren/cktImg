* official Analog Canvas netlist; PDK X cards rewritten by convert.py
.model nch nmos
.model pch pmos

.subckt dut VDD VSS Vout
VB1 net1 VSS DC 1
ISS net0 VSS DC 1m
M1 F net1 net0 VSS nch l=0.15 w=1 nf=1 m=1
M2 Vout net1 net0 VSS nch l=0.15 w=1 nf=1 m=1
M3 F F VDD VDD pch l=0.15 w=1 nf=1 m=1
M4 Vout F VDD VDD pch l=0.15 w=1 nf=1 m=1
.ends dut
