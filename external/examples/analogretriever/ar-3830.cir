* official Analog Canvas netlist; PDK X cards rewritten by convert.py

.subckt dut VDD VSS vo
.model NJF NJF(VTO=-2 BETA=1e-3 LAMBDA=0.01)
CC net4 net1 1p
CC2 net2 vo 1p
CS net0 VSS 1p
J1 net2 net1 net3 NJF m=1
RD VDD net2 8kΩ
RG net1 VSS 50kΩ
RL vo VSS 4kΩ
RS1 net3 net0 100Ω
RS2 net0 VSS 250Ω
Vi net4 VSS DC 1
.ends dut
