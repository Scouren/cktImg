* official Analog Canvas netlist; PDK X cards rewritten by convert.py

.subckt dut VSS V1 V2 S1 S2
.model ideal_switch SW(RON=1 ROFF=1e12 VT=0.5 VH=0)
C1 V2 VSS 1p
C2 net0 VSS 1p
S1 V1 net0 S1 VSS ideal_switch
S2 net0 V2 S2 VSS ideal_switch
.ends dut
