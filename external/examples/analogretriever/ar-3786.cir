* official Analog Canvas netlist; PDK X cards rewritten by convert.py

.subckt dut VSS Vgs Vo
Gm VSS Vo Vgs Vo 1m
RG Vgs VSS 1k
RL Vo VSS 1k
ro VSS Vo 1k
RS Vo VSS 1k
Vi Vgs VSS DC 1
.ends dut
