* official Analog Canvas netlist; PDK X cards rewritten by convert.py
.model nch nmos

.subckt dut VDD VSS Iout
It net1 VSS DC 1m
M1 net0 VSS net2 VSS nch l=0.15 w=1 nf=1 m=1
M2 Iout net0 VSS VSS nch l=0.15 w=1 nf=1 m=1
R1 net2 net1 1k
R2 net2 VSS 1k
RD1 VDD net0 1k
RD2 VDD net1 1k
.ends dut
