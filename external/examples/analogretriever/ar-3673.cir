* official Analog Canvas netlist; PDK X cards rewritten by convert.py

.subckt dut VDD VSS V1 V2 V3 V4 VO
.model DIODE D(IS=1e-14 N=1)
D1 net0 V1 DIODE
D2 net0 V2 DIODE
D3 net1 V3 DIODE
D4 net1 V4 DIODE
D5 net0 VO DIODE
D6 net1 VO DIODE
R1 VDD net0 10kΩ
R2 VDD net1 10kΩ
R3 VO VSS 10kΩ
.ends dut
