* official Analog Canvas netlist; PDK X cards rewritten by convert.py
.model qnpn npn
.model qpnp pnp

.subckt dut VCC VSS Icopy
IREF VCC net0 DC 1m
Q1 net0 net0 VSS VSS qnpn m=1
Q2 net1 net0 VSS VSS qnpn m=1
Q3 net1 net1 VCC qpnp m=1
Q4 Icopy net1 VCC qpnp m=1
.ends dut
