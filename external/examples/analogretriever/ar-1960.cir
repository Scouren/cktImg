* official Analog Canvas netlist; PDK X cards rewritten by convert.py

.subckt dut VSS vin vout
G2 vout VSS net0 VSS 1m
G3 net0 vout vin vout 1m
RL vout VSS 1k
Rpi2 net0 VSS 1k
Rpi3 vout vin 1k
.ends dut
