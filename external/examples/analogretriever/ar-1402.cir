* official Analog Canvas netlist; PDK X cards rewritten by convert.py
.model nch nmos
.model pch pmos

.subckt dut VDD VSS Vin1 Vin2 Vout1 Vout2
IREF VDD net0 DC 0.3mA
M1 VDD Vin1 Vout1 VSS nch l=0.15 w=1 nf=1 m=1
M11 Vout1 net0 VSS VSS nch l=0.15 w=1 nf=1 m=1
M12 Vout2 net0 VSS VSS nch l=0.15 w=1 nf=1 m=1
M2 Vout2 Vin2 VDD VDD pch l=0.15 w=1 nf=1 m=1
MREF net0 net0 VSS VSS nch l=0.15 w=1 nf=1 m=1
.ends dut
