* official Analog Canvas netlist; PDK X cards rewritten by convert.py

.subckt opamp_differential VDD VSS VIP VIN VOP VON params: gain=1e6 vocm=0
VCM ncm 0 DC {vocm}
EPLUS VOP ncm VIP VIN {gain/2}
EMINUS VON ncm VIN VIP {gain/2}
.ends opamp_differential

.subckt dut VSS VIN+ VIN- VOUT+ VOUT-
CI1 VOUT+ net1 1p
CI2 VOUT- net0 1p
CINB1 VSS VOUT+ 1p
CINB2 VOUT- VSS 1p
RI1 VIN+ net1 1k
RI2 VIN- net0 1k
X1 0 VSS net1 net0 VOUT- VOUT+ opamp_differential gain=1e6 vocm=0
.ends dut
