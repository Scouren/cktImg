* official Analog Canvas netlist; PDK X cards rewritten by convert.py
.model qnpn npn

.subckt dut VCC VSS
Q1 net1 net0 VSS VSS qnpn m=1
R1 VCC net1 1kΩ
R2 net0 net1 10kΩ
R3 net0 VSS 40kΩ
.ends dut
