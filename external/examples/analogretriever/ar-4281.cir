* official Analog Canvas netlist; PDK X cards rewritten by convert.py
.model pch pmos

.subckt dut VDD VSS Iout
M1 net0 net0 VDD VDD pch l=0.15 w=1 nf=1 m=1
M2 Iout net0 VDD VDD pch l=0.15 w=1 nf=1 m=1
M3 net1 net1 net0 VDD pch l=0.15 w=1 nf=1 m=1
M4 VSS VSS net1 VDD pch l=0.15 w=1 nf=1 m=1
.ends dut
