* official Analog Canvas netlist; PDK X cards rewritten by convert.py

.subckt dut VSS Vo
Cmu net0 Vo 1p
Cpi net0 VSS 1p
G1 Vo VSS net0 VSS 1m
Is VSS net0 DC 1m
RB net0 VSS 1k
RC Vo VSS 1k
RL Vo VSS 1k
rpi net0 VSS 1k
.ends dut
