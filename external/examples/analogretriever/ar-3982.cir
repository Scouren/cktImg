* official Analog Canvas netlist; PDK X cards rewritten by convert.py
.model qnpn npn

.subckt dut VCC VSS vo
CB VSS net4 1p
CC1 net5 net2 1p
CC2 net0 vo 1p
CE net1 VSS 1p
Q1 net3 net2 net1 VSS qnpn m=1
Q2 net0 net4 net3 VSS qnpn m=1
R1 VCC net4 1k
R2 net4 net2 1k
R3 net2 VSS 1k
RC VCC net0 1k
RE net1 VSS 1k
RL vo VSS 1k
V1 net5 VSS DC 1
.ends dut
