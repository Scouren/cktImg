* official Analog Canvas netlist; PDK X cards rewritten by convert.py

.subckt dut VSS v2
G2 net2 VSS v2 VSS 1m
G3 net1 net0 net2 net0 1m
R1 net2 VSS 5kΩ
R2 net0 VSS 88Ω
RC net1 VSS 1k
Rpi3 net2 net0 1k
.ends dut
