* official Analog Canvas netlist; PDK X cards rewritten by convert.py
.model nch nmos

.subckt dut VDD VSS vo
CC net1 net0 1p
Is VSS net1 DC 1m
M1 vo net0 VSS VSS nch l=0.15 w=1 nf=1 m=1
RD VDD vo 5kΩ
RF net0 vo 25kΩ
.ends dut
