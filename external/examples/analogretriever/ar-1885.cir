* official Analog Canvas netlist; PDK X cards rewritten by convert.py
.model nch nmos
.model pch pmos

.subckt dut VDD VSS Vout
I1 net0 VSS DC 1mA
Iin VSS net1 DC 1m
M1 Vout net1 VSS VSS nch l=0.15 w=1 nf=1 m=1
M2 Vout net0 VDD VDD pch l=0.15 w=1 nf=1 m=1
M3 net0 net0 VDD VDD pch l=0.15 w=1 nf=1 m=1
RF net1 Vout 1k
.ends dut
