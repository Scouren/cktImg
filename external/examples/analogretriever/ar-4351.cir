* official Analog Canvas netlist; PDK X cards rewritten by convert.py
.model qnpn npn

.subckt dut VCC VEE v1 v2 vO1 vO2
IQ net0 VEE DC 1m
Q1 vO1 v1 net0 VEE qnpn m=1
Q2 vO2 v2 net0 VEE qnpn m=1
RC1 VCC vO1 1k
RC2 VCC vO2 1k
RL vO1 vO2 1k
.ends dut
