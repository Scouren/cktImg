* official Analog Canvas netlist; PDK X cards rewritten by convert.py

.subckt dut VSS vin
G1 VSS vout vin vout 1m
R1 vin vout 1k
RB vin VSS 1k
RE vout VSS 1k
RL vout VSS 1k
ro VSS vout 1k
RT net0 vin 1k
vt net0 VSS DC 1
.ends dut
