* official Analog Canvas netlist; PDK X cards rewritten by convert.py
.model qnpn npn
.model qpnp pnp

.subckt dut VCC VEE VSS Vb1 Vb2 Vin Vout
.model DIODE D(IS=1e-14 N=1)
D1 net0 Vin DIODE
D2 Vin net1 DIODE
Q1 VCC net0 Vout VSS qnpn m=1
Q2 VEE net1 Vout qpnp m=1
Q3 net0 Vb1 VCC qpnp m=1
Q4 net1 Vb2 VEE VSS qnpn m=1
RL Vout VSS 1k
.ends dut
