* official Analog Canvas netlist; PDK X cards rewritten by convert.py
.model nch nmos
.model qnpn npn
.model qpnp pnp

.subckt dut VCC VEE VSS vIN1 vIN2 vOUT
M3 net1 vIN1 net2 net2 nch l=0.15 w=1 nf=1 m=1
M4 vOUT vIN2 net2 net2 nch l=0.15 w=1 nf=1 m=1
Q1 net1 net1 VCC qpnp m=1
Q2 vOUT net1 VCC qpnp m=1
Q5 net0 net0 VEE VEE qnpn m=1
Q6 net2 net0 VEE VEE qnpn m=1
R VSS net0 1k
.ends dut
