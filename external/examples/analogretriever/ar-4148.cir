* official Analog Canvas netlist; PDK X cards rewritten by convert.py
.model qnpn npn

.subckt dut VCC VSS vo
CC1 net3 net0 1p
CC2 net1 vo 1p
CE net2 VSS 1p
L VCC net1 1n
Q1 net1 net0 net2 VSS qnpn m=1
R1 VCC net0 1k
R2 net0 VSS 1k
RE net2 VSS 1k
RL vo VSS 1k
Vi net3 VSS DC 1
.ends dut
