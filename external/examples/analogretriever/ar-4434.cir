* official Analog Canvas netlist; PDK X cards rewritten by convert.py
.model nch nmos
.model qpnp pnp

.subckt dut VDD VSS vo
VB1 net0 VSS DC 1
M1 net1 net3 vo VSS nch l=0.15 w=1 nf=1 m=1
Q2 vo net1 net2 qpnp m=1
RD1 VDD net1 1k
RE2 VDD net2 1k
RL vo VSS 1k
vi net3 net0 DC 1
.ends dut
