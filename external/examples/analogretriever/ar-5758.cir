* official Analog Canvas netlist; PDK X cards rewritten by convert.py
.model qpnp pnp

.subckt dut VCC VBB VEE V4 Vout
I5 VCC net0 DC 1m
Q1 Vout V4 net0 qpnp m=1
R1 VBB V4 15kΩ
R2 Vout VEE 20kΩ
.ends dut
