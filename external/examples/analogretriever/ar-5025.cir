* official Analog Canvas netlist; PDK X cards rewritten by convert.py
.model nch nmos

.subckt dut VDD VSS
Cin net3 net1 1p
Cout net4 net0 1p
M1 net4 net1 VSS VSS nch l=0.15 w=1 nf=1 m=1
R1 VDD net1 1k
R2 net1 VSS 1k
RD VDD net4 1k
RG net2 net3 1k
RL net0 VSS 1k
vg net2 VSS SIN(0 1 1k 0 0 0)
.ends dut
