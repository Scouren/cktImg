* official Analog Canvas netlist; PDK X cards rewritten by convert.py
.model qpnp pnp

.subckt dut VCC VSS
Q1 net2 net0 net1 qpnp m=1
R1 VCC net0 10kΩ
R2 net0 VSS 2.2kΩ
RC VCC net2 3.6kΩ
RE net1 VSS 1kΩ
.ends dut
