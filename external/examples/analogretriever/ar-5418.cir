* official Analog Canvas netlist; PDK X cards rewritten by convert.py

.subckt dut P N
L1 P net1 4mH
L2 net1 net2 2mH
L3 net1 net0 1mH
L4 net0 N 1mH
L5 net2 N 2mH
.ends dut
