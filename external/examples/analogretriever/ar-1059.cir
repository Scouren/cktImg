* official Analog Canvas netlist; PDK X cards rewritten by convert.py
.model qnpn npn

.subckt dut VCC VSS Vout1 Vout2 Vb Vin
Q1 Vout1 Vb Vin VSS qnpn m=1
Q2 Vout2 Vb Vin VSS qnpn m=1
RC1 VCC Vout1 1k
RC2 VCC Vout2 1k
.ends dut
