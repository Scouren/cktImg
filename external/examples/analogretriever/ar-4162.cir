* official Analog Canvas netlist; PDK X cards rewritten by convert.py
.model nch nmos

.subckt dut VDD VSS GND vI vO
M1 VDD vI vO VSS nch l=0.15 w=1 nf=1 m=1
M2 vO net0 VSS VSS nch l=0.15 w=1 nf=1 m=1
M3 net0 net0 VSS VSS nch l=0.15 w=1 nf=1 m=1
R GND net0 1kΩ
RL vO GND 1kΩ
.ends dut
