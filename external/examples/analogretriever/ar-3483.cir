* official Analog Canvas netlist; PDK X cards rewritten by convert.py
.model qnpn npn

.subckt dut VEE VSS Iout
Q1 net1 net1 net2 VEE qnpn m=1
Q2 Iout net1 net0 VEE qnpn m=1
R1 VSS net1 10kΩ
R2 net0 VEE 1k
R3 net2 VEE 1.4kΩ
.ends dut
