* official Analog Canvas netlist; PDK X cards rewritten by convert.py
.model nch nmos

.subckt dut VDD VSS vIN vOUT
C1 vIN net0 1p
CO net3 vOUT 1p
CS net2 VSS 1p
M1 net3 net0 net2 net2 nch l=0.15 w=1 nf=1 m=1
RD VDD net3 1k
RG1 VDD net0 1k
RG2 net0 VSS 1k
RL vOUT VSS 1k
RS net2 VSS 1k
RT net1 vIN 1k
vT net1 VSS DC 1
.ends dut
