* official Analog Canvas netlist; PDK X cards rewritten by convert.py

.subckt dut Vout+ Vout-
.model DIODE D(IS=1e-14 N=1)
D1 net0 Vout- DIODE
D2 Vout+ Vout- DIODE
Iin Vout- Vout+ DC 1m
R1 Vout+ net0 1k
.ends dut
