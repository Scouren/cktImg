* official Analog Canvas netlist; PDK X cards rewritten by convert.py
.model nch nmos
.model pch pmos

.subckt dut VDD VSS Iout1 Iout2 Iout3 Iout4
M1 net1 net1 VDD VDD pch l=0.15 w=1 nf=1 m=1
M2 Iout1 net1 VDD VDD pch l=0.15 w=1 nf=1 m=1
M3 Iout2 net1 VDD VDD pch l=0.15 w=1 nf=1 m=1
M4 net0 net0 VSS VSS nch l=0.15 w=1 nf=1 m=1
M5 Iout3 net0 VSS VSS nch l=0.15 w=1 nf=1 m=1
M6 Iout4 net0 VSS VSS nch l=0.15 w=1 nf=1 m=1
R net1 net0 1k
.ends dut
