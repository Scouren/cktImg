* official Analog Canvas netlist; PDK X cards rewritten by convert.py

.subckt dut VSS G
Cgs G VSS 1p
Gm VSS VSS G VSS 1m
Id VSS VSS DC 1m
Ig VSS G DC 1m
Rd VSS VSS 1k
.ends dut
