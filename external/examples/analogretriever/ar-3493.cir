* official Analog Canvas netlist; PDK X cards rewritten by convert.py
.model pch pmos
.model qnpn npn

.subckt dut VCC VEE VSS Vin1 Vin2 Output
IBIAS net1 VEE DC 1m
M1 net0 net2 VCC VCC pch l=0.15 w=1 nf=1 m=1
M2 Output net2 VCC VCC pch l=0.15 w=1 nf=1 m=1
Q1 net0 Vin1 net1 VEE qnpn m=1
Q2 Output Vin2 net1 VEE qnpn m=1
VREF net2 VSS DC 1
.ends dut
