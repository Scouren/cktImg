* official Analog Canvas netlist; PDK X cards rewritten by convert.py
.model nch nmos

.subckt dut VDD VSS Vout
C1 net0 net2 1p
CS net1 VSS 1p
M1 Vout net2 net1 VSS nch l=0.15 w=1 nf=1 m=1
R1 VDD net2 1k
RD VDD Vout 1k
RS net1 VSS 1k
Vin net0 VSS DC 1
.ends dut
