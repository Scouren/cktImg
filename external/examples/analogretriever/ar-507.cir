* official Analog Canvas netlist; PDK X cards rewritten by convert.py
.model qnpn npn

.subckt dut VEE VSS Iout1 Iout2
IEE net2 VEE DC 1m
Q1 Iout1 net1 net2 VEE qnpn m=1
Q2 Iout2 net3 net2 VEE qnpn m=1
RS1 net0 net1 1k
RS2 net3 VSS 1k
Vs net0 VSS DC 1
.ends dut
