* official Analog Canvas netlist; PDK X cards rewritten by convert.py
.model qnpn npn

.subckt dut VSS vo
Q1 vx net1 VSS VSS qnpn m=1
Q2 vo VSS vx VSS qnpn m=1
RL vo VSS 1k
RS net0 net1 1k
Vs net0 VSS DC 1
.ends dut
