* official Analog Canvas netlist; PDK X cards rewritten by convert.py
.model nch nmos

.subckt dut VDD VSS GND vI1 vO1 vI2 vO2
IBIAS net0 VSS DC 1m
M1 VDD vI1 vO1 vO1 nch l=0.15 w=1 nf=1 m=1
M2 VDD vI2 vO2 vO2 nch l=0.15 w=1 nf=1 m=1
RL1 vO1 GND 1k
RL2 vO2 GND 1k
RS1 vO1 net0 1k
RS2 vO2 net0 1k
.ends dut
