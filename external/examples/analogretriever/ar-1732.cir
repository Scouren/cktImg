* official Analog Canvas netlist; PDK X cards rewritten by convert.py
.model qnpn npn

.subckt dut VCC VSS Vin Vout
CF net0 Vout 1p
Q1 Vout net0 VSS VSS qnpn m=1
RB Vin net0 1k
RC VCC Vout 1k
.ends dut
