* official Analog Canvas netlist; PDK X cards rewritten by convert.py
.model qnpn npn

.subckt dut VCC VSS Vout
IEE P VSS DC 1m
Q1 Vout net0 P VSS qnpn m=1
Q2 Vout net0 P VSS qnpn m=1
RC VCC Vout 1k
REE P VSS 1k
VCM net0 VSS DC 1
.ends dut
