* official Analog Canvas netlist; PDK X cards rewritten by convert.py
.model qnpn npn

.subckt dut VCC VEE VSS vo
CC1 net1 net4 1p
CC2 net0 vo 1p
CE net2 VSS 1p
Q1 net0 net4 net2 VEE qnpn m=1
R1 VCC net4 20kΩ
R2 net4 VEE 20kΩ
RC VCC net0 2.3kΩ
RE net2 VEE 5kΩ
RL vo VSS 5kΩ
RS net3 net1 1kΩ
vi net3 VSS DC 1
.ends dut
