* official Analog Canvas netlist; PDK X cards rewritten by convert.py
.model qnpn npn

.subckt dut VCC VSS Vout1 Vout2
Q1 Vout1 VSS net0 VSS qnpn m=1
Q2 net0 net0 VSS VSS qnpn m=1
Q3 Vout2 VSS net1 VSS qnpn m=1
Q4 VCC net1 VSS VSS qnpn m=1
.ends dut
