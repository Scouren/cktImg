* official Analog Canvas netlist; PDK X cards rewritten by convert.py
.model nch nmos
.model pch pmos

.subckt dut VDD VSS Vin1 Vin2 Vout1 Vout2
M1 Vout1 Vin1 net2 VSS nch l=0.15 w=1 nf=1 m=1
M2 Vout2 Vin2 net2 VSS nch l=0.15 w=1 nf=1 m=1
M3 Vout1 net0 VDD VDD pch l=0.15 w=1 nf=1 m=1
M4 Vout2 net0 VDD VDD pch l=0.15 w=1 nf=1 m=1
M5 net2 net1 VSS VSS nch l=0.15 w=1 nf=1 m=1
M6 net1 net1 VSS VSS nch l=0.15 w=1 nf=1 m=1
M7 net0 net0 VDD VDD pch l=0.15 w=1 nf=1 m=1
R1 net0 net1 1kΩ
.ends dut
