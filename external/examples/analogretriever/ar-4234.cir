* official Analog Canvas netlist; PDK X cards rewritten by convert.py

.subckt dut VSS
G2 net0 net1 VSS net1 1m
RE net1 VSS 1k
Ro2 net0 net1 1k
Rpi2 VSS net1 1k
Vx net0 VSS DC 1
.ends dut
