* official Analog Canvas netlist; PDK X cards rewritten by convert.py
.model nch nmos
.model pch pmos

.subckt dut VDD VSS GND vI vO
IBias VDD net0 DC 1m
M1 VDD net0 vO VSS nch l=0.15 w=1 nf=1 m=1
M2 VSS vI vO VDD pch l=0.15 w=1 nf=1 m=1
M3 net0 net0 net1 VSS nch l=0.15 w=1 nf=1 m=1
M4 vI vI net1 VDD pch l=0.15 w=1 nf=1 m=1
RL vO GND 500Ω
.ends dut
