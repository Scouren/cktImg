* official Analog Canvas netlist; PDK X cards rewritten by convert.py
.model nch nmos
.model pch pmos

.subckt dut VDD VSS phi A B C D Y
CL Y VSS 1p
MA Y A net3 VSS nch l=0.15 w=1 nf=1 m=1
MB net3 B net2 VSS nch l=0.15 w=1 nf=1 m=1
MC net2 C net1 VSS nch l=0.15 w=1 nf=1 m=1
MD net1 D net0 VSS nch l=0.15 w=1 nf=1 m=1
Me net0 phi VSS VSS nch l=0.15 w=1 nf=1 m=1
Mp Y phi VDD VDD pch l=0.15 w=1 nf=1 m=1
.ends dut
