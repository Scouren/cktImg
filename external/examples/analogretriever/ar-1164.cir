* official Analog Canvas netlist; PDK X cards rewritten by convert.py
.model nch nmos

.subckt dut VSS vin vout
G2 vout VSS VSS VSS 1m
M1 vout vin VSS VSS nch l=0.15 w=1 nf=1 m=1
RO1 vout VSS 1k
RO2 VSS vout 1k
.ends dut
