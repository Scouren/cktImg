* official Analog Canvas netlist; PDK X cards rewritten by convert.py
.model qnpn npn

.subckt dut VCC VSS vin vout
C1 net1 VSS 1p
I1 net0 VSS DC 1m
Q1 vout net2 net0 VSS qnpn m=1
R1 vout net1 1k
R2 net1 net0 1k
RB vin net2 1k
RC VCC vout 1k
.ends dut
