* official Analog Canvas netlist; PDK X cards rewritten by convert.py

.subckt dut VSS Vo
G1 Vo VSS net0 VSS 18.9mS
RC Vo VSS 1k
RF net0 Vo 82kΩ
Rpi net0 VSS 5.28kΩ
Vx net0 VSS DC 1
.ends dut
