* official Analog Canvas netlist; PDK X cards rewritten by convert.py
.model qnpn npn

.subckt dut VCC VEE VSS vI vO
Q1 VCC vI vO VEE qnpn m=1
Q2 vO net0 VEE VEE qnpn m=1
Q3 net0 net0 VEE VEE qnpn m=1
R VSS net0 1kΩ
RL vO VSS 1kΩ
.ends dut
