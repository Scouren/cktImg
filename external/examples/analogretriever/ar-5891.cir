* official Analog Canvas netlist; PDK X cards rewritten by convert.py
.model qnpn npn

.subckt dut VCC VEE VSS vo
C1 net5 net4 1p
C2 net1 vo 1p
C3 net3 net0 1p
I1 net3 VEE DC 0.1mA
Q1 net1 net4 net3 VEE qnpn m=1
R1 VCC net1 20kΩ
R2 vo VSS 20kΩ
R3 net4 VSS 200kΩ
R4 net2 net5 20kΩ
R5 net0 VSS 250Ω
Vsig net2 VSS DC 1
.ends dut
