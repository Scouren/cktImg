* official Analog Canvas netlist; PDK X cards rewritten by convert.py
.model nch nmos

.subckt dut VDD VSS vIN vOUT
CG net3 VSS 1p
CI vIN net5 1p
CO net4 vOUT 1p
CS net2 VSS 1p
M1 net0 net5 net2 VSS nch l=0.15 w=1 nf=1 m=1
M2 net4 net3 net0 VSS nch l=0.15 w=1 nf=1 m=1
RD VDD net4 1k
RG1 VDD net3 1k
RG2 net3 net5 1k
RG3 net5 VSS 1k
RS net2 VSS 1k
RT net1 vIN 1k
VT net1 VSS DC 1
.ends dut
