* official Analog Canvas netlist; PDK X cards rewritten by convert.py
.model qnpn npn

.subckt dut VCC VSS vin vout1 vout2
C1 vin net0 1p
C2 net2 vout1 1p
C3 net1 vout2 1p
Q1 net2 net0 net1 VSS qnpn m=1
R1 VCC net0 4.7kΩ
R2 net0 VSS 2kΩ
RC VCC net2 1kΩ
RE net1 VSS 1kΩ
.ends dut
