* official Analog Canvas netlist; PDK X cards rewritten by convert.py
.model nch nmos
.model pch pmos

.subckt dut VDD VSS VB1 VB2 VCM VB3 Vi1 Vi2 Vo2 Vo1
C1 Vo2 net0 1p
C2 net3 Vo1 1p
M1 net0 Vi1 net2 VDD pch l=0.15 w=1 nf=1 m=1
M10 Vo2 VB1 VDD VDD pch l=0.15 w=1 nf=1 m=1
M2 net3 Vi2 net2 VDD pch l=0.15 w=1 nf=1 m=1
M21 Vcmc Vo1 net4 VSS nch l=0.15 w=1 nf=1 m=1
M22 VDD VCM net4 VSS nch l=0.15 w=1 nf=1 m=1
M23 VDD VCM net1 VSS nch l=0.15 w=1 nf=1 m=1
M24 Vcmc Vo2 net1 VSS nch l=0.15 w=1 nf=1 m=1
M25 Vcmc Vcmc VDD VDD pch l=0.15 w=1 nf=1 m=1
M26 net4 VB3 VSS VSS nch l=0.15 w=1 nf=1 m=1
M27 net1 VB3 VSS VSS nch l=0.15 w=1 nf=1 m=1
M3 net0 VB2 VSS VSS nch l=0.15 w=1 nf=1 m=1
M4 net3 VB2 VSS VSS nch l=0.15 w=1 nf=1 m=1
M5 net2 Vcmc VDD VDD pch l=0.15 w=1 nf=1 m=1
M6 Vo1 net3 VSS VSS nch l=0.15 w=1 nf=1 m=1
M7 Vo1 VB1 VDD VDD pch l=0.15 w=1 nf=1 m=1
M9 Vo2 net0 VSS VSS nch l=0.15 w=1 nf=1 m=1
.ends dut
