* official Analog Canvas netlist; PDK X cards rewritten by convert.py
.model qnpn npn
.model qpnp pnp

.subckt opamp VDD VSS VIP VIN VOUT params: gain=1e6 vhigh=5 vlow=-5
Blin nlin 0 V={gain*(V(VIP)-V(VIN))}
Bcore VOUT 0 V={0.5*(vhigh+(0.5*(vlow+V(nlin)+sqrt((V(nlin)-vlow)*(V(nlin)-vlow)+(1e-4*(vhigh-vlow))*(1e-4*(vhigh-vlow))+1e-12)))-sqrt((vhigh-(0.5*(vlow+V(nlin)+sqrt((V(nlin)-vlow)*(V(nlin)-vlow)+(1e-4*(vhigh-vlow))*(1e-4*(vhigh-vlow))+1e-12))))*(vhigh-(0.5*(vlow+V(nlin)+sqrt((V(nlin)-vlow)*(V(nlin)-vlow)+(1e-4*(vhigh-vlow))*(1e-4*(vhigh-vlow))+1e-12))))+(1e-4*(vhigh-vlow))*(1e-4*(vhigh-vlow))+1e-12))}
.ends opamp

.subckt dut VCC VEE VSS vI vO
Q1 VEE net0 net1 qpnp m=1
Q2 VCC net0 net3 VEE qnpn m=1
Q3 VCC net1 vO VEE qnpn m=1
Q4 VEE net3 vO qpnp m=1
R1 VCC net1 1k
R2 net3 VEE 1k
RA vO net2 1k
RB VSS net2 1k
RL vO VSS 1k
X1 0 VSS vI net2 net0 opamp gain=1e6
.ends dut
