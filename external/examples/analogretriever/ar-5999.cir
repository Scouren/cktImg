* official Analog Canvas netlist; PDK X cards rewritten by convert.py
.model qnpn npn
.model qpnp pnp

.subckt dut VCC VSS vo
C1 net3 VSS 1p
I1 VCC vo DC 0.5mA
Q1 VSS net2 net0 qpnp m=1
Q2 vo net3 net0 VSS qnpn m=1
R1 net1 net2 10kΩ
R2 vo net3 10kΩ
vsig net1 VSS DC 1
.ends dut
