* official Analog Canvas netlist; PDK X cards rewritten by convert.py
.model nch nmos

.subckt dut VDD VSS vo
CC1 net2 net0 1p
CC2 net1 vo 1p
M1 VDD net0 net1 VSS nch l=0.15 w=1 nf=1 m=1
RG net0 VSS 1k
RL vo VSS 1k
RS net1 VSS 1k
Vi net2 VSS DC 1
.ends dut
