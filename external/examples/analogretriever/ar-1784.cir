* official Analog Canvas netlist; PDK X cards rewritten by convert.py
.model nch nmos

.subckt dut VDD VSS Vout
Iin VSS net1 DC 1m
M1 net0 net1 VSS VSS nch l=0.15 w=1 nf=1 m=1
M2 Vout net0 VSS VSS nch l=0.15 w=1 nf=1 m=1
MF net1 Vout VSS VSS nch l=0.15 w=1 nf=1 m=1
RD1 VDD net0 1k
RD2 VDD Vout 1k
.ends dut
