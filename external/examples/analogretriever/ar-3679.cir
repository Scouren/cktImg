* official Analog Canvas netlist; PDK X cards rewritten by convert.py
.model nch nmos

.subckt dut VDD VSS
M1 net1 net0 VSS VSS nch l=0.15 w=1 nf=1 m=1
R1 VDD net0 60kΩ
R2 net0 VSS 30kΩ
RD VDD net1 4kΩ
.ends dut
