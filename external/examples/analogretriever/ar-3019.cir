* official Analog Canvas netlist; PDK X cards rewritten by convert.py
.model nch nmos

.subckt dut VSS Vin1 Vin2 Vb X Y
C1 Vin1 net4 1p
C2 Vin2 net2 1p
I1 net1 VSS DC 1m
M1 net0 net3 net1 VSS nch l=0.15 w=1 nf=1 m=1
M2 net5 net6 net1 VSS nch l=0.15 w=1 nf=1 m=1
M3 X Vb net0 VSS nch l=0.15 w=1 nf=1 m=1
M4 Y Vb net5 VSS nch l=0.15 w=1 nf=1 m=1
R1 net4 net3 1k
R2 net2 net6 1k
R3 X net3 1k
R4 Y net6 1k
.ends dut
