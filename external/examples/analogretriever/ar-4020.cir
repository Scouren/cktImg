* official Analog Canvas netlist; PDK X cards rewritten by convert.py
.model qnpn npn

.subckt dut VCC VEE VSS vo
CC1 net2 net0 1p
CC2 net1 vo 1p
IQ net0 VEE DC 1mA
Q1 net1 VSS net0 VEE qnpn m=1
RC net1 VCC 2kΩ
RL vo VSS 10kΩ
vs net2 VSS DC 1
.ends dut
