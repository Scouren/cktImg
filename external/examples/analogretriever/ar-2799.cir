* official Analog Canvas netlist; PDK X cards rewritten by convert.py

.subckt dut VSS Vout
G1 Vout net1 net0 net1 1m
RD Vout VSS 1k
RG VSS net0 1k
RS VSS net1 1k
VX Vout net0 DC 1
.ends dut
