* official Analog Canvas netlist; PDK X cards rewritten by convert.py

.subckt dut VSS vbe vo
Ioc vo VSS DC 1m
RC vo VSS 1k
RF vbe vo 1k
Ro vo VSS 1k
Rpi vbe VSS 1k
.ends dut
