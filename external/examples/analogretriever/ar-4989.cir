* official Analog Canvas netlist; PDK X cards rewritten by convert.py
.model nch nmos

.subckt dut VSS EN Vout
VB1 net0 VSS DC 1
VB2 net1 VSS DC 1
M1 net2 EN VSS VSS nch l=0.15 w=1 nf=1 m=1
M2 net0 net2 Vout Vout nch l=0.15 w=1 nf=1 m=1
R1 net1 net2 1k
RL Vout VSS 1k
.ends dut
