* official Analog Canvas netlist; PDK X cards rewritten by convert.py
.model qnpn npn

.subckt dut VCC VSS Vin Q1_E Q2_E
Q1 net1 Vin Q1_E VSS qnpn m=1
Q2 net0 net1 Q2_E VSS qnpn m=1
R1 VCC net1 1k
R2 VCC net0 1k
.ends dut
