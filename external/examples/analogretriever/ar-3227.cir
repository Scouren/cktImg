* official Analog Canvas netlist; PDK X cards rewritten by convert.py

.subckt dut VSS Vout
CH net0 Vout 1p
Cin X VSS 1p
CL Vout VSS 1p
Gm Vout VSS X VSS 1m
RO Vout VSS 1k
VS net0 X DC 1
.ends dut
