* official Analog Canvas netlist; PDK X cards rewritten by convert.py
.model qpnp pnp

.subckt dut VCC VEE VSS vo
CC1 net0 net2 1p
CC2 net1 vo 1p
CE net3 VSS 1p
IEo VCC net3 DC 0.80mA
Q1 net1 net2 net3 qpnp m=1
RB net2 VSS 1k
RC net1 VEE 1k
RL vo VSS 4kΩ
vs net0 VSS DC 1
.ends dut
