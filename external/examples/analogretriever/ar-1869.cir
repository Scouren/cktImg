* official Analog Canvas netlist; PDK X cards rewritten by convert.py
.model nch nmos

.subckt dut VDD VSS Vb vout
I1 VDD vout DC 1m
iin VSS net2 DC 1m
M1 net1 Vb net2 VSS nch l=0.15 w=1 nf=1 m=1
M2 vout net1 VSS VSS nch l=0.15 w=1 nf=1 m=1
R1 vout net0 1k
R2 net0 VSS 1k
RD1 VDD net1 1k
RF net2 net0 1k
.ends dut
