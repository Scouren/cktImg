* official Analog Canvas netlist; PDK X cards rewritten by convert.py
.model qnpn npn

.subckt dut VCC VSS Vin Vout
Q1 Vout Vin net1 VSS qnpn m=1
Q2 VCC VCC net0 VSS qnpn m=1
R1 net0 Vout 1k
RE net1 VSS 1k
.ends dut
