* official Analog Canvas netlist; PDK X cards rewritten by convert.py

.subckt opamp_differential VDD VSS VIP VIN VOP VON params: gain=1e6 vocm=0
VCM ncm 0 DC {vocm}
EPLUS VOP ncm VIP VIN {gain/2}
EMINUS VON ncm VIN VIP {gain/2}
.ends opamp_differential

.subckt dut Vin1 Vout1 Vin2 Vout2
C1 Vin1 X 1p
C2 X Vout1 1p
C3 Vin2 Y 1p
C4 Y Vout2 1p
R1 Y Vout2 1k
RF X Vout1 1k
X1 0 0 X Y Vout2 Vout1 opamp_differential gain=1e6 vocm=0
.ends dut
