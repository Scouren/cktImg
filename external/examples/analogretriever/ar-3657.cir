* official Analog Canvas netlist; PDK X cards rewritten by convert.py

.subckt dut VDD VSS GND
.model DIODE D(IS=1e-14 N=1)
D1 net0 GND DIODE
D2 net0 net1 DIODE
I VDD net0 DC 5mA
R net1 VSS 1k
.ends dut
