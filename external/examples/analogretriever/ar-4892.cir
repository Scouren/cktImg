* official Analog Canvas netlist; PDK X cards rewritten by convert.py
.model qnpn npn

.subckt dut VCC VSS INPUT Vout
C VCC net2 1p
C1 INPUT net0 1p
C2 net2 Vout 1p
C3 net1 VSS 1p
L VCC net2 1n
Q1 net2 net0 net1 VSS qnpn m=1
R1 VCC net0 1k
R2 net0 VSS 1k
RE net1 VSS 1k
.ends dut
