* official Analog Canvas netlist; PDK X cards rewritten by convert.py

.subckt dut VSS
E1 net3 VSS net1 net2 1
R1 net1 net2 1k
R2 net3 net0 1k
R3 net0 VSS 1k
RE net1 VSS 1k
RF net1 net0 1k
V1 net2 VSS DC 1
.ends dut
