* official Analog Canvas netlist; PDK X cards rewritten by convert.py

.subckt dut VSS
F1 VSS VSS V__icm_sense_197146c984cc0435 1
G1 net3 net2 net0 net2 1m
G2 VSS net2 net1 net2 1m
Rmir VSS __icm_sense_node_197146c984cc0435 1k
V__icm_sense_197146c984cc0435 net3 __icm_sense_node_197146c984cc0435 DC 0
Ro1 net3 net2 1k
Ro2 VSS net2 1k
Rpi1 net0 net2 1k
Rpi2 net1 net2 1k
Rtail net2 VSS 1k
Vi1 net0 VSS DC 1
Vi2 net1 VSS DC 1
.ends dut
