* official Analog Canvas netlist; PDK X cards rewritten by convert.py
.model nch nmos

.subckt dut VDD VSS Vin Vout
C1 Vout VSS 1p
CDB VSS VDD 1p
CGD VDD X 1p
CGS X Vout 1p
I1 Vout VSS DC 1m
M1 VDD X Vout VSS nch l=0.15 w=1 nf=1 m=1
RS Vin X 1k
.ends dut
