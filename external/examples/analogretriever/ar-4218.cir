* official Analog Canvas netlist; PDK X cards rewritten by convert.py
.model qnpn npn

.subckt opamp VDD VSS VIP VIN VOUT params: gain=1e6 vhigh=5 vlow=-5
Blin nlin 0 V={gain*(V(VIP)-V(VIN))}
Bcore VOUT 0 V={0.5*(vhigh+(0.5*(vlow+V(nlin)+sqrt((V(nlin)-vlow)*(V(nlin)-vlow)+(1e-4*(vhigh-vlow))*(1e-4*(vhigh-vlow))+1e-12)))-sqrt((vhigh-(0.5*(vlow+V(nlin)+sqrt((V(nlin)-vlow)*(V(nlin)-vlow)+(1e-4*(vhigh-vlow))*(1e-4*(vhigh-vlow))+1e-12))))*(vhigh-(0.5*(vlow+V(nlin)+sqrt((V(nlin)-vlow)*(V(nlin)-vlow)+(1e-4*(vhigh-vlow))*(1e-4*(vhigh-vlow))+1e-12))))+(1e-4*(vhigh-vlow))*(1e-4*(vhigh-vlow))+1e-12))}
.ends opamp

.subckt dut VSS v1 v2 vO
Q1 net1 VSS net2 VSS qnpn m=1
Q2 net3 VSS net4 VSS qnpn m=1
R1 v1 net1 1k
R2 net3 v2 1k
R3 net4 net0 20kΩ
R4 net0 vO 333kΩ
R5 net2 net5 20kΩ
R6 net5 VSS 333kΩ
X1 0 VSS VSS net1 net2 opamp gain=1e6
X2 0 VSS VSS net3 net4 opamp gain=1e6
X3 0 VSS net5 net0 vO opamp gain=1e6
.ends dut
