* official Analog Canvas netlist; PDK X cards rewritten by convert.py

.subckt dut VSS
G1 net0 S VSS S 1m
Ii VSS S DC 1m
RD net0 VSS 1k
RL net0 VSS 1k
RSi S VSS 1k
.ends dut
