* official Analog Canvas netlist; PDK X cards rewritten by convert.py

.subckt dut A B
R1 A net0 1k
R2 net0 B 1k
R3 A net2 1k
R4 net2 B 1k
R5 A net1 1k
R6 net1 B 1k
.ends dut
