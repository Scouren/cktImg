* official Analog Canvas netlist; PDK X cards rewritten by convert.py

.subckt dut A C
R1 net0 B 1k
R2 B C 1k
R3 B C 1k
R4 A net0 1k
.ends dut
