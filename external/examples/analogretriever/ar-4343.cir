* official Analog Canvas netlist; PDK X cards rewritten by convert.py
.model qnpn npn

.subckt dut VCC VEE VSS vO1 vO2
Q1 vO1 net3 net1 VEE qnpn m=1
Q2 vO2 net4 net1 VEE qnpn m=1
RB1 net2 net3 0.5kΩ
RB2 net0 net4 0.5kΩ
RC1 VCC vO1 50kΩ
RC2 VCC vO2 50kΩ
RE net1 VEE 1k
v1 net2 VSS DC 1
v2 net0 VSS DC 1
.ends dut
