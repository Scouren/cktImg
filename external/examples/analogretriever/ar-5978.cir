* official Analog Canvas netlist; PDK X cards rewritten by convert.py
.model nch nmos
.model pch pmos

.subckt dut VDD VSS vi v3 v2 v1
M1 v1 vi VSS VSS nch l=0.15 w=1 nf=1 m=1
M2 v2 VSS v1 VSS nch l=0.15 w=1 nf=1 m=1
M3 v2 VSS v3 VDD pch l=0.15 w=1 nf=1 m=1
M4 v3 VSS VSS VDD pch l=0.15 w=1 nf=1 m=1
R1 v1 VSS 1k
R2 v2 v1 1k
R3 v3 v2 1k
R4 VSS v3 1k
.ends dut
