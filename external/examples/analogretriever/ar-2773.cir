* official Analog Canvas netlist; PDK X cards rewritten by convert.py
.model nch nmos

.subckt dut VDD VSS Vout Vb
Cin net1 VSS 1p
CL Vout VSS 1p
I1 VDD Vout DC 1m
M1 Vout Vb net1 VSS nch l=0.15 w=1 nf=1 m=1
RO Vout net1 1k
RS net0 net1 1k
Vin net0 VSS DC 1
.ends dut
