* official Analog Canvas netlist; PDK X cards rewritten by convert.py
.model qnpn npn
.model qpnp pnp

.subckt dut VCC VEE v1 v2 vo
IQ VCC net1 DC 1m
Q1 net0 v1 net1 qpnp m=1
Q2 vo1 v2 net1 qpnp m=1
Q3 vo vo1 net2 VEE qnpn m=1
RC1 net0 VEE 1k
RC2 VCC vo 1k
RC3 vo1 VEE 1k
RE net2 VEE 0.5kΩ
.ends dut
