* official Analog Canvas netlist; PDK X cards rewritten by convert.py
.model nch nmos
.model pch pmos

.subckt dut VDD VSS Vout
CA A VSS 1p
CX X VSS 1p
CY Vout VSS 1p
I1 Vout VSS DC 1m
Iin VSS A DC 1m
M1 X A VSS VSS nch l=0.15 w=1 nf=1 m=1
M2 Vout X VDD VDD pch l=0.15 w=1 nf=1 m=1
RD VDD X 1k
RF A Vout 1k
.ends dut
