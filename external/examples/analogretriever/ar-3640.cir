* official Analog Canvas netlist; PDK X cards rewritten by convert.py

.subckt dut VSS vI vO
.model DIODE D(IS=1e-14 N=1)
.model icm_zener_DZ1 D(BV=5)
.model icm_zener_DZ2 D(BV=5)
D1 vO net0 DIODE
D2 net1 vO DIODE
DZ1 net3 net0 icm_zener_DZ1
DZ2 net1 net2 icm_zener_DZ2
R vI vO 0.5kΩ
R1 net3 VSS 1kΩ
R2 net2 VSS 2kΩ
.ends dut
