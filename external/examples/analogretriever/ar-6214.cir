* official Analog Canvas netlist; PDK X cards rewritten by convert.py
.model qnpn npn
.model qpnp pnp

.subckt dut VCC VSS Vin Vout
C net0 Vout 1p
QN VCC Vin net0 VSS qnpn m=1
QP VSS Vin net0 qpnp m=1
RL Vout VSS 1k
.ends dut
