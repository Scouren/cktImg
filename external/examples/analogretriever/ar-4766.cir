* official Analog Canvas netlist; PDK X cards rewritten by convert.py
.model qnpn npn

.subckt dut VCC VSS
Q1 net2 net1 net0 VSS qnpn m=1
RB VCC net1 1k
RC VCC net2 1k
RE net0 VSS 1k
.ends dut
