* official Analog Canvas netlist; PDK X cards rewritten by convert.py
.model qnpn npn
.model qpnp pnp

.subckt dut VCC VEE VSS
I1 VCC net1 DC 1m
Q1 net1 net1 net0 VSS qnpn m=1
Q2 net0 net0 VSS VSS qnpn m=1
Q3 VCC net1 net2 VSS qnpn m=1
Q4 VEE VSS net2 qpnp m=1
.ends dut
