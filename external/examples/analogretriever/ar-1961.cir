* official Analog Canvas netlist; PDK X cards rewritten by convert.py
.model qnpn npn
.model qpnp pnp

.subckt dut VCC VEE VSS Vin Q1_B Vout
Q1 VCC Q1_B Vout VEE qnpn m=1
Q2 Vout net0 VEE VEE qnpn m=1
Q3 net0 Vin Vout qpnp m=1
RL Vout VSS 1k
.ends dut
