* official Analog Canvas netlist; PDK X cards rewritten by convert.py
.model nch nmos
.model pch pmos

.subckt dut VDD VSS Vin1 Vin2 Vb Vout1 Vout2
I1 Vbp VSS DC 1m
ISS net1 VSS DC 1mA
M1 net2 Vin1 net1 VSS nch l=0.15 w=1 nf=1 m=1
M2 net0 Vin2 net1 VSS nch l=0.15 w=1 nf=1 m=1
M3 Vout1 Vb net2 VSS nch l=0.15 w=1 nf=1 m=1
M4 Vout2 Vb net0 VSS nch l=0.15 w=1 nf=1 m=1
M7 Vout1 Vbp VDD VDD pch l=0.15 w=1 nf=1 m=1
M8 Vout2 Vbp VDD VDD pch l=0.15 w=1 nf=1 m=1
M9 Vbp Vbp VDD VDD pch l=0.15 w=1 nf=1 m=1
.ends dut
