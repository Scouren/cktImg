* official Analog Canvas netlist; PDK X cards rewritten by convert.py
.model nch nmos
.model pch pmos

.subckt dut VDD VSS Vin1 Vin2 vo
CC net2 vo 1p
I1 VDD net0 DC 1m
I2 VDD vo DC 1m
M1 net1 Vin1 net0 VDD pch l=0.15 w=1 nf=1 m=1
M2 net2 Vin2 net0 VDD pch l=0.15 w=1 nf=1 m=1
M3 net1 net1 VSS VSS nch l=0.15 w=1 nf=1 m=1
M4 net2 net1 VSS VSS nch l=0.15 w=1 nf=1 m=1
M5 vo net2 VSS VSS nch l=0.15 w=1 nf=1 m=1
.ends dut
