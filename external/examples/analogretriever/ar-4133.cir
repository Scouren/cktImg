* official Analog Canvas netlist; PDK X cards rewritten by convert.py
.model pch pmos

.subckt dut VDD VSS GND vo
CC1 net2 net3 1p
CC2 net4 vo 1p
CG net1 GND 1p
M1 net4 net1 net3 VDD pch l=0.15 w=1 nf=1 m=1
RD net4 VSS 1k
RG net1 GND 1k
Ri net0 net2 1k
RL vo GND 1k
RS net3 VDD 1k
vi net0 GND DC 1
.ends dut
