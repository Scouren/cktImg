* official Analog Canvas netlist; PDK X cards rewritten by convert.py
.model nch nmos
.model pch pmos

.subckt dut VDD VSS GND vo
CC net1 net2 1p
M1 net0 net2 net3 VDD pch l=0.15 w=1 nf=1 m=1
M2 VDD net0 vo VSS nch l=0.15 w=1 nf=1 m=1
R1 VDD net2 1k
R2 net2 VSS 1k
RD1 net0 VSS 1k
RS1 VDD net3 1k
RS2 vo VSS 1k
Vi net1 GND DC 1
.ends dut
