* official Analog Canvas netlist; PDK X cards rewritten by convert.py

.subckt dut VSS Vin
Cgs vg VSS 1p
Gm VSS VSS vg VSS 1m
Ii VSS vg DC 1m
Rd VSS VSS 1k
Vi Vin vg DC 1
.ends dut
