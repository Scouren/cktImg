* official Analog Canvas netlist; PDK X cards rewritten by convert.py
.model qnpn npn
.model qpnp pnp

.subckt dut VCC VSS vin vO
Q1 VCC vin net1 VSS qnpn m=1
Q2 net0 net1 VSS VSS qnpn m=1
Q3 VSS net0 vO qpnp m=1
R1 VCC net0 50kΩ
R2 VCC vO 5kΩ
.ends dut
