* official Analog Canvas netlist; PDK X cards rewritten by convert.py
.model nch nmos
.model pch pmos

.subckt dut VDD VSS
M1 net2 net3 net1 VSS nch l=0.15 w=1 nf=1 m=1
M2 net0 net2 VDD VDD pch l=0.15 w=1 nf=1 m=1
RD VDD net2 1k
RF net1 VSS 1k
RL net0 net1 1k
Vs net3 VSS DC 1
.ends dut
