* official Analog Canvas netlist; PDK X cards rewritten by convert.py
.model qnpn npn

.subckt dut VCC VSS vIN vOUT
QB net1 net0 vIN VSS qnpn m=1
QD vOUT net1 VSS VSS qnpn m=1
RB VCC net0 1k
RC VCC vOUT 1k
.ends dut
