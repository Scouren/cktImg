* official Analog Canvas netlist; PDK X cards rewritten by convert.py
.model qnpn npn

.subckt dut VCC VSS Vin Vout
Q1 net1 net0 VSS VSS qnpn m=1
Q2 Vout net1 VSS VSS qnpn m=1
R1 Vin net0 5kΩ
R2 VCC net1 1kΩ
R3 VCC Vout 1kΩ
.ends dut
