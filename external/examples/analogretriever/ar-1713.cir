* official Analog Canvas netlist; PDK X cards rewritten by convert.py
.model nch nmos

.subckt dut VSS Vin Vout
CDB1 X VSS 1p
CDB2 Vout VSS 1p
CGD1 net0 X 1p
CGD2 X Vout 1p
CGS1 net0 VSS 1p
CGS2 X VSS 1p
M1 X net0 VSS VSS nch l=0.15 w=1 nf=1 m=1
M2 Vout X VSS VSS nch l=0.15 w=1 nf=1 m=1
RD1 VSS X 1k
RD2 VSS Vout 1k
RF X Vout 1k
RS Vin net0 1k
.ends dut
