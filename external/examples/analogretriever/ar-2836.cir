* official Analog Canvas netlist; PDK X cards rewritten by convert.py
.model nch nmos

.subckt dut VDD VSS Vout
Cin net2 VSS 1p
M1 Vout net2 VSS VSS nch l=0.15 w=1 nf=1 m=1
R1 net1 net0 1k
RD VDD Vout 1k
Vin net1 VSS DC 1
Vn net2 net0 DC 1
.ends dut
