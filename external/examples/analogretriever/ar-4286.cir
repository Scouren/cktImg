* official Analog Canvas netlist; PDK X cards rewritten by convert.py
.model nch nmos

.subckt dut VDD VSS
IREF VDD net1 DC 1m
M1 net1 net1 VSS VSS nch l=0.15 w=1 nf=1 m=1
M2 net3 net1 VSS VSS nch l=0.15 w=1 nf=1 m=1
M3 net2 net1 VSS VSS nch l=0.15 w=1 nf=1 m=1
M4 net0 net1 VSS VSS nch l=0.15 w=1 nf=1 m=1
RL1 VDD net3 1k
RL2 VDD net2 1k
RL3 VDD net0 1k
.ends dut
