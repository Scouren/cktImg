* official Analog Canvas netlist; PDK X cards rewritten by convert.py

.subckt dut VSS Voutp Voutn
VB1 net0 VSS DC 30V
R1 net0 Voutp 1k
R2 Voutp net1 100Ω
R3 net1 net3 1k
R4 net2 net3 1k
R5 net2 Voutn 1k
R6 VSS Voutn 1k
.ends dut
