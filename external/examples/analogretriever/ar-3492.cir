* official Analog Canvas netlist; PDK X cards rewritten by convert.py
.model qnpn npn

.subckt dut VCC VEE VSS Vin Vout
CC net1 Vin 1p
Q2 VCC net1 Vout VEE qnpn m=1
Q3 Vout net0 VEE VEE qnpn m=1
Q4 net0 net0 VEE VEE qnpn m=1
R VCC net0 1k
R2 VCC net1 1k
R3 net1 VEE 1k
RL Vout VSS 1k
.ends dut
