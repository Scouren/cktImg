* official Analog Canvas netlist; PDK X cards rewritten by convert.py

.subckt dut VSS vI vO
.model DIODE D(IS=1e-14 N=1)
D1 vI net0 DIODE
D2 vO net0 DIODE
D3 net0 vO DIODE
R1 vO VSS 1kΩ
.ends dut
