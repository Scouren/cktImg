* official Analog Canvas netlist; PDK X cards rewritten by convert.py
.model nch nmos

.subckt dut VSS vo
ii VSS net0 DC 1m
M1 net1 net0 VSS VSS nch l=0.15 w=1 nf=1 m=1
M2 net2 net1 VSS VSS nch l=0.15 w=1 nf=1 m=1
M3 vo net2 VSS VSS nch l=0.15 w=1 nf=1 m=1
R1 net1 VSS 5kΩ
R2 net2 VSS 5kΩ
R3 vo VSS 5kΩ
R4 net0 vo 10kΩ
.ends dut
