* official Analog Canvas netlist; PDK X cards rewritten by convert.py
.model nch nmos
.model pch pmos

.subckt dut VDD VSS IBIAS VIN11 VIN12 VOUT11 VOUT12
MB51 net0 net1 VDD VDD pch l=0.15 w=1 nf=1 m=1
MB52 net1 IBIAS net0 VDD pch l=0.15 w=1 nf=1 m=1
MB52p net1 VDD IBIAS IBIAS nch l=0.15 w=1 nf=1 m=1
MB53 net3 net1 VDD VDD pch l=0.15 w=1 nf=1 m=1
MB54 net2 net1 VDD VDD pch l=0.15 w=1 nf=1 m=1
MB55 VOUT11 IBIAS net3 VDD pch l=0.15 w=1 nf=1 m=1
MB56 VOUT12 IBIAS net2 VDD pch l=0.15 w=1 nf=1 m=1
MD1 VOUT11 VIN11 VSS VSS nch l=0.15 w=1 nf=1 m=1
MD2 VOUT12 VIN12 VSS VSS nch l=0.15 w=1 nf=1 m=1
.ends dut
