* official Analog Canvas netlist; PDK X cards rewritten by convert.py
.model nch nmos

.subckt dut VDD VSS GND vo
CC1 net3 net4 1p
CC2 net2 vo 1p
CG net0 GND 1p
IQ net4 VSS DC 1m
M1 net2 net0 net4 GND nch l=0.15 w=1 nf=1 m=1
RD net2 VDD 1k
RG net0 GND 1k
RL vo GND 1k
RSi net1 net3 1k
Vi net1 GND DC 1
.ends dut
