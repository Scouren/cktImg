* official Analog Canvas netlist; PDK X cards rewritten by convert.py
.model nch nmos
.model pch pmos

.subckt dut VDD VSS Vb Vout
M1 X Vout VSS VSS nch l=0.15 w=1 nf=1 m=1
M2 Y X VSS VSS nch l=0.15 w=1 nf=1 m=1
M3 Vout Y VSS VSS nch l=0.15 w=1 nf=1 m=1
M4 X Vb VDD VDD pch l=0.15 w=1 nf=1 m=1
M5 Y Vb VDD VDD pch l=0.15 w=1 nf=1 m=1
M6 Vout Vb VDD VDD pch l=0.15 w=1 nf=1 m=1
.ends dut
