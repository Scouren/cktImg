* official Analog Canvas netlist; PDK X cards rewritten by convert.py
.model nch nmos
.model pch pmos

.subckt dut VDD VSS F A B_bar B A_bar
MNA F A net1 VSS nch l=0.15 w=1 nf=1 m=1
MNA_bar F A_bar net3 VSS nch l=0.15 w=1 nf=1 m=1
MNB net1 B VSS VSS nch l=0.15 w=1 nf=1 m=1
MNB_bar net3 B_bar VSS VSS nch l=0.15 w=1 nf=1 m=1
MPA net0 A VDD VDD pch l=0.15 w=1 nf=1 m=1
MPA_bar F A_bar net2 VDD pch l=0.15 w=1 nf=1 m=1
MPB net2 B VDD VDD pch l=0.15 w=1 nf=1 m=1
MPB_bar F B_bar net0 VDD pch l=0.15 w=1 nf=1 m=1
.ends dut
