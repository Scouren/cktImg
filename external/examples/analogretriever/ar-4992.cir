* official Analog Canvas netlist; PDK X cards rewritten by convert.py
.model nch nmos

.subckt dut VDD VSS vout
C1 net0 net2 1p
C2 net1 vout 1p
M1 net1 net2 VSS VSS nch l=0.15 w=1 nf=1 m=1
R1 VDD net2 1MegΩ
R2 net2 VSS 350kΩ
RD VDD net1 68Ω
RL vout VSS 1kΩ
vin net0 VSS AC 100mV 0 SIN(0 100mV 1k 0 0 0)
.ends dut
