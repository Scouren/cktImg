* official Analog Canvas netlist; PDK X cards rewritten by convert.py
.model nch nmos

.subckt dut VDD VSS A B Y
.model NMOS nmos level=54
M1 net1 A VSS VSS nch l=0.15 w=1 nf=1 m=1
M2 net1 B VSS VSS nch l=0.15 w=1 nf=1 m=1
M3 VDD net1 net1 VSS NMOS l=150n m=1 nf=1 w=1u
M4 Y net1 VSS VSS nch l=0.15 w=1 nf=1 m=1
M5 net0 A VSS VSS nch l=0.15 w=1 nf=1 m=1
M6 Y B net0 VSS nch l=0.15 w=1 nf=1 m=1
M7 VDD Y Y VSS NMOS l=150n m=1 nf=1 w=1u
.ends dut
