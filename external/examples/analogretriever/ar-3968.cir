* official Analog Canvas netlist; PDK X cards rewritten by convert.py
.model qnpn npn

.subckt dut VCC VEE VSS vo
CC1 net1 net2 1p
CC2 net0 vo 1p
Q1 VCC net2 net0 VEE qnpn m=1
R1 VCC net2 1k
R2 net2 VEE 1k
RE net0 VEE 1k
RL vo VSS 1k
RS net3 net1 10kΩ
vs net3 VSS DC 1
.ends dut
