* official Analog Canvas netlist; PDK X cards rewritten by convert.py
.model nch nmos

.subckt dut VDD VSS A B C D Y
.model NMOS nmos level=54
MA Y A net0 VSS nch l=0.15 w=1 nf=1 m=1
MB Y B net1 VSS nch l=0.15 w=1 nf=1 m=1
MC net1 C net0 VSS nch l=0.15 w=1 nf=1 m=1
MD net0 D VSS VSS nch l=0.15 w=1 nf=1 m=1
ML VDD Y Y VSS NMOS l=150n m=1 nf=1 w=1u
.ends dut
