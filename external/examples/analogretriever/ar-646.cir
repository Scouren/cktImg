* official Analog Canvas netlist; PDK X cards rewritten by convert.py

.subckt dut Vin+ Vin- Vout+ Vout-
.model DIODE D(IS=1e-14 N=1)
VB3 Vin+ Vout+ DC 1
C1 Vout+ Vout- 1p
D1 Vin- Vout+ DIODE
D2 Vout- Vin+ DIODE
D4 Vout- Vin- DIODE
RL Vout+ Vout- 1k
.ends dut
