* official Analog Canvas netlist; PDK X cards rewritten by convert.py

.subckt dut VCC VSS
I1 VCC X DC 1m
I2 VCC Y DC 1m
RC1 X VSS 1k
RC2 Y VSS 1k
.ends dut
