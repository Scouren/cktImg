* official Analog Canvas netlist; PDK X cards rewritten by convert.py
.model nch nmos

.subckt dut VDD VSS Vout Vb
M1 Vout net2 net0 VSS nch l=0.15 w=1 nf=1 m=1
RD VDD Vout 1k
RG net2 Vb 1k
RS net1 net0 1k
Vin net1 VSS DC 1
.ends dut
