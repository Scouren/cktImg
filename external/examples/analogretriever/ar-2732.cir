* official Analog Canvas netlist; PDK X cards rewritten by convert.py
.model nch nmos

.subckt dut VDD VSS Iout
I1 net1 VSS DC 1m
IREF VDD Vb1 DC 1m
M0 Vb1 Vb1 X VSS nch l=0.15 w=1 nf=1 m=1
M1 X X VSS VSS nch l=0.15 w=1 nf=1 m=1
M2 net0 X VSS VSS nch l=0.15 w=1 nf=1 m=1
M3 Iout net1 net0 VSS nch l=0.15 w=1 nf=1 m=1
M4 VDD Vb1 net1 VSS nch l=0.15 w=1 nf=1 m=1
.ends dut
