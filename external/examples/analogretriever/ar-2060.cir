* official Analog Canvas netlist; PDK X cards rewritten by convert.py
.model nch nmos
.model pch pmos

.subckt dut VDD VSS A B C Vout
M1 net0 A VSS VSS nch l=0.15 w=1 nf=1 m=1
M2 net1 B net0 VSS nch l=0.15 w=1 nf=1 m=1
M3 Vout C net1 VSS nch l=0.15 w=1 nf=1 m=1
M4 Vout A VDD VDD pch l=0.15 w=1 nf=1 m=1
M5 Vout B VDD VDD pch l=0.15 w=1 nf=1 m=1
M6 Vout C VDD VDD pch l=0.15 w=1 nf=1 m=1
.ends dut
