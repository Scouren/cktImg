* official Analog Canvas netlist; PDK X cards rewritten by convert.py
.model nch nmos

.subckt dut VDD VSS vo
CC1 net0 net1 1p
CC2 net3 vo 1p
CS net2 VSS 1p
M1 net3 net1 net2 VSS nch l=0.15 w=1 nf=1 m=1
R1 VDD net1 1k
R2 net1 VSS 1k
RD VDD net3 1k
RL vo VSS 1k
RS net2 VSS 1k
Vi net0 VSS DC 1
.ends dut
