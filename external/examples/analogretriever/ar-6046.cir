* official Analog Canvas netlist; PDK X cards rewritten by convert.py
.model qpnp pnp

.subckt dut VSS vo2 vo3
Q7 vo3 vo2 net0 qpnp m=1
R4 VSS net0 1k
R5 vo3 VSS 1k
Ri4 vo3 VSS 1k
.ends dut
