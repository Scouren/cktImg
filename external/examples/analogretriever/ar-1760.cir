* official Analog Canvas netlist; PDK X cards rewritten by convert.py
.model nch nmos

.subckt dut VDD VSS Vin Vout
C1 Vin net1 100pF
CL Vout VSS 1p
M1 Vout net0 VSS VSS nch l=0.15 w=1 nf=1 m=1
R1 net1 net0 1k
RD VDD Vout 1k
RF net0 Vout 1k
.ends dut
