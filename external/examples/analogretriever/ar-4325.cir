* official Analog Canvas netlist; PDK X cards rewritten by convert.py
.model nch nmos
.model qpnp pnp

.subckt dut VDD VSS v1 v2 vO
IQ net1 VSS DC 1m
M1 net0 v1 net1 VSS nch l=0.15 w=1 nf=1 m=1
M2 vO v2 net1 VSS nch l=0.15 w=1 nf=1 m=1
Q1 net0 net0 VDD qpnp m=1
Q2 vO net0 VDD qpnp m=1
.ends dut
