* official Analog Canvas netlist; PDK X cards rewritten by convert.py
.model nch nmos
.model pch pmos

.subckt dut VDD VSS Vin Vout Vb
M1 X Vin VDD VDD pch l=0.15 w=1 nf=1 m=1
M2 Vout Vb X VSS nch l=0.15 w=1 nf=1 m=1
RD1 X VSS 1k
RD2 VDD Vout 1k
.ends dut
