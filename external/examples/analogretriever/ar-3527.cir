* official Analog Canvas netlist; PDK X cards rewritten by convert.py
.model nch nmos
.model qpnp pnp

.subckt dut VDD VSS GND vIN1 vIN2 Vout
IBIAS1 net2 VSS DC 1m
IBIAS2 Vout VSS DC 1m
M1A net0 vIN1 net2 net2 nch l=0.15 w=1 nf=1 m=1
M1B net3 vIN2 net2 net2 nch l=0.15 w=1 nf=1 m=1
Q2 Vout net1 VDD qpnp m=1
Q2p GND net3 net1 qpnp m=1
Q6A net0 net0 VDD qpnp m=1
Q6B net3 net0 VDD qpnp m=1
R2 VDD net1 1k
.ends dut
