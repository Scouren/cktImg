* official Analog Canvas netlist; PDK X cards rewritten by convert.py
.model qnpn npn

.subckt dut VCC VSS Vout
Q1 net0 net1 VSS VSS qnpn m=1
Q2 Vout net0 net1 VSS qnpn m=1
Q3 net1 net1 VSS VSS qnpn m=1
R1 VCC net0 13.7kΩ
.ends dut
