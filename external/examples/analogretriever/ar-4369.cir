* official Analog Canvas netlist; PDK X cards rewritten by convert.py
.model nch nmos

.subckt dut VDD VSS v1 v2 vO1 vO2
IQ net0 VSS DC 1m
M1 vO1 v1 net0 VSS nch l=0.15 w=1 nf=1 m=1
M2 vO2 v2 net0 VSS nch l=0.15 w=1 nf=1 m=1
RD1 VDD vO1 1k
RD2 VDD vO2 1k
RL vO1 vO2 1k
.ends dut
