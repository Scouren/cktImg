* official Analog Canvas netlist; PDK X cards rewritten by convert.py
.model qnpn npn
.model qpnp pnp

.subckt dut VEE Y X Z
Q1 net1 net0 X qpnp m=1
Q2 net0 net0 Y qpnp m=1
Q3 net1 net1 VEE VEE qnpn m=1
Q4 net0 net1 VEE VEE qnpn m=1
Q5 Z net1 VEE VEE qnpn m=1
.ends dut
