* official Analog Canvas netlist; PDK X cards rewritten by convert.py
.model nch nmos

.subckt dut VDD VSS Vout
I1 VDD Vout DC 1m
Iin VSS net0 DC 1m
M1 Vout net0 VSS VSS nch l=0.15 w=1 nf=1 m=1
RF net0 Vout 1k
.ends dut
