* official Analog Canvas netlist; PDK X cards rewritten by convert.py
.model nch nmos
.model pch pmos

.subckt dut VDD VSS Vb Vout
Iin VSS net0 DC 1m
M1 net1 Vb net0 VSS nch l=0.15 w=1 nf=1 m=1
M2 Vout net1 VDD VDD pch l=0.15 w=1 nf=1 m=1
RD VDD net1 1k
RF net0 VSS 1k
RF2 VSS Vout 1k
RM Vout VSS 1k
.ends dut
