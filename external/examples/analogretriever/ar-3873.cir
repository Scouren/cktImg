* official Analog Canvas netlist; PDK X cards rewritten by convert.py
.model qnpn npn

.subckt dut VCC VSS vo
CB VSS net0 1p
CC1 net5 net4 1p
CC2 net1 vo 1p
Q1 net2 net4 net3 VSS qnpn m=1
Q2 net1 net0 net2 VSS qnpn m=1
R1 VCC net0 1k
R2 net0 net4 1k
R3 net4 VSS 1k
RC VCC net1 1k
RE net3 VSS 1k
RL vo VSS 1k
Vi net5 VSS DC 1
.ends dut
