* official Analog Canvas netlist; PDK X cards rewritten by convert.py

.subckt voltage_amplifier VDD VSS VIN VOUT params: gain=1
ECORE VOUT 0 VIN 0 {gain}
.ends voltage_amplifier

.subckt dut VSS Vout
C1 Vout X 1p
C2 X Y 1p
C3 Y net0 1p
R1 X VSS 1k
R2 Y VSS 1k
R3 net0 VSS 1k
X1 0 VSS net0 Vout voltage_amplifier gain=1
.ends dut
