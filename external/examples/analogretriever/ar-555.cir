* official Analog Canvas netlist; PDK X cards rewritten by convert.py
.model nch nmos
.model pch pmos

.subckt dut VSS vid
M1 net5 net3 VSS VSS nch l=0.15 w=1 nf=1 m=1
M11 net5 net0 VSS VSS pch l=0.15 w=1 nf=1 m=1
M1A VSS net4 net5 VSS pch l=0.15 w=1 nf=1 m=1
M3 net1 net6 VSS VSS nch l=0.15 w=1 nf=1 m=1
M3A VSS net2 net1 VSS nch l=0.15 w=1 nf=1 m=1
Vi1 net3 vid DC 1
Vi11 net0 VSS DC 1
Vi1A net4 VSS DC 1
Vi3 net6 VSS DC 1
Vi3A net2 VSS DC 1
.ends dut
