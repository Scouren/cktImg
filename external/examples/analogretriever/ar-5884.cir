* official Analog Canvas netlist; PDK X cards rewritten by convert.py
.model nch nmos

.subckt dut VDD VSS GND vi2 vo
C1 net0 vo 1p
M1 net0 GND vi2 GND nch l=0.15 w=1 nf=1 m=1
R1 VDD net0 5kΩ
R2 vo GND 2kΩ
R3 vi2 VSS 10kΩ
.ends dut
