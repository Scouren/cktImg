* official Analog Canvas netlist; PDK X cards rewritten by convert.py
.model nch nmos

.subckt dut VSS Vb I1 I2 IN
M1 I1 Vb net0 VSS nch l=0.15 w=1 nf=1 m=1
M2 I2 Vb net2 VSS nch l=0.15 w=1 nf=1 m=1
MN IN Vb net1 VSS nch l=0.15 w=1 nf=1 m=1
R1 VSS net0 1k
R2 net0 net2 1k
R3 net2 net1 1k
.ends dut
