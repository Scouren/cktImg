* official Analog Canvas netlist; PDK X cards rewritten by convert.py
.model nch nmos

.subckt dut VSS vo1 vo2 vicm
M1 vo1 vicm net0 VSS nch l=0.15 w=1 nf=1 m=1
M2 vo2 vicm net0 VSS nch l=0.15 w=1 nf=1 m=1
RD1 VSS vo1 1k
RD2 VSS vo2 1k
RSS net0 VSS 1k
.ends dut
