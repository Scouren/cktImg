* official Analog Canvas netlist; PDK X cards rewritten by convert.py
.model nch nmos

.subckt dut VDD VSS Vout
M1 Vout X VSS VSS nch l=0.15 w=1 nf=1 m=1
R1 VDD X 100kΩ
R2 X VSS 50kΩ
RD VDD Vout 1kΩ
V1 X VSS DC 1
.ends dut
