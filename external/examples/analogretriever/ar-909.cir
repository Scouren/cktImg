* official Analog Canvas netlist; PDK X cards rewritten by convert.py
.model qnpn npn

.subckt dut VCC VSS vout
Q1 vout VSS X VSS qnpn m=1
RC VCC vout 1k
Rgm X2 VSS 1k
RS net1 X 1k
RS2 net0 X2 1k
Vin net1 VSS DC 1
Vin2 net0 VSS DC 1
.ends dut
