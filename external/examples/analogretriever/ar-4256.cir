* official Analog Canvas netlist; PDK X cards rewritten by convert.py
.model nch nmos
.model pch pmos

.subckt dut VDD VSS vI vO
CC net0 vO 1p
IREF net1 VSS DC 1m
M0 net0 vI VSS VSS nch l=0.15 w=1 nf=1 m=1
M1 net1 net1 VDD VDD pch l=0.15 w=1 nf=1 m=1
M2 net0 net1 VDD VDD pch l=0.15 w=1 nf=1 m=1
RL vO VSS 1k
.ends dut
