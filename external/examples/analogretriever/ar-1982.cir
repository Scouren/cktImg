* official Analog Canvas netlist; PDK X cards rewritten by convert.py
.model qnpn npn

.subckt dut VCC VSS Vin Vb Vout
C1 net0 Vout 50uF
Q1 VCC Vin net0 VSS qnpn m=1
Q2 net0 Vb VSS VSS qnpn m=1
R1 Vout VSS 8Ω
.ends dut
