* official Analog Canvas netlist; PDK X cards rewritten by convert.py
.model qnpn npn

.subckt dut VCC VSS Vin1 Vin2 Vout1 Vout2
IEE P VSS DC 1m
Q1 Vout1 Vin1 P VSS qnpn m=1
Q2 Vout2 Vin2 P VSS qnpn m=1
R1 Vout1 P 1k
R2 Vout2 P 1k
RC1 VCC Vout1 1k
RC2 VCC Vout2 1k
.ends dut
