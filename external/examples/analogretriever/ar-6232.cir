* official Analog Canvas netlist; PDK X cards rewritten by convert.py
.model qnpn npn
.model qpnp pnp

.subckt dut VCC VEE VSS vI vO
I1 VCC net0 DC 1mA
I2 net1 VEE DC 1mA
Q1 VEE vI net0 qpnp m=1
Q2 VCC vI net1 VSS qnpn m=1
Q3 VCC net0 vO VSS qnpn m=1
Q4 VEE net1 vO qpnp m=1
RL vO VSS 200Ω
.ends dut
