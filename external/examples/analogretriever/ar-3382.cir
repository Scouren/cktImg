* official Analog Canvas netlist; PDK X cards rewritten by convert.py

.subckt dut D S B
.model DIODE D(IS=1e-14 N=1)
D1 B net1 DIODE
D2 B net0 DIODE
I1 net1 net0 DC 1m
RD D net1 1k
RS net0 S 1k
RSD net1 net0 1k
.ends dut
