* official Analog Canvas netlist; PDK X cards rewritten by convert.py
.model qnpn npn

.subckt dut VCC VEE VSS
Q1 VCC VSS net0 VEE qnpn m=1
Q2 VCC net0 net1 VEE qnpn m=1
RE1 net0 VEE 20kΩ
RE2 net1 VEE 1kΩ
.ends dut
