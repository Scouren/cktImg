* official Analog Canvas netlist; PDK X cards rewritten by convert.py

.subckt dut VSS
Rb net0 net1 1k
RE net2 net3 1k
Rpi net1 net2 1k
Vfb net3 VSS DC 1
Vs net0 VSS DC 1
.ends dut
