* official Analog Canvas netlist; PDK X cards rewritten by convert.py
.model qnpn npn

.subckt dut VCC VEE VSS vo
CC1 net0 net2 1p
CC2 net3 vo 1p
CL vo VSS 1p
Q1 VCC net2 net3 VEE qnpn m=1
R1 VCC net2 1k
R2 net2 VEE 1k
RE net3 VEE 1k
RL vo VSS 1k
RS net1 net0 1k
vi net1 VSS DC 1
.ends dut
