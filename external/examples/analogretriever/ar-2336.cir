* official Analog Canvas netlist; PDK X cards rewritten by convert.py
.model nch nmos
.model pch pmos

.subckt dut VDD VSS VIN+ VIN- IOUTn- IOUTn+ IOUTp- IOUTp+
IBIAS1 VDD net1 DC 1m
IBIAS2 net0 VSS DC 1m
MN1 IOUTn- VIN+ net0 VSS nch l=0.15 w=1 nf=1 m=1
MN2 IOUTn+ VIN- net0 VSS nch l=0.15 w=1 nf=1 m=1
MP1 IOUTp- VIN+ net1 VDD pch l=0.15 w=1 nf=1 m=1
MP2 IOUTp+ VIN- net1 VDD pch l=0.15 w=1 nf=1 m=1
.ends dut
