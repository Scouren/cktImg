* official Analog Canvas netlist; PDK X cards rewritten by convert.py
.model pch pmos

.subckt dut VDD VSS GND vO
CC1 net2 net0 1p
CS net1 GND 1p
M1 vO net0 net1 VDD pch l=0.15 w=1 nf=1 m=1
RD vO VSS 2kΩ
RG net0 GND 100kΩ
RS VDD net1 1.2kΩ
vi net2 GND DC 1
.ends dut
