* official Analog Canvas netlist; PDK X cards rewritten by convert.py

.subckt dut VSS vo
G1 vo VSS B VSS 1m
RBB net0 B 100kΩ
RC vo VSS 3kΩ
Rpi B VSS 1k
Vi net0 VSS DC 1
.ends dut
