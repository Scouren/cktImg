* official Analog Canvas netlist; PDK X cards rewritten by convert.py
.model qnpn npn

.subckt dut VSS Vout
VB1 net0 VSS DC 1
C1 net1 VSS 1p
I1 net2 VSS DC 1m
Q1 Vout net0 net2 VSS qnpn m=1
R1 Vout net1 1k
R2 net1 net2 1k
.ends dut
