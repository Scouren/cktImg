* official Analog Canvas netlist; PDK X cards rewritten by convert.py

.subckt dut VSS
G1 net3 net0 net1 net0 1m
G2 net2 net0 net1 net0 1m
R1 VSS net3 1k
R2 VSS net2 1k
R3 net0 VSS 1k
R4 net0 VSS 1k
Rpi1 net1 net0 1k
Rpi2 net1 net0 1k
vic net1 VSS DC 1
.ends dut
