* official Analog Canvas netlist; PDK X cards rewritten by convert.py

.subckt dut VDD VSS
.model NJF NJF(VTO=-2 BETA=1e-3 LAMBDA=0.01)
C1 net0 net2 1p
C2 net3 net4 1p
J1 VDD net2 net3 NJF m=1
R1 VDD net2 10MegΩ
R2 net2 VSS 10MegΩ
RG net1 net0 47kΩ
RL net4 VSS 1kΩ
RS net3 VSS 1kΩ
vg net1 VSS DC 0 SIN(0 1mV 1k 0 0 0)
.ends dut
