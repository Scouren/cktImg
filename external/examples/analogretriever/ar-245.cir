* official Analog Canvas netlist; PDK X cards rewritten by convert.py
.model nch nmos
.model pch pmos

.subckt dut VSS vo
M12 net0 VSS VSS VSS nch l=0.15 w=1 nf=1 m=1
M2 net0 VSS VSS VSS pch l=0.15 w=1 nf=1 m=1
M2A vo VSS net0 VSS nch l=0.15 w=1 nf=1 m=1
M4 net1 VSS VSS VSS pch l=0.15 w=1 nf=1 m=1
M4A vo VSS net1 VSS pch l=0.15 w=1 nf=1 m=1
Vx vo VSS DC 1
.ends dut
