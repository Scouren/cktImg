* official Analog Canvas netlist; PDK X cards rewritten by convert.py
.model qnpn npn

.subckt dut VEE VCC VSS vi vo
Q1 VCC vi net0 VEE qnpn m=1
Q2 vo VSS net0 VEE qnpn m=1
R1 VCC vo 10kΩ
RTAIL net0 VEE 10kΩ
.ends dut
