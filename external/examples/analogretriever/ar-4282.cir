* official Analog Canvas netlist; PDK X cards rewritten by convert.py
.model pch pmos

.subckt dut VDD VSS
M1 net1 net1 VDD VDD pch l=0.15 w=1 nf=1 m=1
M2 net0 net1 VDD VDD pch l=0.15 w=1 nf=1 m=1
M3 VSS VSS net1 VDD pch l=0.15 w=1 nf=1 m=1
R net0 VSS 1k
.ends dut
