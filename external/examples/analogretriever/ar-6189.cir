* official Analog Canvas netlist; PDK X cards rewritten by convert.py
.model nch nmos
.model pch pmos

.subckt dut VDD VSS GND Vin vO
I1 net0 VSS DC 200uA
I2 net1 VSS DC 300uA
I3 vO VSS DC 0.8mA
M1 net2 Vin net0 VSS nch l=0.15 w=1 nf=1 m=1
M2 VDD vO net0 VSS nch l=0.15 w=1 nf=1 m=1
M3 net2 net2 VDD VDD pch l=0.15 w=1 nf=1 m=1
M4 net1 net2 VDD VDD pch l=0.15 w=1 nf=1 m=1
M5 VDD net1 vO VSS nch l=0.15 w=1 nf=1 m=1
vS Vin GND DC 1
.ends dut
