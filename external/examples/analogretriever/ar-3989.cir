* official Analog Canvas netlist; PDK X cards rewritten by convert.py
.model qnpn npn

.subckt dut VCC VSS vo1 vo3
C1 net0 vo2 1p
Q2 net0 vo1 net1 VSS qnpn m=1
Q3 vo3 vo2 net2 VSS qnpn m=1
R3 VCC vo1 1k
R4 vo1 VSS 1k
R5 VCC vo2 1k
R6 vo2 VSS 1k
RC2 VCC net0 1k
RC3 VCC vo3 1k
RE2 net1 VSS 1k
RE3 net2 VSS 1k
.ends dut
