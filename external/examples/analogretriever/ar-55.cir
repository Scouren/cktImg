* official Analog Canvas netlist; PDK X cards rewritten by convert.py

.subckt dut VSS vo
Fb VSS vo V__icm_sense_dde58e8dcf408876 1
it VSS vt DC 1m
RL vo VSS 1k
ro VSS vo 1k
rpi __icm_sense_node_dde58e8dcf408876 vo 1k
V__icm_sense_dde58e8dcf408876 vt __icm_sense_node_dde58e8dcf408876 DC 0
.ends dut
