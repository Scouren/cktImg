* official Analog Canvas netlist; PDK X cards rewritten by convert.py

.subckt dut VSS
C net0 VSS 0.022uF
Leq net0 VSS 5.0mH
R1 net0 VSS 5.1kΩ
Rpeq net0 VSS 10.0kΩ
V1 net0 VSS DC 0 SIN(0 1 1k 0 0 0)
.ends dut
