* official Analog Canvas netlist; PDK X cards rewritten by convert.py
.model nch nmos
.model pch pmos

.subckt dut VDD VSS Vin Vout
I1 Vout VSS DC 1m
ISS net2 VSS DC 1m
M1 net0 Vin net2 VSS nch l=0.15 w=1 nf=1 m=1
M2 net1 Vout net2 VSS nch l=0.15 w=1 nf=1 m=1
M3 net0 net0 VDD VDD pch l=0.15 w=1 nf=1 m=1
M4 net1 net0 VDD VDD pch l=0.15 w=1 nf=1 m=1
M5 VDD net1 Vout VSS nch l=0.15 w=1 nf=1 m=1
.ends dut
