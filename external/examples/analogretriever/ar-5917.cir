* official Analog Canvas netlist; PDK X cards rewritten by convert.py

.subckt dut VSS
G1 D VSS VSS S 1m
R1 VSS S {1/gm}
Ro D S 1k
Rs S VSS 1k
Vx D VSS DC 1
.ends dut
