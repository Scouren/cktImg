* official Analog Canvas netlist; PDK X cards rewritten by convert.py
.model qnpn npn

.subckt dut VCC VEE v1 v2
Q1 net4 v1 net0 VEE qnpn m=1
Q2 net1 v2 net3 VEE qnpn m=1
R1 net0 net2 2kΩ
R2 net3 net2 2kΩ
RC1 VCC net4 100kΩ
RC2 VCC net1 100kΩ
RE net2 VEE 85kΩ
.ends dut
