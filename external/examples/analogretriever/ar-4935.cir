* official Analog Canvas netlist; PDK X cards rewritten by convert.py

.subckt dut VDD VSS
.model NJF NJF(VTO=-2 BETA=1e-3 LAMBDA=0.01)
J1 net1 net2 net0 NJF m=1
RD VDD net1 1k
RG net2 VSS 1k
RS net0 VSS 1k
.ends dut
