* official Analog Canvas netlist; PDK X cards rewritten by convert.py
.model nch nmos
.model pch pmos

.subckt dut VSS vo
M1 net4 VSS VSS VSS pch l=0.15 w=1 nf=1 m=1
M11 net4 VSS VSS VSS nch l=0.15 w=1 nf=1 m=1
M12 net2 VSS VSS VSS nch l=0.15 w=1 nf=1 m=1
M1A net3 VSS net4 VSS nch l=0.15 w=1 nf=1 m=1
M2 net2 VSS VSS VSS pch l=0.15 w=1 nf=1 m=1
M2A vo VSS net2 VSS nch l=0.15 w=1 nf=1 m=1
M3 net0 net0 VSS VSS pch l=0.15 w=1 nf=1 m=1
M3A net3 net3 net0 VSS pch l=0.15 w=1 nf=1 m=1
M4 net1 net0 VSS VSS pch l=0.15 w=1 nf=1 m=1
M4A vo net3 net1 VSS pch l=0.15 w=1 nf=1 m=1
Vx vo VSS DC 1
.ends dut
