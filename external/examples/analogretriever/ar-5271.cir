* official Analog Canvas netlist; PDK X cards rewritten by convert.py

.subckt dut VSS
VB1 A E DC 100V
R1 A B 1.0kΩ
R2 B VSS 1.0kΩ
R3 VSS D 1.0kΩ
R4 E D 1.0kΩ
.ends dut
