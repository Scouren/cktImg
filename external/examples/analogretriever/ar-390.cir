* official Analog Canvas netlist; PDK X cards rewritten by convert.py

.subckt dut VSS vo
G1 vo VSS vbe VSS {gm}
iin VSS vbe DC 1m
RC vo VSS 1k
RF vbe vo 1k
ro vo VSS 1k
rpi vbe VSS 1k
.ends dut
