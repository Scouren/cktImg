* official Analog Canvas netlist; PDK X cards rewritten by convert.py
.model qnpn npn
.model qpnp pnp

.subckt dut VCC VSS Vin Vout
I1 net0 VSS DC 1m
Q1 net1 Vin net0 VSS qnpn m=1
Q2 Vout net1 VCC qpnp m=1
RC1 VCC net1 1k
.ends dut
