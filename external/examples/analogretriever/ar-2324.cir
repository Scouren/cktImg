* official Analog Canvas netlist; PDK X cards rewritten by convert.py
.model nch nmos

.subckt dut VSS OUT- OUT+ VBIAS IN+ IN-
IBIAS net1 VSS DC 1m
M1 net2 IN+ net1 VSS nch l=0.15 w=1 nf=1 m=1
M2 net0 IN- net1 VSS nch l=0.15 w=1 nf=1 m=1
M3 OUT- VBIAS net2 VSS nch l=0.15 w=1 nf=1 m=1
M4 OUT+ VBIAS net0 VSS nch l=0.15 w=1 nf=1 m=1
.ends dut
