* official Analog Canvas netlist; PDK X cards rewritten by convert.py
.model nch nmos
.model pch pmos

.subckt dut VDD VSS Vb1 Vin1 Vin2 Vb2 Vb3 Vout1 Vout2
M1 Vout1 Vin1 net0 VSS nch l=0.15 w=1 nf=1 m=1
M2 Vout2 Vin2 net0 VSS nch l=0.15 w=1 nf=1 m=1
M3 Vout1 Vb1 VDD VDD pch l=0.15 w=1 nf=1 m=1
M4 Vout2 Vb1 VDD VDD pch l=0.15 w=1 nf=1 m=1
M5 net0 Vb2 net1 VSS nch l=0.15 w=1 nf=1 m=1
M6 net1 Vb3 VSS VSS nch l=0.15 w=1 nf=1 m=1
.ends dut
