* official Analog Canvas netlist; PDK X cards rewritten by convert.py
.model nch nmos

.subckt dut VDD VSS GND vo
CC net0 vo 1p
I net0 VSS DC 1m
M1 VDD net1 net0 GND nch l=0.15 w=1 nf=1 m=1
RG net1 GND 100kΩ
RL vo GND 1k
Vi net1 GND DC 1
.ends dut
