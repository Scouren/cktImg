* official Analog Canvas netlist; PDK X cards rewritten by convert.py
.model nch nmos
.model pch pmos

.subckt dut VDD VSS vin
ISS net1 VSS DC 1m
M1 VSS X VDD VDD pch l=0.15 w=1 nf=1 m=1
M3 X vin net1 VSS nch l=0.15 w=1 nf=1 m=1
M4 net0 VSS net1 VSS nch l=0.15 w=1 nf=1 m=1
M5 X net0 VDD VDD pch l=0.15 w=1 nf=1 m=1
M6 net0 net0 VDD VDD pch l=0.15 w=1 nf=1 m=1
.ends dut
