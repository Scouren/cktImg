* official Analog Canvas netlist; PDK X cards rewritten by convert.py

.subckt dut VSS Vin
Cpi v1 VSS 1p
Gm VSS VSS v1 VSS 1m
Ii VSS net0 DC 1m
Rb net0 v1 1k
Ro VSS VSS 1k
Rpi v1 VSS 1k
Vi Vin net0 DC 1
.ends dut
