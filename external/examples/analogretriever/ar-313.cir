* official Analog Canvas netlist; PDK X cards rewritten by convert.py

.subckt dut VSS vo
Cdb1 v2 VSS 1p
Cdb2 vo VSS 1p
Cgd1 v2 v1 1p
Cgd2 vo v2 1p
Cgs1 v1 VSS 1p
Cgs2 v2 VSS 1p
G1 v2 VSS v1 VSS 1m
G2 vo VSS v2 VSS 1m
RL1 v2 VSS 1k
RL2 vo VSS 1k
RS net0 v1 1k
Vs net0 VSS DC 1
.ends dut
