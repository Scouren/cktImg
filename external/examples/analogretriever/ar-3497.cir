* official Analog Canvas netlist; PDK X cards rewritten by convert.py

.subckt dut VSS VIN VOUT
G1 net1 VSS VIN VSS 1m
G2 VOUT VSS net1 VSS 1m
RB1 VIN VSS 1k
RC2 VOUT VSS 1k
RL VOUT VSS 1k
RL1 net1 VSS 1k
RPI1 VIN VSS 1k
RPI2 net1 VSS 1k
RT net0 VIN 1k
VT net0 VSS DC 1
.ends dut
