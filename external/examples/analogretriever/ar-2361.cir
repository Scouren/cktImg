* official Analog Canvas netlist; PDK X cards rewritten by convert.py
.model nch nmos
.model pch pmos

.subckt dut VDD VSS VIN+ VIN- VOUT- VOUT+ VBIAS4 VBIAS5 VBIAS3 VBIAS2 VBIAS1 VCMFB
M10 net3 VBIAS3 VDD VDD pch l=0.15 w=1 nf=1 m=1
M3 net4 VCMFB VSS VSS nch l=0.15 w=1 nf=1 m=1
M4 net2 VCMFB VSS VSS nch l=0.15 w=1 nf=1 m=1
M5 VOUT- VBIAS1 net4 VSS nch l=0.15 w=1 nf=1 m=1
M6 VOUT+ VBIAS1 net2 VSS nch l=0.15 w=1 nf=1 m=1
M7 VOUT- VBIAS2 net0 VDD pch l=0.15 w=1 nf=1 m=1
M8 VOUT+ VBIAS2 net3 VDD pch l=0.15 w=1 nf=1 m=1
M9 net0 VBIAS3 VDD VDD pch l=0.15 w=1 nf=1 m=1
MB1 net5 VBIAS4 VDD VDD pch l=0.15 w=1 nf=1 m=1
MB2 net1 VBIAS5 VSS VSS nch l=0.15 w=1 nf=1 m=1
MN1 net0 VIN+ net1 VSS nch l=0.15 w=1 nf=1 m=1
MN2 net3 VIN- net1 VSS nch l=0.15 w=1 nf=1 m=1
MP1 net4 VIN+ net5 VDD pch l=0.15 w=1 nf=1 m=1
MP2 net2 VIN- net5 VDD pch l=0.15 w=1 nf=1 m=1
.ends dut
