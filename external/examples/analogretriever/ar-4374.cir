* official Analog Canvas netlist; PDK X cards rewritten by convert.py
.model qnpn npn
.model qpnp pnp

.subckt dut VCC VEE VSS v1 v2 vO
IQ VCC net1 DC 1m
Q1 net0 v1 net1 qpnp m=1
Q2 vO v2 net1 qpnp m=1
Q3 net0 net0 VEE VEE qnpn m=1
Q4 vO net0 VEE VEE qnpn m=1
RL vO VSS 1k
.ends dut
