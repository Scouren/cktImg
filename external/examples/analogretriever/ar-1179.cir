* official Analog Canvas netlist; PDK X cards rewritten by convert.py
.model nch nmos

.subckt dut VDD VSS Vin Vout
C1 net2 net1 1p
M1 Vout net1 net0 VSS nch l=0.15 w=1 nf=1 m=1
R1 VDD net1 1k
R2 net1 VSS 1k
RD VDD Vout 1k
RG Vin net2 1k
RS net0 VSS 1k
.ends dut
