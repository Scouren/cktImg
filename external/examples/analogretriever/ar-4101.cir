* official Analog Canvas netlist; PDK X cards rewritten by convert.py
.model pch pmos

.subckt dut VDD VSS GND vo
CC net1 vo 1p
M1 VSS net0 net1 VDD pch l=0.15 w=1 nf=1 m=1
RG net0 GND 50kΩ
RL vo GND 10kΩ
RS VDD net1 12kΩ
vi net0 GND DC 1
.ends dut
