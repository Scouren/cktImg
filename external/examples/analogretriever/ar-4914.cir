* official Analog Canvas netlist; PDK X cards rewritten by convert.py

.subckt dut VSS
.model DIODE D(IS=1e-14 N=1)
C net0 VSS 1p
C1 net1 net2 1p
D1 net2 VSS DIODE
I1 net0 VSS DC 1m
L net0 VSS 1n
RB net2 VSS 1k
rc net0 VSS 1k
Vin net1 VSS DC 1
.ends dut
