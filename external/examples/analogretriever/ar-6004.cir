* official Analog Canvas netlist; PDK X cards rewritten by convert.py
.model nch nmos

.subckt dut VDD VSS Vin1 Vin2
I1 net3 VSS DC 1m
M1 net0 Vin1 net2 VSS nch l=0.15 w=1 nf=1 m=1
M2 net4 Vin2 net1 VSS nch l=0.15 w=1 nf=1 m=1
RD1 VDD net0 1k
RD2 VDD net4 1k
RL net0 net4 1k
RS1 net2 net3 1k
RS2 net3 net1 1k
.ends dut
