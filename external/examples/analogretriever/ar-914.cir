* official Analog Canvas netlist; PDK X cards rewritten by convert.py
.model qnpn npn

.subckt dut VCC VSS vout vout2
Q1 vout net2 net0 VSS qnpn m=1
Q2 vout2 VSS net1 VSS qnpn m=1
RC VCC vout 1k
RC2 VCC vout2 1k
RE net0 VSS 1k
RE2 net1 VSS 1k
vin net2 VSS DC 1
.ends dut
