* official Analog Canvas netlist; PDK X cards rewritten by convert.py
.model qnpn npn
.model qpnp pnp

.subckt dut VCC VEE VSS vO VB
CC net2 net1 1p
CE net0 VSS 1p
IQ net0 VEE DC 1m
Q1 vO VB VCC qpnp m=1
Qo vO net1 net0 VEE qnpn m=1
RB net1 VSS 1k
vs net2 VSS DC 1
.ends dut
