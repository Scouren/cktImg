* official Analog Canvas netlist; PDK X cards rewritten by convert.py
.model nch nmos

.subckt dut VDD VSS Vout
C1 net1 net0 1p
C2 net2 VSS 1p
I1 net2 VSS DC 1m
M1 Vout net0 net2 VSS nch l=0.15 w=1 nf=1 m=1
R1 VDD net0 1k
RD VDD Vout 1k
Vin net1 VSS DC 1
.ends dut
