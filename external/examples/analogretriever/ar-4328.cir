* official Analog Canvas netlist; PDK X cards rewritten by convert.py
.model qnpn npn

.subckt dut VSS Vout
QA VSS net0 net1 VSS qnpn m=1
QB VSS net1 Vout VSS qnpn m=1
R1 net0 VSS 300kΩ
R2 Vout VSS 10kΩ
.ends dut
