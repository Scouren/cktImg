* official Analog Canvas netlist; PDK X cards rewritten by convert.py
.model pch pmos
.model qnpn npn

.subckt dut VDD VSS Vin1 Vin2 vo
I1 VDD net1 DC 1m
M1 net0 Vin1 net1 VDD pch l=0.15 w=1 nf=1 m=1
M2 vo Vin2 net1 VDD pch l=0.15 w=1 nf=1 m=1
Q3 net0 net0 VSS VSS qnpn m=1
Q4 vo net0 VSS VSS qnpn m=1
.ends dut
