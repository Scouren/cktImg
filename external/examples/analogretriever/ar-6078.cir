* official Analog Canvas netlist; PDK X cards rewritten by convert.py
.model nch nmos
.model pch pmos

.subckt dut VDD VSS Vin1 Vin2 vo
I1 net0 VSS DC 1m
M1 net1 Vin1 net0 VSS nch l=0.15 w=1 nf=1 m=1
M2 net2 Vin2 net0 VSS nch l=0.15 w=1 nf=1 m=1
M3 net1 net1 VDD VDD pch l=0.15 w=1 nf=1 m=1
M4 net2 net2 VDD VDD pch l=0.15 w=1 nf=1 m=1
M5 net3 net1 VDD VDD pch l=0.15 w=1 nf=1 m=1
M6 vo net2 VDD VDD pch l=0.15 w=1 nf=1 m=1
M7 net3 net3 VSS VSS nch l=0.15 w=1 nf=1 m=1
M8 vo net3 VSS VSS nch l=0.15 w=1 nf=1 m=1
.ends dut
