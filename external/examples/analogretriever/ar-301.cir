* official Analog Canvas netlist; PDK X cards rewritten by convert.py

.subckt dut VSS vo
Cpi Bp vo 1p
Gm VSS vo Bp vo 1m
RL vo VSS 1k
RS net0 Bp 1k
rpi Bp vo 1k
vi net0 VSS DC 1
.ends dut
