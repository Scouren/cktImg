* official Analog Canvas netlist; PDK X cards rewritten by convert.py
.model nch nmos

.subckt dut VDD VSS vout1 vout2 Vin1 Vin2 Vb2 Vb3
M1 vout1 Vin1 P VSS nch l=0.15 w=1 nf=1 m=1
M2 vout2 Vin2 P VSS nch l=0.15 w=1 nf=1 m=1
M3 P Vb2 net0 VSS nch l=0.15 w=1 nf=1 m=1
M4 net0 Vb3 VSS VSS nch l=0.15 w=1 nf=1 m=1
RD1 VDD vout1 1k
RD2 VDD vout2 1k
.ends dut
