* official Analog Canvas netlist; PDK X cards rewritten by convert.py
.model nch nmos
.model pch pmos

.subckt dut VDD VSS Vin Iout I1_N
I1 net0 I1_N DC 1m
M1 net1 Vin net0 VSS nch l=0.15 w=1 nf=1 m=1
M2 Iout net1 VDD VDD pch l=0.15 w=1 nf=1 m=1
RD1 VDD net1 1k
.ends dut
