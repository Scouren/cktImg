* official Analog Canvas netlist; PDK X cards rewritten by convert.py

.subckt dut VSS
.model DIODE D(IS=1e-14 N=1)
VB1 net0 VSS DC 1
D1 VSS net2 DIODE
D2 net1 VSS DIODE
R1 net0 net2 1k
R2 net2 net1 1k
.ends dut
