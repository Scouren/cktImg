* official Analog Canvas netlist; PDK X cards rewritten by convert.py
.model qnpn npn

.subckt dut VSS vo1 vo2
Q1 vo1 net0 ve VSS qnpn m=1
Q2 vo2 VSS ve VSS qnpn m=1
RC1 VSS vo1 1k
RC2 VSS vo2 1k
REE ve VSS 1k
Vid net0 VSS DC 1
.ends dut
