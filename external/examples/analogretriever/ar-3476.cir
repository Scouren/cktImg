* official Analog Canvas netlist; PDK X cards rewritten by convert.py
.model qnpn npn

.subckt dut VCC VEE Iout1 Iout2
Q1 VCC net1 net0 VEE qnpn m=1
Q2 net1 net0 VEE VEE qnpn m=1
Q3 Iout1 net0 VEE VEE qnpn m=1
Q4 Iout2 net0 VEE VEE qnpn m=1
R1 VCC net1 1k
.ends dut
