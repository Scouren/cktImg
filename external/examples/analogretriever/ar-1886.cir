* official Analog Canvas netlist; PDK X cards rewritten by convert.py
.model nch nmos
.model pch pmos

.subckt dut VDD VSS Vin Vout
M1 net0 Vin Vout VSS nch l=0.15 w=1 nf=1 m=1
M2 Vout net0 VDD VDD pch l=0.15 w=1 nf=1 m=1
RD1 VDD net0 2kΩ
RD2 Vout VSS 500Ω
.ends dut
