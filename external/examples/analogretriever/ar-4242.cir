* official Analog Canvas netlist; PDK X cards rewritten by convert.py
.model nch nmos

.subckt dut VDD VSS Iout
IREF VDD net0 DC 1m
M1 net2 net1 VSS VSS nch l=0.15 w=1 nf=1 m=1
M2 net1 net1 VSS VSS nch l=0.15 w=1 nf=1 m=1
M3 Iout net0 net1 VSS nch l=0.15 w=1 nf=1 m=1
M4 net0 net0 net2 VSS nch l=0.15 w=1 nf=1 m=1
.ends dut
