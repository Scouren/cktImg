* official Analog Canvas netlist; PDK X cards rewritten by convert.py

.subckt dut VSS Vo
Cmu net1 Vo 1p
Cpi net1 VSS 1p
G1 Vo VSS net1 VSS 1m
RB net0 VSS 1k
Rbb net0 net1 1k
RL Vo VSS 1k
Rpi net1 VSS 1k
RS net2 net0 1k
Vi net2 VSS DC 1
.ends dut
