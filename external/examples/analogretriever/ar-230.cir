* official Analog Canvas netlist; PDK X cards rewritten by convert.py
.model nch nmos
.model pch pmos

.subckt dut VDD VSS Vin+ Vin- VO
CC net1 VO 1p
IBIAS net0 VSS DC 1m
M1 net2 Vin+ net3 VDD pch l=0.15 w=1 nf=1 m=1
M2 net1 Vin- net3 VDD pch l=0.15 w=1 nf=1 m=1
M3 net2 net2 VSS VSS nch l=0.15 w=1 nf=1 m=1
M4 net1 net2 VSS VSS nch l=0.15 w=1 nf=1 m=1
M5 net3 net0 VDD VDD pch l=0.15 w=1 nf=1 m=1
M6 VO net1 VSS VSS nch l=0.15 w=1 nf=1 m=1
M7 VO net0 VDD VDD pch l=0.15 w=1 nf=1 m=1
M8 net0 net0 VDD VDD pch l=0.15 w=1 nf=1 m=1
.ends dut
