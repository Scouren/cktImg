* official Analog Canvas netlist; PDK X cards rewritten by convert.py
.model nch nmos

.subckt dut VDD VSS GND vo
CC1 net1 net3 1p
CC2 net4 net0 1p
CC3 net5 vo 1p
M1 VDD net3 net4 GND nch l=0.15 w=1 nf=1 m=1
M2 net5 GND net0 GND nch l=0.15 w=1 nf=1 m=1
RD net5 VDD 5kΩ
RG net3 GND 400kΩ
Ri net2 net1 2kΩ
RL vo GND 2kΩ
RS1 net4 VSS 10kΩ
RS2 net0 VSS 10kΩ
Vi net2 GND DC 1
.ends dut
