* official Analog Canvas netlist; PDK X cards rewritten by convert.py
.model qnpn npn

.subckt dut VCC VSS vIN vOUT
CE1 net5 VSS 1p
CE2 net3 VSS 1p
CI net0 vIN 1p
CO vOUT net1 1p
Q1 net4 net0 net5 VSS qnpn m=1
Q2 net1 net4 net3 VSS qnpn m=1
RB1 VCC net0 1k
RB2 net0 VSS 1k
RC1 VCC net4 1k
RC2 VCC net1 1k
RE1 net5 VSS 1k
RE2 net3 VSS 1k
RL vOUT VSS 1k
RT vIN net2 1k
VT net2 VSS DC 1
.ends dut
