* official Analog Canvas netlist; PDK X cards rewritten by convert.py

.subckt dut VSS
C net0 VSS 1p
I1 net0 VSS DC 1m
L net0 VSS 1n
rc net0 VSS 1k
.ends dut
