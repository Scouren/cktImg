* official Analog Canvas netlist; PDK X cards rewritten by convert.py
.model qnpn npn
.model qpnp pnp

.subckt dut VCC VSS vIN vOUT
CE net0 VSS 1p
CI vIN net7 1p
CO net4 vOUT 1p
Q1 net4 net7 net0 VSS qnpn m=1
Q2 net5 net2 net3 VSS qnpn m=1
Q3 net4 net6 VCC qpnp m=1
Q4 net5 net6 VCC qpnp m=1
Q5 VSS net5 net6 qpnp m=1
RB11 VCC net7 1k
RB12 VCC net2 1k
RB2 net7 VSS 1k
RB22 net2 VSS 1k
RE1 net0 VSS 1k
RE2 net3 VSS 1k
RL vOUT VSS 1k
RT net1 vIN 1k
VT net1 VSS DC 1
.ends dut
