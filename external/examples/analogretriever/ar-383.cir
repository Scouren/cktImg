* official Analog Canvas netlist; PDK X cards rewritten by convert.py

.subckt dut VSS G vfb vo
E1 vfb VSS vo VSS 1
G1 VSS vo G vfb 1m
RL vo VSS 1k
RS net0 G 1k
Vs net0 VSS DC 1
.ends dut
