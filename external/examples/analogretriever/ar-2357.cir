* official Analog Canvas netlist; PDK X cards rewritten by convert.py
.model nch nmos
.model pch pmos

.subckt dut VDD VSS Vb1 Vb2 Vb3 Iout1 Iout2
M1 net0 Vb1 VDD VDD pch l=0.15 w=1 nf=1 m=1
M2 net3 Vb1 VDD VDD pch l=0.15 w=1 nf=1 m=1
M3 net2 net0 VDD VDD pch l=0.15 w=1 nf=1 m=1
M4 Iout1 net2 net0 VDD pch l=0.15 w=1 nf=1 m=1
M5 net2 Vb2 VSS VSS nch l=0.15 w=1 nf=1 m=1
M6 net1 net3 VDD VDD pch l=0.15 w=1 nf=1 m=1
M7 Iout2 net1 net3 VDD pch l=0.15 w=1 nf=1 m=1
M8 net1 Vb3 VSS VSS nch l=0.15 w=1 nf=1 m=1
.ends dut
