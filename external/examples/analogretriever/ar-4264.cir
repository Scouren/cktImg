* official Analog Canvas netlist; PDK X cards rewritten by convert.py
.model qpnp pnp

.subckt dut VCC VEE VSS
Q1 net0 net0 VCC qpnp m=1
Q2A net1 net0 VCC qpnp m=1
Q2B net1 net0 VCC qpnp m=1
R1 net0 VEE 1k
RC2 net1 VSS 1k
.ends dut
