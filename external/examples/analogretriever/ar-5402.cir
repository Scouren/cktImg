* official Analog Canvas netlist; PDK X cards rewritten by convert.py

.subckt dut VSS
C1 net2 net1 0.1uF
C2 net1 VSS 0.047uF
C3 net1 VSS 0.22uF
R1 net1 net0 330Ω
R2 net0 VSS 180Ω
Vs net2 VSS DC 0 SIN(0 1 1k 0 0 0)
.ends dut
