* official Analog Canvas netlist; PDK X cards rewritten by convert.py
.model nch nmos

.subckt dut VDD VSS GND Vo
CC net1 net0 1p
IQ net0 VSS DC 2mA
M1 Vo GND net0 GND nch l=0.15 w=1 nf=1 m=1
RD Vo VDD 1k
Vi net1 GND DC 1
.ends dut
