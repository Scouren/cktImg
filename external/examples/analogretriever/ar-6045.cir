* official Analog Canvas netlist; PDK X cards rewritten by convert.py
.model qnpn npn

.subckt dut VSS vo2 Vin1 Vin2
Q4 VSS Vin1 net0 VSS qnpn m=1
Q5 vo2 Vin2 net0 VSS qnpn m=1
R3 VSS vo2 1k
Ri3 vo2 VSS 1k
.ends dut
