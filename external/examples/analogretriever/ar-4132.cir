* official Analog Canvas netlist; PDK X cards rewritten by convert.py
.model nch nmos

.subckt dut VDD VSS GND vo
CC1 net1 net2 1uF
CC2 net3 vo 2uF
M1 net3 GND net2 GND nch l=0.15 w=1 nf=1 m=1
RD net3 VDD 5kΩ
Ri net0 net1 2kΩ
RL vo GND 4kΩ
RS net2 VSS 10kΩ
vi net0 GND DC 1
.ends dut
