* official Analog Canvas netlist; PDK X cards rewritten by convert.py
.model nch nmos
.model pch pmos

.subckt dut VSS vo vicm
M1 net1 vicm net0 VSS nch l=0.15 w=1 nf=1 m=1
M2 vo vicm net2 VSS nch l=0.15 w=1 nf=1 m=1
M3 net1 net1 VSS VSS pch l=0.15 w=1 nf=1 m=1
M4 vo net1 VSS VSS pch l=0.15 w=1 nf=1 m=1
RSS1 net0 VSS 1k
RSS2 net2 VSS 1k
.ends dut
