* official Analog Canvas netlist; PDK X cards rewritten by convert.py
.model qnpn npn
.model qpnp pnp

.subckt dut VSS Vout
Q13A net0 VSS VSS qpnp m=1
Q18 net0 net1 net2 VSS qnpn m=1
Q19 net0 net0 net1 VSS qnpn m=1
Q20 VSS net2 Vout qpnp m=1
Q23 VSS Vin net2 qpnp m=1
R10 net1 net2 1k
Ro2 Vin VSS 1k
.ends dut
