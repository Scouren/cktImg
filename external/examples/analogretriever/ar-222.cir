* official Analog Canvas netlist; PDK X cards rewritten by convert.py
.model nch nmos

.subckt opamp VDD VSS VIP VIN VOUT params: gain=1e6 vhigh=5 vlow=-5
Blin nlin 0 V={gain*(V(VIP)-V(VIN))}
Bcore VOUT 0 V={0.5*(vhigh+(0.5*(vlow+V(nlin)+sqrt((V(nlin)-vlow)*(V(nlin)-vlow)+(1e-4*(vhigh-vlow))*(1e-4*(vhigh-vlow))+1e-12)))-sqrt((vhigh-(0.5*(vlow+V(nlin)+sqrt((V(nlin)-vlow)*(V(nlin)-vlow)+(1e-4*(vhigh-vlow))*(1e-4*(vhigh-vlow))+1e-12))))*(vhigh-(0.5*(vlow+V(nlin)+sqrt((V(nlin)-vlow)*(V(nlin)-vlow)+(1e-4*(vhigh-vlow))*(1e-4*(vhigh-vlow))+1e-12))))+(1e-4*(vhigh-vlow))*(1e-4*(vhigh-vlow))+1e-12))}
.ends opamp

.subckt dut VSS phi1 phi2 Vs Vo
CI net1 Vo 5pF
CL Vo VSS 2pF
CS Top net0 1pF
M1 Top phi1 VSS VSS nch l=0.15 w=1 nf=1 m=1
M2 net1 phi2 Top VSS nch l=0.15 w=1 nf=1 m=1
M3 net0 phi1 Vs VSS nch l=0.15 w=1 nf=1 m=1
M4 VSS phi2 net0 VSS nch l=0.15 w=1 nf=1 m=1
X1 0 VSS VSS net1 Vo opamp gain=1e6
.ends dut
