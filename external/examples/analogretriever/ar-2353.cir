* official Analog Canvas netlist; PDK X cards rewritten by convert.py
.model nch nmos
.model pch pmos

.subckt dut VDD VSS VOUT- VOUT+ VBIAS3 VREFCM VCMFB
MB12 net1 VBIAS3 VDD VDD pch l=0.15 w=1 nf=1 m=1
MB13 net2 VBIAS3 VDD VDD pch l=0.15 w=1 nf=1 m=1
MC1 net0 VOUT- net1 VDD pch l=0.15 w=1 nf=1 m=1
MC2 VCMFB VREFCM net1 VDD pch l=0.15 w=1 nf=1 m=1
MC3 VCMFB VREFCM net2 VDD pch l=0.15 w=1 nf=1 m=1
MC4 net0 VOUT+ net2 VDD pch l=0.15 w=1 nf=1 m=1
MC5 net0 net0 VSS VSS nch l=0.15 w=1 nf=1 m=1
MC6 VCMFB VCMFB VSS VSS nch l=0.15 w=1 nf=1 m=1
.ends dut
