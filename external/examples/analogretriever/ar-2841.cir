* official Analog Canvas netlist; PDK X cards rewritten by convert.py
.model nch nmos

.subckt dut VSS
In_M1 VSS VSS DC 1m
In_RF VSS VSS DC 1m
M1 VSS VSS VSS VSS nch l=0.15 w=1 nf=1 m=1
RF VSS VSS 1k
.ends dut
