* official Analog Canvas netlist; PDK X cards rewritten by convert.py
.model nch nmos

.subckt dut VDD VSS GND Vin Vout
CO net1 Vout 1p
CS net0 GND 1p
M1 VDD VDD net1 net1 nch l=0.15 w=1 nf=1 m=1
M2 net1 Vin net0 net0 nch l=0.15 w=1 nf=1 m=1
RS net0 VSS 1k
RT net2 Vin 1k
VT net2 GND DC 1
.ends dut
