* official Analog Canvas netlist; PDK X cards rewritten by convert.py

.subckt dut VSS Vo
CC1 net2 net3 1p
CC2 net1 Vo 1p
Cmu net3 net1 1p
Cpi net3 VSS 1p
G1 net1 VSS net3 VSS 1m
RC net1 VSS 1k
RL Vo VSS 1k
Rpi net3 VSS 1k
RS net0 net2 1k
Vi net0 VSS DC 1
.ends dut
