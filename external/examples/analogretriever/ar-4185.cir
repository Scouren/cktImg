* official Analog Canvas netlist; PDK X cards rewritten by convert.py
.model qpnp pnp

.subckt dut VCC VSS VATp VATn
.model DIODE D(IS=1e-14 N=1)
D1 VATp VSS DIODE
D2 VATn VSS DIODE
Q1 net1 net1 VCC qpnp m=1
Q2 VATp net1 VCC qpnp m=1
Q3 net0 net0 VCC qpnp m=1
Q4 VATn net0 VCC qpnp m=1
R1 net1 VSS 1k
R2 net0 VSS 1k
.ends dut
