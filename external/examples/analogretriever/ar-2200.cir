* official Analog Canvas netlist; PDK X cards rewritten by convert.py
.model nch nmos

.subckt dut VDD VSS
M1 net2 net0 net1 VSS nch l=0.15 w=1 nf=1 m=1
R1 VDD net0 10kΩ
R2 VDD net2 1kΩ
R3 net1 VSS 100Ω
.ends dut
