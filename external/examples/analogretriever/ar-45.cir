* official Analog Canvas netlist; PDK X cards rewritten by convert.py

.subckt dut VSS vi vo
G1 1 vo vi 1 1m
Rb 1 VSS 1k
RC vo VSS 1k
Re vi 1 1k
.ends dut
