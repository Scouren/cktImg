* official Analog Canvas netlist; PDK X cards rewritten by convert.py

.subckt dut VSS
L1 net1 net0 50mH
L2 net0 net3 100mH
R1 net2 net1 47Ω
R2 net3 VSS 10Ω
Vs net2 VSS DC 0 SIN(0 5 100 0 0 0)
.ends dut
