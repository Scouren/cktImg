* official Analog Canvas netlist; PDK X cards rewritten by convert.py
.model qnpn npn

.subckt dut VCC VEE VSS Vin Vout1 Vout2
I1 net0 VEE DC 1m
Q1 Vout1 Vin net0 VEE qnpn m=1
Q2 Vout2 VSS net0 VEE qnpn m=1
RC1 VCC Vout1 1k
RC2 VCC Vout2 1k
.ends dut
