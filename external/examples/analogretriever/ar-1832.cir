* official Analog Canvas netlist; PDK X cards rewritten by convert.py
.model nch nmos

.subckt dut VDD VSS Vin Vout
I1 VDD net1 DC 1m
I2 Vout VSS DC 1m
ISS net0 VSS DC 1m
M1 VDD Vin net0 VSS nch l=0.15 w=1 nf=1 m=1
M2 net1 Vout net0 VSS nch l=0.15 w=1 nf=1 m=1
M3 VDD net1 Vout VSS nch l=0.15 w=1 nf=1 m=1
.ends dut
