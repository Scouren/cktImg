* official Analog Canvas netlist; PDK X cards rewritten by convert.py
.model qnpn npn
.model qpnp pnp

.subckt dut VCC VSS vI vO
Q0 vO vI VCC qpnp m=1
Q1 net0 net0 VSS VSS qnpn m=1
Q2 vO net0 VSS VSS qnpn m=1
R1 VCC net0 1k
.ends dut
