* official Analog Canvas netlist; PDK X cards rewritten by convert.py
.model nch nmos

.subckt dut VDD VSS Vo
CC1 net1 net3 10uF
CC2 net0 Vo 10uF
CL Vo VSS 1p
M1 VDD net3 net0 VSS nch l=0.15 w=1 nf=1 m=1
R1 VDD net3 234kΩ
R2 net3 VSS 166kΩ
Ri net2 net1 2kΩ
RL Vo VSS 4kΩ
RS net0 VSS 0.5kΩ
vi net2 VSS DC 1
.ends dut
