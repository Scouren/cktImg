* official Analog Canvas netlist; PDK X cards rewritten by convert.py
.model qnpn npn

.subckt dut VCC VEE VSS von vop
Q1 net0 vin net7 VEE qnpn m=1
Q2 net6 net4 net2 VEE qnpn m=1
Q3 vop net5 net0 VEE qnpn m=1
Q4 von net5 net6 VEE qnpn m=1
R1 VCC net5 1k
R2 net5 VEE 1k
R3 net3 VEE 1k
RE1 net7 net3 1k
RE2 net3 net2 1k
RL1 VCC vop 1k
RL2 VCC von 1k
RS1 net8 vin 1k
RS2 net4 VSS 1k
Vs net8 VSS DC 1
.ends dut
