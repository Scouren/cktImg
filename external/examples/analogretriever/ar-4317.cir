* official Analog Canvas netlist; PDK X cards rewritten by convert.py
.model nch nmos
.model pch pmos

.subckt dut VDD VSS v1 v2 vo VBias
IQ net3 VSS DC 1m
M1 net5 v1 net3 VSS nch l=0.15 w=1 nf=1 m=1
M2 net4 v2 net3 VSS nch l=0.15 w=1 nf=1 m=1
M3 net0 VBias net5 VSS nch l=0.15 w=1 nf=1 m=1
M4 vo VBias net4 VSS nch l=0.15 w=1 nf=1 m=1
M5 net0 net0 net1 VDD pch l=0.15 w=1 nf=1 m=1
M6 vo net0 net2 VDD pch l=0.15 w=1 nf=1 m=1
M7 net1 net1 VDD VDD pch l=0.15 w=1 nf=1 m=1
M8 net2 net1 VDD VDD pch l=0.15 w=1 nf=1 m=1
.ends dut
