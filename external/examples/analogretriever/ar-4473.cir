* official Analog Canvas netlist; PDK X cards rewritten by convert.py
.model nch nmos
.model pch pmos

.subckt dut VDD VSS v1 v2 vo
IQ net0 VSS DC 1m
M1 net1 v1 net0 VSS nch l=0.15 w=1 nf=1 m=1
M2 vo1 v2 net0 VSS nch l=0.15 w=1 nf=1 m=1
M3 vo2 vo1 VDD VDD pch l=0.15 w=1 nf=1 m=1
M4 VDD vo2 vo VSS nch l=0.15 w=1 nf=1 m=1
RD1 VDD net1 1k
RD1B VDD vo1 1k
RD2 vo2 VSS 1k
RS vo VSS 1k
.ends dut
