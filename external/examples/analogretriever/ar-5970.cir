* official Analog Canvas netlist; PDK X cards rewritten by convert.py
.model nch nmos
.model pch pmos

.subckt dut VDD VSS GND VBIAS vo
I1 net1 VSS DC 100uA
M1 vo VBIAS vi GND nch l=0.15 w=1 nf=1 m=1
M2 vo net1 VDD VDD pch l=0.15 w=1 nf=1 m=1
M3 net1 net1 VDD VDD pch l=0.15 w=1 nf=1 m=1
R1 net0 vi 50Ω
vsig net0 GND DC 1
.ends dut
