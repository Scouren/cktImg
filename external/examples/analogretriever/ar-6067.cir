* official Analog Canvas netlist; PDK X cards rewritten by convert.py
.model nch nmos
.model pch pmos

.subckt dut VSS Vin1 Vin2 vo
M1 vg3 Vin1 vs VSS nch l=0.15 w=1 nf=1 m=1
M2 vo Vin2 vs VSS nch l=0.15 w=1 nf=1 m=1
M3 vg3 vg3 VSS VSS pch l=0.15 w=1 nf=1 m=1
M4 vo vg3 VSS VSS pch l=0.15 w=1 nf=1 m=1
R1 VSS vg3 1k
R2 VSS vo 1k
R3 vg3 vs 1k
R4 vo vs 1k
.ends dut
