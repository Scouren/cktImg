* official Analog Canvas netlist; PDK X cards rewritten by convert.py

.subckt dut VSS Vin Vout
C1 net2 VSS 1p
C2 net0 VSS 1p
C3 net1 VSS 1p
C4 Vout VSS 1p
R1 Vin net2 1k
R2 net2 net0 1k
R3 net0 net1 1k
R4 net1 Vout 1k
.ends dut
