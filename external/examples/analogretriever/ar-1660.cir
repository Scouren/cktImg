* official Analog Canvas netlist; PDK X cards rewritten by convert.py
.model nch nmos
.model qnpn npn

.subckt dut VDD VCC VSS Vin Vout Vin2 Vout2
M1 Vout2 net0 VSS VSS nch l=0.15 w=1 nf=1 m=1
Q1 Vout net1 VSS VSS qnpn m=1
RL VCC Vout 1k
RL2 VDD Vout2 1k
RS Vin net1 1k
RS2 Vin2 net0 1k
.ends dut
