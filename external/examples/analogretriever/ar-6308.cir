* official Analog Canvas netlist; PDK X cards rewritten by convert.py

.subckt dut VSS vI vO
C1 net0 VSS 1p
C2 net1 VSS 1p
C3 vO VSS 1p
R1 vI net0 1k
R2 net0 net1 1k
R3 net1 vO 1k
.ends dut
