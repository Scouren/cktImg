* official Analog Canvas netlist; PDK X cards rewritten by convert.py
.model nch nmos
.model pch pmos

.subckt dut VDD VSS phi A B C Y
M1 Y A net1 VSS nch l=0.15 w=1 nf=1 m=1
M2 Y B net0 VSS nch l=0.15 w=1 nf=1 m=1
M3 net0 C net1 VSS nch l=0.15 w=1 nf=1 m=1
Me net1 phi VSS VSS nch l=0.15 w=1 nf=1 m=1
Mp Y phi VDD VDD pch l=0.15 w=1 nf=1 m=1
.ends dut
