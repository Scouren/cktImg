* official Analog Canvas netlist; PDK X cards rewritten by convert.py
.model qnpn npn

.subckt dut VSS Vin1 Vin2 Q1_C Vb
IEE P VSS DC 1m
Q1 Q1_C Vin1 P VSS qnpn m=1
Q2 net0 Vin2 P VSS qnpn m=1
RL net0 Vb 1k
.ends dut
