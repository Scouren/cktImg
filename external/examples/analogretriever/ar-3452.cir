* official Analog Canvas netlist; PDK X cards rewritten by convert.py
.model nch nmos
.model qnpn npn

.subckt dut VCC VSS vin vout
CE net1 VSS 1p
CI vin net2 1p
Co net0 vout 1p
M2 VCC VCC net0 VSS nch l=0.15 w=1 nf=1 m=1
Q1 net0 net2 net1 VSS qnpn m=1
R1 VCC net2 1k
R2 net2 VSS 1k
R3 net1 VSS 1k
.ends dut
