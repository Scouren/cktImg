* official Analog Canvas netlist; PDK X cards rewritten by convert.py
.model nch nmos

.subckt dut VDD VSS GND vO
CC net2 net3 1p
CG GND net0 1p
CS net4 GND 1p
M1 net1 net3 net4 VSS nch l=0.15 w=1 nf=1 m=1
M2 vO net0 net1 VSS nch l=0.15 w=1 nf=1 m=1
R1 VDD net0 1k
R2 net0 net3 1k
R3 net3 GND 1k
RD VDD vO 1k
RS net4 VSS 1k
vi net2 GND DC 1
.ends dut
