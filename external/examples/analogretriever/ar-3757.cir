* official Analog Canvas netlist; PDK X cards rewritten by convert.py
.model nch nmos

.subckt dut VDD VSS vO
CC net0 net1 1p
M1 VDD net1 vO VSS nch l=0.15 w=1 nf=1 m=1
R1 VDD net1 1k
R2 net1 VSS 1k
RS vO VSS 1k
RSi net2 net0 1k
Vi net2 VSS DC 1
.ends dut
