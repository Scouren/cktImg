* official Analog Canvas netlist; PDK X cards rewritten by convert.py
.model nch nmos
.model qpnp pnp

.subckt dut VCC VEE VSS vIN1 vIN2 Vout
IBIAS1 net5 VEE DC 1m
IBIAS2 Vout VEE DC 1m
M1 net3 vIN2 net5 VSS nch l=0.15 w=1 nf=1 m=1
M2 net1 vIN1 net5 VSS nch l=0.15 w=1 nf=1 m=1
Q5 net1 net1 net4 qpnp m=1
Q5A net4 net0 VCC qpnp m=1
Q6 net3 net1 net0 qpnp m=1
Q6A net0 net0 VCC qpnp m=1
Q7 Vout net2 VCC qpnp m=1
Q7A VSS net3 net2 qpnp m=1
R2 VCC net2 1k
.ends dut
