* official Analog Canvas netlist; PDK X cards rewritten by convert.py

.subckt dut A B
R1 A B 1.0kΩ
R2 A B 2.2kΩ
R3 A B 820Ω
R4 A B 2.7kΩ
R5 A B 1.0kΩ
.ends dut
