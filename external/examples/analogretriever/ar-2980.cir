* official Analog Canvas netlist; PDK X cards rewritten by convert.py
.model nch nmos

.subckt dut VDD VSS VX
C1 net0 P 1p
C2 P VSS 1p
I1 net0 VX DC 1m
M1 VX P VSS VSS nch l=0.15 w=1 nf=1 m=1
RD VDD net0 1k
RT VX VSS 1k
.ends dut
