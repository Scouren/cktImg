* official Analog Canvas netlist; PDK X cards rewritten by convert.py
.model nch nmos

.subckt dut VDD VSS
ISS net0 VSS DC 1m
M1 X net1 net0 VSS nch l=0.15 w=1 nf=1 m=1
M2 Y net1 net0 VSS nch l=0.15 w=1 nf=1 m=1
RD1 VDD X 1k
RD2 VDD Y 1k
VCM net1 VSS DC 1
.ends dut
