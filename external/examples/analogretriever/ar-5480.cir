* official Analog Canvas netlist; PDK X cards rewritten by convert.py
.model qnpn npn
.model qpnp pnp

.subckt dut VCC VSS Vout
.model DIODE D(IS=1e-14 N=1)
C1 net3 net0 1p
C2 net1 net0 1p
C3 Vout net2 1p
D1 net3 A DIODE
D2 A net1 DIODE
Q1 VCC net3 net2 VSS qnpn m=1
Q2 VSS net1 net2 qpnp m=1
R1 VCC net3 1k
R2 net1 VSS 1k
RL Vout VSS 1k
Vin net0 VSS DC 1 SIN(0 1 1k 0 0 0)
.ends dut
