* official Analog Canvas netlist; PDK X cards rewritten by convert.py
.model nch nmos

.subckt dut VDD VSS Vout
Iin VSS X DC 1m
M1 Vout X VSS VSS nch l=0.15 w=1 nf=1 m=1
M2 X Vout VSS VSS nch l=0.15 w=1 nf=1 m=1
RD1 VDD Vout 1k
.ends dut
