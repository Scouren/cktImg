* official Analog Canvas netlist; PDK X cards rewritten by convert.py
.model nch nmos

.subckt dut VDD VSS GND V1 V2 V3
I1 V3 VSS DC 200uA
M1 V1 GND V3 GND nch l=0.15 w=1 nf=1 m=1
M2 V2 GND V3 GND nch l=0.15 w=1 nf=1 m=1
R1 VDD V1 20kΩ
R2 VDD V2 20kΩ
.ends dut
