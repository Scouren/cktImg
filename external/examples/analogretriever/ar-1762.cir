* official Analog Canvas netlist; PDK X cards rewritten by convert.py
.model nch nmos
.model pch pmos

.subckt dut VDD VSS Vin Vout
C1 Vin net0 1pF
M1 net1 net2 VSS VSS nch l=0.15 w=1 nf=1 m=1
M2 net1 net2 VDD VDD pch l=0.15 w=1 nf=1 m=1
M3 Vout net1 VSS VSS nch l=0.15 w=1 nf=1 m=1
M4 Vout net1 VDD VDD pch l=0.15 w=1 nf=1 m=1
R1 net0 net2 1kΩ
RF net2 net1 1k
.ends dut
