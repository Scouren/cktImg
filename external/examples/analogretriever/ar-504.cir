* official Analog Canvas netlist; PDK X cards rewritten by convert.py
.model nch nmos
.model qnpn npn

.subckt dut VDD VSS Vi Vo
M1 VDD Vi net0 VSS nch l=0.15 w=1 nf=1 m=1
Q1 Vo net0 net1 VSS qnpn m=1
R1 net0 VSS 300Ω
R2 net1 VSS 100Ω
R3 VDD Vo 2kΩ
.ends dut
