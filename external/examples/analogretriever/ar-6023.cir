* official Analog Canvas netlist; PDK X cards rewritten by convert.py

.subckt dut VSS vo1 vo2 g1 g2
G1 vo1 g1 g1 net0 1m
G2 vo2 g2 g2 net0 1m
R1 g1 net0 1k
R2 g2 net0 1k
RD1 VSS vo1 1k
RD2 VSS vo2 1k
RSS net0 VSS 1k
Vicm1 g1 VSS DC 1
Vicm2 g2 VSS DC 1
.ends dut
