* official Analog Canvas netlist; PDK X cards rewritten by convert.py
.model qnpn npn
.model qpnp pnp

.subckt dut VCC VSS
Q1 VCC VCC net2 VSS qnpn m=1
Q2 net0 net1 net2 qpnp m=1
R1 net0 VSS 300Ω
R2 net1 VSS 80kΩ
.ends dut
