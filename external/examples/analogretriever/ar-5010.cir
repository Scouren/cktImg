* official Analog Canvas netlist; PDK X cards rewritten by convert.py

.subckt put a g k
.model qn NPN(IS=1e-16 BF=100 VAF=100)
.model qp PNP(IS=1e-16 BF=50 VAF=50)
Q1 nk g a qp
Q2 g nk k qn
RGK nk k 1Meg
CGK nk k 10p
.ends put

.subckt dut VCC VSS Vin Vout
C1 Vin VSS 1p
R1 VCC Vin 1k
R2 VCC net0 1k
R3 net0 VSS 1k
R4 Vout VSS 1k
X1 Vin net0 Vout put
.ends dut
