* official Analog Canvas netlist; PDK X cards rewritten by convert.py
.model nch nmos

.subckt dut VDD VSS GND
CC1 net2 net0 1p
CS net3 GND 1p
M1 net4 net0 net3 GND nch l=0.15 w=1 nf=1 m=1
R1 VDD net0 150kΩ
R2 net0 VSS 50kΩ
RD VDD net4 5kΩ
Ri net1 net2 20kΩ
RS net3 VSS 2kΩ
vi net1 GND DC 1
.ends dut
