* official Analog Canvas netlist; PDK X cards rewritten by convert.py

.subckt dut VSS vo
Cin v1 VSS 1p
CM v1 VSS 1p
G1 vo VSS v1 VSS 1m
rin v1 VSS 1k
RL vo VSS 1k
RS net1 net0 1k
rx net0 v1 1k
vi net1 VSS DC 1
.ends dut
