* official Analog Canvas netlist; PDK X cards rewritten by convert.py
.model nch nmos
.model pch pmos

.subckt dut VDD VSS GND Vin+ Vin- VBIAS1 vo
CL vo GND 1p
I1 net4 VSS DC 1m
IB1 VDD net3 DC 1m
IB2 VDD net1 DC 1m
M1 net3 Vin+ net4 VSS nch l=0.15 w=1 nf=1 m=1
M2 net1 Vin- net4 VSS nch l=0.15 w=1 nf=1 m=1
M3 net2 VBIAS1 net3 VDD pch l=0.15 w=1 nf=1 m=1
M4 vo VBIAS1 net1 VDD pch l=0.15 w=1 nf=1 m=1
M5 net2 net2 net0 VSS nch l=0.15 w=1 nf=1 m=1
M6 vo net2 net5 VSS nch l=0.15 w=1 nf=1 m=1
M7 net0 net0 VSS VSS nch l=0.15 w=1 nf=1 m=1
M8 net5 net0 VSS VSS nch l=0.15 w=1 nf=1 m=1
.ends dut
