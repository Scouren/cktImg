* official Analog Canvas netlist; PDK X cards rewritten by convert.py

.subckt dut VSS Vin
ic net0 Vin DC 1m
R1 Vin net1 1k
rc net0 VSS 1k
re net1 VSS 1k
.ends dut
