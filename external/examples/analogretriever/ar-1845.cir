* official Analog Canvas netlist; PDK X cards rewritten by convert.py
.model nch nmos
.model pch pmos

.subckt dut VDD VSS Vout Vin
M1 net0 Vout Vin VSS nch l=0.15 w=1 nf=1 m=1
M2 Vout net0 VDD VDD pch l=0.15 w=1 nf=1 m=1
M3 net0 net0 VDD VDD pch l=0.15 w=1 nf=1 m=1
R1 Vout VSS 1k
.ends dut
