* official Analog Canvas netlist; PDK X cards rewritten by convert.py

.subckt dut VSS
VB1 A VSS DC 10V
R1 A B 1.0kΩ
R2 A B 2.2kΩ
R3 B VSS 1.8kΩ
R4 B net0 330Ω
R5 net0 VSS 680Ω
.ends dut
