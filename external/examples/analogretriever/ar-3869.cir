* official Analog Canvas netlist; PDK X cards rewritten by convert.py
.model qnpn npn

.subckt dut VCC VEE VSS vO
CC net2 net0 1p
Q1 vO net0 net1 VEE qnpn m=1
R1 VCC net0 1k
R2 net0 VEE 1k
RC VCC vO 1k
RE net1 VEE 1k
Vs net2 VSS DC 1
.ends dut
