* official Analog Canvas netlist; PDK X cards rewritten by convert.py
.model qnpn npn

.subckt dut VCC VSS vX VR vO
IQ net0 VSS DC 1m
Q1 VCC vX net0 VSS qnpn m=1
Q2 vO VR net0 VSS qnpn m=1
RL VCC vO 1k
.ends dut
