* official Analog Canvas netlist; PDK X cards rewritten by convert.py
.model qnpn npn

.subckt dut VCC VSS
C1 net3 net1 1p
C2 net0 net2 1p
I1 net0 VSS DC 1m
Q1 VCC net1 net0 VSS qnpn m=1
RB VCC net1 1k
RL net2 VSS 1k
vin net3 VSS DC 1
.ends dut
