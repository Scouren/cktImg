* official Analog Canvas netlist; PDK X cards rewritten by convert.py
.model qnpn npn

.subckt dut VCC VEE VSS V2 V1
I1 V1 VEE DC 0.5mA
Q1 V2 net0 V1 VEE qnpn m=1
R1 VSS net0 43kΩ
R2 VCC V2 3.6kΩ
.ends dut
