* official Analog Canvas netlist; PDK X cards rewritten by convert.py

.subckt opamp VDD VSS VIP VIN VOUT params: gain=1e6 vhigh=5 vlow=-5
Blin nlin 0 V={gain*(V(VIP)-V(VIN))}
Bcore VOUT 0 V={0.5*(vhigh+(0.5*(vlow+V(nlin)+sqrt((V(nlin)-vlow)*(V(nlin)-vlow)+(1e-4*(vhigh-vlow))*(1e-4*(vhigh-vlow))+1e-12)))-sqrt((vhigh-(0.5*(vlow+V(nlin)+sqrt((V(nlin)-vlow)*(V(nlin)-vlow)+(1e-4*(vhigh-vlow))*(1e-4*(vhigh-vlow))+1e-12))))*(vhigh-(0.5*(vlow+V(nlin)+sqrt((V(nlin)-vlow)*(V(nlin)-vlow)+(1e-4*(vhigh-vlow))*(1e-4*(vhigh-vlow))+1e-12))))+(1e-4*(vhigh-vlow))*(1e-4*(vhigh-vlow))+1e-12))}
.ends opamp

.subckt dut VSS vO
C1 net7 VSS 1p
C2 net3 VSS 1p
C3 net5 VSS 1p
R1 vO net7 1k
R2 net4 net3 1k
R3 net1 net5 1k
RA1 VSS net0 1k
RA2 VSS net6 1k
RA3 net5 net2 1k
RF1 net0 net4 1k
RF2 net6 net1 1k
RF3 net2 vO 1k
X1 0 VSS net7 net0 net4 opamp gain=1e6
X2 0 VSS net3 net6 net1 opamp gain=1e6
X3 0 VSS VSS net2 vO opamp gain=1e6
.ends dut
