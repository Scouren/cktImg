* official Analog Canvas netlist; PDK X cards rewritten by convert.py
.model qnpn npn
.model qpnp pnp

.subckt dut VCC VEE VSS vO
.model DIODE D(IS=1e-14 N=1)
C net2 net0 1p
D1 net1 net0 DIODE
D2 net0 net3 DIODE
Qn VCC net1 vO VEE qnpn m=1
Qp VEE net3 vO qpnp m=1
R1 VCC net1 1k
R2 net3 VEE 1k
RL vO VSS 8Ω
vS net2 VSS DC 1
.ends dut
