* official Analog Canvas netlist; PDK X cards rewritten by convert.py
.model qnpn npn
.model qpnp pnp

* Potentiometer: end 1 to wiper r*pos, wiper to end 2 r*(1-pos)
.subckt potentiometer n1 nw n2 params: r=10k pos=0.5
R1 n1 nw {max(r*pos,1m)}
R2 nw n2 {max(r*(1-pos),1m)}
.ends potentiometer

.subckt dut VCC VEE v1 v2 Null1 Null2
IQ VCC 3 DC 1m
Q1 net0 v1 3 qpnp m=1
Q2 net1 v2 3 qpnp m=1
Q3 net0 net0 Null1 VEE qnpn m=1
Q4 net1 net0 Null2 VEE qnpn m=1
R1 Null1 VEE 1k
R2 Null2 VEE 1k
X1 Null2 VEE Null1 potentiometer pos=0.5 r=10k
.ends dut
