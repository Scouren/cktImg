* official Analog Canvas netlist; PDK X cards rewritten by convert.py
.model nch nmos

.subckt dut VDD VSS GND vo
CC net5 net1 1p
CC2 net2 vo 1p
CS net0 VSS 1p
M1 net3 net1 net0 VSS nch l=0.15 w=1 nf=1 m=1
M2 VDD net3 net2 VSS nch l=0.15 w=1 nf=1 m=1
R1 VDD net1 1k
R2 net1 VSS 1k
RD1 VDD net3 1k
RL vo GND 4kΩ
RS1 net0 VSS 1k
RS2 net2 VSS 1k
RSi net4 net5 1k
vi net4 GND DC 1
.ends dut
