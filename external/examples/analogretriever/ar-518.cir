* official Analog Canvas netlist; PDK X cards rewritten by convert.py

.subckt dut VSS vo1 vo2
V1 vo1 net1 DC 1
V2 net1 vo2 DC 1
V3 net1 net0 DC 1
V4 net0 VSS DC 1
.ends dut
