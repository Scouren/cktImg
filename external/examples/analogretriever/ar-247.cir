* official Analog Canvas netlist; PDK X cards rewritten by convert.py
.model nch nmos
.model pch pmos

.subckt dut VDD VSS P N O VBIAS4
M21 net1 P net0 VSS nch l=0.15 w=1 nf=1 m=1
M22 O N net0 VSS nch l=0.15 w=1 nf=1 m=1
M23 net1 net1 VDD VDD pch l=0.15 w=1 nf=1 m=1
M24 O net1 VDD VDD pch l=0.15 w=1 nf=1 m=1
M25 net0 VBIAS4 VSS VSS nch l=0.15 w=1 nf=1 m=1
.ends dut
