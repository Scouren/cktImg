* official Analog Canvas netlist; PDK X cards rewritten by convert.py
.model nch nmos

.subckt dut VDD VSS GND vD1 vD2
I1 vS VSS DC 1m
M1 vD1 Vin vS GND nch l=0.15 w=1 nf=1 m=1
M2 vD2 GND vS GND nch l=0.15 w=1 nf=1 m=1
RD1 VDD vD1 1k
RD2 VDD vD2 1k
vid Vin GND DC 1
.ends dut
