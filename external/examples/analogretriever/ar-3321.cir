* official Analog Canvas netlist; PDK X cards rewritten by convert.py
.model nch nmos

.subckt dut VDD VSS Vout Vin
C1 Vout VSS 1p
C2 VDD VSS 1p
M1 Vout Vin VSS VSS nch l=0.15 w=1 nf=1 m=1
R1 VDD Vout 1k
.ends dut
