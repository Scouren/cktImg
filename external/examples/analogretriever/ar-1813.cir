* official Analog Canvas netlist; PDK X cards rewritten by convert.py
.model nch nmos

.subckt dut VDD VSS Vin VF1 VF2
M1 X VF1 Vin VSS nch l=0.15 w=1 nf=1 m=1
M2 VDD X net0 VSS nch l=0.15 w=1 nf=1 m=1
RD VDD X 1k
RL net0 VF2 1k
RM1 VF1 VSS 1k
RM2 VF2 VSS 1k
.ends dut
