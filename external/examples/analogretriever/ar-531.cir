* official Analog Canvas netlist; PDK X cards rewritten by convert.py
.model nch nmos
.model pch pmos

.subckt dut VSS vcmc vic voc
C net0 voc 1p
M2 net0 vic net1 VSS pch l=0.15 w=1 nf=1 m=1
M5h net1 vcmc VSS VSS pch l=0.15 w=1 nf=1 m=1
M6 voc net0 VSS VSS nch l=0.15 w=1 nf=1 m=1
ro4 net0 VSS 1k
ro7 VSS voc 1k
.ends dut
