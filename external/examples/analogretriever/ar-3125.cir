* official Analog Canvas netlist; PDK X cards rewritten by convert.py
.model nch nmos
.model pch pmos

.subckt dut VDD VSS Vin1 Vin2 Vb Vout
CX X VSS 1p
CY Vout VSS 1p
I1 Vout VSS DC 1m
ISS net0 VSS DC 1m
M1 VDD Vin1 net0 VSS nch l=0.15 w=1 nf=1 m=1
M2 X Vin2 net0 VSS nch l=0.15 w=1 nf=1 m=1
M3 X Vb VDD VDD pch l=0.15 w=1 nf=1 m=1
M4 VDD X Vout VSS nch l=0.15 w=1 nf=1 m=1
.ends dut
