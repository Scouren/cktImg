* official Analog Canvas netlist; PDK X cards rewritten by convert.py
.model nch nmos
.model pch pmos

.subckt dut VDD VSS GND
VB1 net5 VSS DC 1
I1 VDD net2 DC 1m
M1 net0 net4 net2 VDD pch l=0.15 w=1 nf=1 m=1
M2 net5 net3 net2 VDD pch l=0.15 w=1 nf=1 m=1
M3 net0 net6 VSS VSS nch l=0.15 w=1 nf=1 m=1
M4 net5 net1 VSS VSS nch l=0.15 w=1 nf=1 m=1
Veq1 net4 GND DC 1
Veq2 net3 GND DC 1
Veq3 net0 net6 DC 1
Veq4 net0 net1 DC 1
.ends dut
