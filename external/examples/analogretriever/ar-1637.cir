* official Analog Canvas netlist; PDK X cards rewritten by convert.py
.model nch nmos

.subckt dut VDD VSS Vin1 Vin2
CF1 Vin1 Y 1p
CF2 X Vin2 1p
I1 net0 VSS DC 1m
M1 X Vin1 net0 VSS nch l=0.15 w=1 nf=1 m=1
M2 Y Vin2 net0 VSS nch l=0.15 w=1 nf=1 m=1
RD1 VDD X 1k
RD2 VDD Y 1k
.ends dut
