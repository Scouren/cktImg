* official Analog Canvas netlist; PDK X cards rewritten by convert.py

.subckt icm_opamp_vdd_vss VDD VSS VIP VIN VOUT params: gain=1e6
Blin nlin 0 V={gain*(V(VIP)-V(VIN))}
Bcore VOUT 0 V={0.5*(V(VDD)+(0.5*(V(VSS)+V(nlin)+sqrt((V(nlin)-V(VSS))*(V(nlin)-V(VSS))+(1e-4*(V(VDD)-V(VSS)))*(1e-4*(V(VDD)-V(VSS)))+1e-12)))-sqrt((V(VDD)-(0.5*(V(VSS)+V(nlin)+sqrt((V(nlin)-V(VSS))*(V(nlin)-V(VSS))+(1e-4*(V(VDD)-V(VSS)))*(1e-4*(V(VDD)-V(VSS)))+1e-12))))*(V(VDD)-(0.5*(V(VSS)+V(nlin)+sqrt((V(nlin)-V(VSS))*(V(nlin)-V(VSS))+(1e-4*(V(VDD)-V(VSS)))*(1e-4*(V(VDD)-V(VSS)))+1e-12))))+(1e-4*(V(VDD)-V(VSS)))*(1e-4*(V(VDD)-V(VSS)))+1e-12))}
.ends icm_opamp_vdd_vss

.subckt dut VCC VEE VSS vin A
.model DIODE D(IS=1e-14 N=1)
C1 A VSS 1p
D1 net0 A DIODE
RL A VSS 1k
X1 VCC VEE vin A net0 icm_opamp_vdd_vss gain=1e6
.ends dut
