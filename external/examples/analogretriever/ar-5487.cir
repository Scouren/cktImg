* official Analog Canvas netlist; PDK X cards rewritten by convert.py

.subckt dut VDD VSS Vout
.model NMOS nmos level=54
C1 net0 net2 1p
C2 Vout net1 1p
M1 net1 net0 VSS VSS NMOS l=150n m=1 nf=1 w=1u
RD VDD net1 1k
RG net0 VSS 1k
Vin net2 VSS DC 1 SIN(0 1 1k 0 0 0)
.ends dut
