* official Analog Canvas netlist; PDK X cards rewritten by convert.py
.model nch nmos
.model pch pmos

.subckt dut VDD VSS in- in+ VBB Vo
C net3 Vo 1p
I1 VDD net2 DC 1m
I3 VDD Vo DC 1m
M1 net1 in- net2 VDD pch l=0.15 w=1 nf=1 m=1
M2 Y in+ net2 VDD pch l=0.15 w=1 nf=1 m=1
M3 net1 VBB net0 VSS nch l=0.15 w=1 nf=1 m=1
M4 Y VBB net3 VSS nch l=0.15 w=1 nf=1 m=1
M5 net0 net1 VSS VSS nch l=0.15 w=1 nf=1 m=1
M6 net3 net1 VSS VSS nch l=0.15 w=1 nf=1 m=1
M7 Vo Y VSS VSS nch l=0.15 w=1 nf=1 m=1
.ends dut
