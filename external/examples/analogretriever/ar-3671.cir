* official Analog Canvas netlist; PDK X cards rewritten by convert.py

.subckt dut VSS V1 V2 V3 VO2
.model DIODE D(IS=1e-14 N=1)
D1 V1 VO1 DIODE
D2 V2 VO1 DIODE
D3 VO1 VO2 DIODE
D4 V3 VO2 DIODE
R1 VO1 VSS 10kΩ
R2 VO2 VSS 10kΩ
.ends dut
