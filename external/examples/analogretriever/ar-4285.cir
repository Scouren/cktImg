* official Analog Canvas netlist; PDK X cards rewritten by convert.py
.model nch nmos

.subckt dut VDD VSS Iout1 Iout2
M1 Iout1 net0 VSS VSS nch l=0.15 w=1 nf=1 m=1
M2 Iout2 net0 VSS VSS nch l=0.15 w=1 nf=1 m=1
M3 net0 net0 VSS VSS nch l=0.15 w=1 nf=1 m=1
M4 net1 net1 net0 VSS nch l=0.15 w=1 nf=1 m=1
M5 VDD VDD net1 VSS nch l=0.15 w=1 nf=1 m=1
.ends dut
