* official Analog Canvas netlist; PDK X cards rewritten by convert.py
.model qnpn npn

.subckt dut VSS Vin
.model icm_zener_DZ D(BV=5.1)
DZ net1 net0 icm_zener_DZ
Q1 net0 net1 VSS VSS qnpn m=1
RL net0 VSS 1k
RS Vin net0 1k
.ends dut
