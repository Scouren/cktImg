* official Analog Canvas netlist; PDK X cards rewritten by convert.py
.model nch nmos

.subckt dut VDD VSS Vin Vout
Ci Y X 1p
I1 Vout VSS DC 1m
M1 VDD X Vout VSS nch l=0.15 w=1 nf=1 m=1
M2 Y Vin VSS VSS nch l=0.15 w=1 nf=1 m=1
RD VDD Y 1k
Ri VDD X 1k
.ends dut
