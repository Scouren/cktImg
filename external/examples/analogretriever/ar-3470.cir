* official Analog Canvas netlist; PDK X cards rewritten by convert.py

.subckt dut Vin+ Vin-
G1 net0 Vin- Vin+ Vin- 1m
G2 net0 Vin- net0 Vin- 1m
R1 Vin+ Vin- 1k
R2 net0 Vin- 1k
R3 net0 Vin- 1k
R4 net0 Vin- 1k
.ends dut
