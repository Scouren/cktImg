* official Analog Canvas netlist; PDK X cards rewritten by convert.py
.model nch nmos

.subckt dut VSS Vo
Cgd Vo net2 1p
Cgs net2 net1 1p
CL Vo VSS 1p
M1 Vo net2 net1 VSS nch l=0.15 w=1 nf=1 m=1
RL Vo VSS 1k
Rs net1 VSS 1k
Rsig net0 net2 1k
Vsig net0 VSS DC 1
.ends dut
