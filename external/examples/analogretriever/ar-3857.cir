* official Analog Canvas netlist; PDK X cards rewritten by convert.py
.model qnpn npn

.subckt dut VCC VSS V1 V2 VO
Q1 VO net1 VSS VSS qnpn m=1
Q2 VO net0 VSS VSS qnpn m=1
RB1 V1 net1 1k
RB2 V2 net0 1k
RC VCC VO 1k
.ends dut
