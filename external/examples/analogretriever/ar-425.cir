* official Analog Canvas netlist; PDK X cards rewritten by convert.py

.subckt dut VSS vo
C net0 vo 1p
C1 v1 VSS 1p
C2 vo VSS 1p
G1 vo VSS v1 VSS 1m
Is v1 VSS DC 1m
R1 v1 VSS 1k
R2 vo VSS 1k
RZ v1 net0 1k
.ends dut
