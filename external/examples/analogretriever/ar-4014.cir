* official Analog Canvas netlist; PDK X cards rewritten by convert.py
.model qnpn npn

.subckt dut VCC VSS vo
CC1 net1 net2 1p
CC2 VE vo 1p
Q1 VCC net2 VE VSS qnpn m=1
RB VCC net2 100kΩ
RE VE VSS 1kΩ
RL vo VSS 1kΩ
RS net0 net1 10kΩ
vs net0 VSS DC 1
.ends dut
