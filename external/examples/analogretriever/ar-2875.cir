* official Analog Canvas netlist; PDK X cards rewritten by convert.py
.model nch nmos

.subckt dut VDD VSS Vin1 Vin2 Vout1 Vout2
ISS net2 VSS DC 1m
M1 Vout1 net1 net2 VSS nch l=0.15 w=1 nf=1 m=1
M2 Vout2 net3 net2 VSS nch l=0.15 w=1 nf=1 m=1
RD1 net0 Vout1 1k
RD2 net4 Vout2 1k
Vn_RD1 VDD net0 DC 1
Vn_RD2 VDD net4 DC 1
Vn1 net1 Vin1 DC 1
Vn2 Vin2 net3 DC 1
.ends dut
