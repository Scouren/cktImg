* official Analog Canvas netlist; PDK X cards rewritten by convert.py
.model nch nmos
.model pch pmos

.subckt dut VDD VSS GND Iout1 Iout2 Iout3 Iout4 Iout5 Iout6 Iout7
I1 net1 GND DC 10uA
M1 net10 net14 VDD VDD pch l=1 w=20 nf=1 m=1
M10 Iout2 net1 net4 VDD pch l=1 w=80 nf=1 m=1
M11 net7 net14 VDD VDD pch l=1 w=5 nf=1 m=1
M12 Iout3 net1 net7 VDD pch l=1 w=20 nf=1 m=1
M13 net5 net5 net11 VSS nch l=1 w=128 nf=1 m=1
M14 net11 net5 VSS VSS nch l=1 w=1 nf=1 m=1
M15 net9 net5 net6 VSS nch l=1 w=128 nf=1 m=1
M16 net6 net9 VSS VSS nch l=1 w=32 nf=1 m=1
M17 Iout4 net5 net13 VSS nch l=1 w=128 nf=1 m=1
M18 net13 net9 VSS VSS nch l=1 w=32 nf=1 m=1
M19 Iout5 net5 net2 VSS nch l=1 w=128 nf=1 m=1
M2 net14 net1 net10 VDD pch l=1 w=80 nf=1 m=1
M20 net2 net9 VSS VSS nch l=1 w=32 nf=1 m=1
M21 Iout6 net5 net3 VSS nch l=1 w=64 nf=1 m=1
M22 net3 net9 VSS VSS nch l=1 w=16 nf=1 m=1
M23 Iout7 net5 net12 VSS nch l=1 w=32 nf=1 m=1
M24 net12 net9 VSS VSS nch l=1 w=8 nf=1 m=1
M3 net0 net14 VDD VDD pch l=1 w=10 nf=1 m=1
M4 net5 net1 net0 VDD pch l=1 w=40 nf=1 m=1
M5 net15 net14 VDD VDD pch l=1 w=20 nf=1 m=1
M6 net9 net1 net15 VDD pch l=1 w=80 nf=1 m=1
M7 net8 net14 VDD VDD pch l=1 w=20 nf=1 m=1
M8 Iout1 net1 net8 VDD pch l=1 w=80 nf=1 m=1
M9 net4 net14 VDD VDD pch l=1 w=20 nf=1 m=1
R1 net14 net1 20kΩ
.ends dut
