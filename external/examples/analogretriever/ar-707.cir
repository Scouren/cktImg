* official Analog Canvas netlist; PDK X cards rewritten by convert.py

.subckt dut VSS Vin Vout
.model DIODE D(IS=1e-14 N=1)
D1 Vin net0 DIODE
D2 Vout net0 DIODE
R1 net0 Vout 1k
R2 Vout VSS 1k
.ends dut
