* official Analog Canvas netlist; PDK X cards rewritten by convert.py
.model nch nmos

.subckt dut VDD VSS Vo
C1 Vo VSS 2pF
I1 VDD Vo DC 0.5mA
is VSS net0 DC 1m
M1 Vo net0 VSS VSS nch l=0.15 w=1 nf=1 m=1
R1 net0 Vo 20kΩ
.ends dut
