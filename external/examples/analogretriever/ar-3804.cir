* official Analog Canvas netlist; PDK X cards rewritten by convert.py
.model pch pmos

.subckt dut VDD VSS vo
CC1 net1 net2 1p
CC2 net0 vo 1p
M1 VSS net2 net0 VDD pch l=0.15 w=1 nf=1 m=1
R1 VDD net2 1k
R2 net2 VSS 1k
RL vo VSS 1k
RS VDD net0 1k
Vi net1 VSS DC 1
.ends dut
