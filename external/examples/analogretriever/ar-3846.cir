* official Analog Canvas netlist; PDK X cards rewritten by convert.py
.model qnpn npn

.subckt dut VCC VEE VBB
Q1 net1 net0 net2 VEE qnpn m=1
RB VBB net0 560kΩ
RC VCC net1 7kΩ
RE net2 VEE 3kΩ
.ends dut
