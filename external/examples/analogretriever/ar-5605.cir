* official Analog Canvas netlist; PDK X cards rewritten by convert.py

.subckt dut VDD vA vB vC vY
.model DIODE D(IS=1e-14 N=1)
D1 vY vA DIODE
D2 vY vB DIODE
D3 vY vC DIODE
R VDD vY 1k
.ends dut
