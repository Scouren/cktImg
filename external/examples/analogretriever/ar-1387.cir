* official Analog Canvas netlist; PDK X cards rewritten by convert.py
.model qnpn npn

.subckt dut VCC VSS Iout1 Iout2
IREF VCC net0 DC 0.25mA
Q1 Iout1 net0 VSS VSS qnpn m=1
Q2 Iout1 net0 VSS VSS qnpn m=1
Q3 Iout1 net0 VSS VSS qnpn m=1
Q4 Iout2 net0 VSS VSS qnpn m=1
Q5 Iout2 net0 VSS VSS qnpn m=1
QREF net0 net0 VSS VSS qnpn m=1
.ends dut
