* official Analog Canvas netlist; PDK X cards rewritten by convert.py
.model qpnp pnp

.subckt dut VSS
Q25 VSS net2 net1 qpnp m=1
Q26 26 net2 net1 qpnp m=1
Q27 VSS net0 net1 qpnp m=1
Q28 VSS net0 net1 qpnp m=1
Rin3_25 VSS VSS 1k
Rin3_26 26 VSS 1k
Rup2 VSS VSS 5MegΩ
Rup2b VSS 26 5MegΩ
V1 net2 VSS DC 1
V2 net0 VSS DC 1
.ends dut
