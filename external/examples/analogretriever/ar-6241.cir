* official Analog Canvas netlist; PDK X cards rewritten by convert.py
.model nch nmos
.model pch pmos

.subckt dut VDD VSS GND Vin+ Vin- VBIAS1 VBIAS2 VBIAS3 vO
CL vO GND 1p
M1 net4 Vin+ net2 VSS nch l=0.15 w=1 nf=1 m=1
M10 net1 VBIAS2 VDD VDD pch l=0.15 w=1 nf=1 m=1
M11 net2 VBIAS3 VSS VSS nch l=0.15 w=1 nf=1 m=1
M2 net1 Vin- net2 VSS nch l=0.15 w=1 nf=1 m=1
M3 net3 VBIAS1 net4 VDD pch l=0.15 w=1 nf=1 m=1
M4 vO VBIAS1 net1 VDD pch l=0.15 w=1 nf=1 m=1
M5 net3 net3 net0 VSS nch l=0.15 w=1 nf=1 m=1
M6 vO net3 net5 VSS nch l=0.15 w=1 nf=1 m=1
M7 net0 net0 VSS VSS nch l=0.15 w=1 nf=1 m=1
M8 net5 net0 VSS VSS nch l=0.15 w=1 nf=1 m=1
M9 net4 VBIAS2 VDD VDD pch l=0.15 w=1 nf=1 m=1
.ends dut
