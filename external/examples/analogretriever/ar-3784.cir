* official Analog Canvas netlist; PDK X cards rewritten by convert.py

.subckt dut VSS Vgs Vo
Gm Vo VSS Vgs VSS 1m
R12 Vgs VSS 1k
RD Vo VSS 1k
RL Vo VSS 1k
ro Vo VSS 1k
Vi Vgs VSS DC 1
.ends dut
