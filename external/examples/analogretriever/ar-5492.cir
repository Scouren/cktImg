* official Analog Canvas netlist; PDK X cards rewritten by convert.py
.model qnpn npn

.subckt dut VCC VSS Vout
C1 VSS net3 1p
C2 net1 VSS 1p
C3 net0 net3 1p
C4 Vout net1 1p
C5 net2 VSS 1p
L net3 net1 1n
Q1 net1 net0 net2 VSS qnpn m=1
R1 VCC net0 1k
R2 net0 VSS 1k
R3 VCC net1 1k
R4 net2 VSS 1k
.ends dut
