* official Analog Canvas netlist; PDK X cards rewritten by convert.py
.model nch nmos

.subckt dut VDD VSS GND vo
CC1 net1 Vin 1p
CC2 net0 vo 1p
I Vin VSS DC 1m
M1 net0 GND Vin GND nch l=0.15 w=1 nf=1 m=1
RD VDD net0 1k
Vi net1 GND DC 1
.ends dut
