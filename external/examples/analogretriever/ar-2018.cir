* official Analog Canvas netlist; PDK X cards rewritten by convert.py

.subckt dut VSS Vout
C1 net0 Vout 1p
C2 Vout VSS 1p
Iin VSS net0 DC 1m
R1 Vout VSS 1k
.ends dut
