* official Analog Canvas netlist; PDK X cards rewritten by convert.py
.model nch nmos
.model pch pmos

.subckt dut VDD VSS Vb Vin Vout
I1 Vout VSS DC 1m
M1 net0 Vin VSS VSS nch l=0.15 w=1 nf=1 m=1
M2 net0 Vb VDD VDD pch l=0.15 w=1 nf=1 m=1
M3 VDD net0 Vout VSS nch l=0.15 w=1 nf=1 m=1
.ends dut
