* official Analog Canvas netlist; PDK X cards rewritten by convert.py
.model nch nmos
.model pch pmos

.subckt dut VDD VSS vo
VB1 net3 VSS DC 1
IREF net1 VSS DC 100uA
M1 vo net2 VSS VSS nch l=0.15 w=1 nf=1 m=1
M2 vo net1 net0 VDD pch l=0.15 w=1 nf=1 m=1
M3 net0 net0 VDD VDD pch l=0.15 w=1 nf=1 m=1
M4 net1 net0 VDD VDD pch l=0.15 w=1 nf=1 m=1
Vi net2 net3 DC 1
.ends dut
