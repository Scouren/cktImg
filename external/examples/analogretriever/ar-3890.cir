* official Analog Canvas netlist; PDK X cards rewritten by convert.py
.model qpnp pnp

.subckt dut VCC VEE VE
Q1 net0 net1 VE qpnp m=1
RB net0 net1 100kΩ
RC net0 VEE 8kΩ
RE VCC VE 2kΩ
.ends dut
