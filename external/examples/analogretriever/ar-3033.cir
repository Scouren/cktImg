* official Analog Canvas netlist; PDK X cards rewritten by convert.py
.model nch nmos
.model pch pmos

.subckt dut VDD VSS Vin VP Vout Vb1 Vb4
Ctot net0 VSS 1p
ISS VDD VP DC 1m
M1 net0 Vin VP VDD pch l=0.15 w=1 nf=1 m=1
M3 Vout Vb1 net0 VSS nch l=0.15 w=1 nf=1 m=1
M5 net0 Vb4 VSS VSS nch l=0.15 w=1 nf=1 m=1
.ends dut
