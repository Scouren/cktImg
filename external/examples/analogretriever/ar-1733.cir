* official Analog Canvas netlist; PDK X cards rewritten by convert.py
.model qnpn npn

.subckt dut VCC VSS Vin Vout
CF net0 Vout 1p
I1 Vout VSS DC 1m
Q1 net1 net0 VSS VSS qnpn m=1
Q2 VCC net1 Vout VSS qnpn m=1
RB Vin net0 1k
RC VCC net1 1k
.ends dut
