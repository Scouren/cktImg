* official Analog Canvas netlist; PDK X cards rewritten by convert.py
.model nch nmos

.subckt dut VDD VSS
M1 net0 Y VSS VSS nch l=0.15 w=1 nf=1 m=1
RD VDD net0 1k
RF net1 net0 1k
RS VSS net1 1k
V1 Y net1 DC 1
.ends dut
