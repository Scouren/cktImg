* official Analog Canvas netlist; PDK X cards rewritten by convert.py
.model nch nmos

.subckt dut VDD VSS Vin
M1 X net1 Vin VSS nch l=0.15 w=1 nf=1 m=1
M2 VDD X net0 VSS nch l=0.15 w=1 nf=1 m=1
RD VDD X 1k
RM net1 VSS 1k
RM2 net2 VSS 1k
VX net0 net2 DC 1
.ends dut
