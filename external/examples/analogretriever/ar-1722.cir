* official Analog Canvas netlist; PDK X cards rewritten by convert.py
.model nch nmos

.subckt dut VDD VSS Vin Vb Vout
Cin net1 VSS 1p
CL Vout VSS 1p
M1 Vout Vb net0 VSS nch l=0.15 w=1 nf=1 m=1
RD VDD Vout 1k
RP net0 net1 1k
RS Vin net1 1k
.ends dut
