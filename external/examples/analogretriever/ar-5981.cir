* official Analog Canvas netlist; PDK X cards rewritten by convert.py
.model qnpn npn
.model qpnp pnp

.subckt dut VCC VEE VSS vI VBIAS vo
I1 VCC net0 DC 1m
I2 vo VEE DC 1m
Q1 net0 vI VSS VEE qnpn m=1
Q2 vo VBIAS net0 qpnp m=1
.ends dut
