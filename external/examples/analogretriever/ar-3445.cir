* official Analog Canvas netlist; PDK X cards rewritten by convert.py
.model nch nmos

.subckt dut VDD VSS GND vIN vOUT
CS net1 GND 1p
M1 vOUT vIN net1 net1 nch l=0.15 w=1 nf=1 m=1
RD VDD vOUT 1k
RL vOUT GND 1k
RS net1 VSS 1k
RT net0 vIN 1k
VT net0 GND DC 1
.ends dut
