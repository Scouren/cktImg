* official Analog Canvas netlist; PDK X cards rewritten by convert.py
.model nch nmos

.subckt dut VDD VSS Vin1 Vin2 Vb Vout1 Vout2
ISS net2 VSS DC 1m
M1 net4 net1 net2 VSS nch l=0.15 w=1 nf=1 m=1
M2 net0 net3 net2 VSS nch l=0.15 w=1 nf=1 m=1
M3 Vout1 Vb net4 VSS nch l=0.15 w=1 nf=1 m=1
M4 Vout2 Vb net0 VSS nch l=0.15 w=1 nf=1 m=1
RD1 VDD Vout1 1k
RD2 VDD Vout2 1k
RS1 Vin1 net1 1k
RS2 Vin2 net3 1k
.ends dut
