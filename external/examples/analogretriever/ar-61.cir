* official Analog Canvas netlist; PDK X cards rewritten by convert.py

.subckt dut VSS vi vo
G1 vo net0 vi net0 1m
RC VSS vo 1k
RE net0 VSS 1k
ro vo net0 1k
rpi vi net0 1k
.ends dut
