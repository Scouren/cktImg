* official Analog Canvas netlist; PDK X cards rewritten by convert.py
.model pch pmos

.subckt dut VDD VSS VG VS VD
M1 VD VG VS VDD pch l=0.15 w=1 nf=1 m=1
R1 VDD VG 1k
R2 VG VSS 1k
RD VD VSS 1k
RS VDD VS 1k
.ends dut
