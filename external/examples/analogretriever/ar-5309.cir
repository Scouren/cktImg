* official Analog Canvas netlist; PDK X cards rewritten by convert.py

.subckt dut A B
R1 A B 1k
R2 A B 1k
R3 A B 1k
R4 A B 1k
R5 A B 1k
R6 B A 1k
R7 A B 1k
R8 A B 1k
R9 A B 1k
.ends dut
