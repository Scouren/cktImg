* official Analog Canvas netlist; PDK X cards rewritten by convert.py
.model qnpn npn

.subckt dut VCC VSS vo
CB net1 VSS 1p
CC1 net3 net2 1p
CC2 net0 vo 1p
ICC VCC net0 DC 0.5mA
Q1 net0 net1 net2 VSS qnpn m=1
RB net1 net0 100kΩ
RE net2 VSS 1kΩ
RL vo VSS 1kΩ
RS net3 net4 50Ω
vs net4 VSS DC 1
.ends dut
