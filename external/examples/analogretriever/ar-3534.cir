* official Analog Canvas netlist; PDK X cards rewritten by convert.py
.model qnpn npn

.subckt dut VCC VSS vIN vOUT
C1 vIN net0 1p
Q1 net0 net0 VSS VSS qnpn m=1
Q2 vOUT net0 VSS VSS qnpn m=1
R1 VCC net0 10kΩ
R2 VCC vOUT 1kΩ
.ends dut
