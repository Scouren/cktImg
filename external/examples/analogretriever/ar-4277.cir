* official Analog Canvas netlist; PDK X cards rewritten by convert.py
.model qnpn npn
.model qpnp pnp

.subckt dut VCC1 VCC2 VEE VSS
Q1 net5 net5 VCC2 qpnp m=1
Q2 net0 net0 VEE VEE qnpn m=1
Q3 net3 net0 VEE VEE qnpn m=1
Q4 net3 net0 VEE VEE qnpn m=1
Q5 net2 net0 net1 VEE qnpn m=1
Q6 net2 net2 VCC1 qpnp m=1
Q7 net4 net2 VCC1 qpnp m=1
R1 net5 net0 10kΩ
R2 VSS net3 0.8kΩ
R3 net4 VSS 0.8kΩ
RE net1 VEE 500Ω
.ends dut
