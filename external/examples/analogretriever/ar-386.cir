* official Analog Canvas netlist; PDK X cards rewritten by convert.py

.subckt dut VSS vo
E1 net0 VSS vx VSS {-av}
RF vx vo 1k
ri vx VSS 1k
ro net0 vo 1k
RS net1 vx 1k
Vs net1 VSS DC 1
.ends dut
