* official Analog Canvas netlist; PDK X cards rewritten by convert.py
.model qnpn npn

.subckt dut VCC VEE VSS Vout
C1 VSS net1 1p
C2 net0 net1 1p
C3 net1 Vout 1p
I net1 VEE DC 1m
L VSS net0 1n
Q1 VCC net0 net1 VEE qnpn m=1
RL Vout VSS 1k
.ends dut
