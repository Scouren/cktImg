* official Analog Canvas netlist; PDK X cards rewritten by convert.py
.model qnpn npn

.subckt dut VCC VEE
Q1 VCC net1 net0 VEE qnpn m=1
R1 VCC net1 1k
R2 net1 VEE 1k
RE net0 VEE 1k
.ends dut
