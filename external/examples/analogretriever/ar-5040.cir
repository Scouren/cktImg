* official Analog Canvas netlist; PDK X cards rewritten by convert.py
.model qnpn npn

.subckt dut VCC VEE VSS
Q1 VCC VSS net1 VEE qnpn m=1
Q2 net0 VSS net1 VEE qnpn m=1
RC VCC net0 3kΩ
RE net1 VEE 5kΩ
.ends dut
