* official Analog Canvas netlist; PDK X cards rewritten by convert.py
.model qnpn npn

.subckt dut VSS
Q1 net1 net2 net3 VSS qnpn m=1
Q2 net6 net1 VSS VSS qnpn m=1
Q3 net0 net6 net4 VSS qnpn m=1
RE1 net3 VSS 1k
RE2 net4 VSS 1k
RF net3 net4 1k
RL net0 VSS 1k
RL1 net1 VSS 1k
RL2 net6 VSS 1k
RS net5 net2 1k
Vs net5 VSS DC 1
.ends dut
