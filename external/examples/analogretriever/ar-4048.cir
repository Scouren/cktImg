* official Analog Canvas netlist; PDK X cards rewritten by convert.py

.subckt dut VSS Vo
CC net1 net3 10uF
CL Vo VSS 15pF
G1 Vo net0 net3 net0 1m
R12 net3 VSS 5kΩ
RC Vo VSS 5kΩ
RE net0 VSS 0.5kΩ
RL Vo VSS 10kΩ
Rpi net3 net0 1k
RS net2 net1 0.1kΩ
Vi net2 VSS DC 1
.ends dut
