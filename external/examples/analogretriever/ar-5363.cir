* official Analog Canvas netlist; PDK X cards rewritten by convert.py

.subckt dut VSS
VB1 net0 VSS DC 18V
R1 net0 A 4.7kΩ
R2 A VSS 2.2kΩ
R3 A B 1.0kΩ
R4 B VSS 2.2kΩ
R5 B C 1.0kΩ
R6 C VSS 1.0kΩ
.ends dut
