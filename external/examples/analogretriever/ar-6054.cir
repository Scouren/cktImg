* official Analog Canvas netlist; PDK X cards rewritten by convert.py
.model nch nmos
.model pch pmos

.subckt dut VDD VSS Vin1 Vin2 vod- vod+
M1 vod- Vin1 net2 VDD pch l=0.15 w=1 nf=1 m=1
M2 vod+ Vin2 net2 VDD pch l=0.15 w=1 nf=1 m=1
M3 net2 net0 VDD VDD pch l=0.15 w=1 nf=1 m=1
M4 vod- net1 VSS VSS nch l=0.15 w=1 nf=1 m=1
M5 vod+ net1 VSS VSS nch l=0.15 w=1 nf=1 m=1
M6 net0 net0 VDD VDD pch l=0.15 w=1 nf=1 m=1
M7 net1 net1 VSS VSS nch l=0.15 w=1 nf=1 m=1
R1 net0 net1 1k
.ends dut
