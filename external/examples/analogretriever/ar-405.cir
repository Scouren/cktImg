* official Analog Canvas netlist; PDK X cards rewritten by convert.py
.model qnpn npn
.model qpnp pnp

.subckt dut VCC VEE VSS vo
Q1 net2 net0 net3 VEE qnpn m=1
Q2 VCC net1 net3 VEE qnpn m=1
Q3 vo net2 VCC qpnp m=1
R1 VCC net2 1.25kΩ
R2 net3 VEE 5kΩ
R3 net1 VSS 1kΩ
R4 net1 vo 10kΩ
R5 vo VEE 6kΩ
vi net0 VSS DC 1
.ends dut
