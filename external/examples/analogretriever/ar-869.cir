* official Analog Canvas netlist; PDK X cards rewritten by convert.py
.model qnpn npn

.subckt dut VCC VSS vin vout
Q1 vout A net0 VSS qnpn m=1
RB vin A 1k
RC VCC vout 1k
RE net0 VSS 1k
.ends dut
