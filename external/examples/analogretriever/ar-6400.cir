* official Analog Canvas netlist; PDK X cards rewritten by convert.py
.model qnpn npn

.subckt dut VCC VSS Vout
C1 net1 VSS 1p
C2 net0 VSS 1p
C3 net0 net2 1p
C4 net1 Vout 1p
I VCC net0 DC 1m
L net0 net1 1n
Q1 net1 net2 VSS VSS qnpn m=1
Rf net2 net1 1k
RL Vout VSS 1k
.ends dut
