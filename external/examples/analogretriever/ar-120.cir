* official Analog Canvas netlist; PDK X cards rewritten by convert.py
.model nch nmos

.subckt dut VDD VSS VOUT
VB1 net0 net1 DC 1
IIN VDD net0 DC 1m
M1 net3 net2 VSS VSS nch l=0.15 w=1 nf=1 m=1
M2 VOUT net1 net3 VSS nch l=0.15 w=1 nf=1 m=1
M3 net2 net2 VSS VSS nch l=0.15 w=1 nf=1 m=1
M4 net0 net0 net2 VSS nch l=0.15 w=1 nf=1 m=1
.ends dut
