* official Analog Canvas netlist; PDK X cards rewritten by convert.py
.model qnpn npn
.model qpnp pnp

.subckt dut VCC VEE
Q1 net0 net1 net2 VEE qnpn m=1
Q2 net4 net0 net3 qpnp m=1
R1 VCC net1 100kΩ
R2 net1 VEE 50kΩ
RC1 VCC net0 5kΩ
RC2 net4 VEE 1.5kΩ
RE1 net2 VEE 2kΩ
RE2 VCC net3 2kΩ
.ends dut
