* official Analog Canvas netlist; PDK X cards rewritten by convert.py
.model qnpn npn

.subckt dut VSS io
Is VSS net1 DC 1m
Q1 net2 net1 VSS VSS qnpn m=1
Q2 io net2 net0 VSS qnpn m=1
R1 net2 VSS 20kΩ
R2 net0 VSS 500Ω
R3 net1 net0 5kΩ
.ends dut
