* official Analog Canvas netlist; PDK X cards rewritten by convert.py
.model nch nmos

.subckt dut VDD VSS Vin
I1 VDD net2 DC 1m
ISS net0 VSS DC 1m
M1 VDD Vin net0 VSS nch l=0.15 w=1 nf=1 m=1
M2 net2 net1 net0 VSS nch l=0.15 w=1 nf=1 m=1
M3 VDD net2 net1 VSS nch l=0.15 w=1 nf=1 m=1
R1 net1 VSS 1k
.ends dut
