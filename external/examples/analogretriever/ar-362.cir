* official Analog Canvas netlist; PDK X cards rewritten by convert.py

.subckt dut
E1 net3 net5 net0 net2 1
E2 net6 net7 net0 net2 1
F1 net0 net2 V__icm_sense_6d6af886da8fe5cb 1
F2 net0 net2 V__icm_sense_6d6af886da8fe5cb 1
R1 __icm_sense_node_6d6af886da8fe5cb net1 1k
V__icm_sense_6d6af886da8fe5cb net4 __icm_sense_node_6d6af886da8fe5cb DC 0
R2 net1 net3 1k
R3 net5 net6 1k
R4 net0 net2 1k
R5 net0 net2 1k
R6 net0 net2 1k
V1 net4 net7 DC 1
.ends dut
