* official Analog Canvas netlist; PDK X cards rewritten by convert.py
.model qnpn npn

.subckt dut VCC VSS Vin Vout
C1 net2 net0 1p
C2 net1 VSS 1p
Q1 Vout net0 net1 VSS qnpn m=1
R1 Vin net2 1kΩ
R2 VCC net0 50kΩ
R3 VCC Vout 1kΩ
R4 net1 VSS 2kΩ
.ends dut
