* official Analog Canvas netlist; PDK X cards rewritten by convert.py

.subckt dut B E vo
CM B E 1p
Cmu B E 1p
G1 vo E B E 1m
RC vo E 1k
rpi B E 1k
.ends dut
