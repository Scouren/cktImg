* official Analog Canvas netlist; PDK X cards rewritten by convert.py

.subckt icm_opamp_vdd_vss VDD VSS VIP VIN VOUT params: gain=1e6
Blin nlin 0 V={gain*(V(VIP)-V(VIN))}
Bcore VOUT 0 V={0.5*(V(VDD)+(0.5*(V(VSS)+V(nlin)+sqrt((V(nlin)-V(VSS))*(V(nlin)-V(VSS))+(1e-4*(V(VDD)-V(VSS)))*(1e-4*(V(VDD)-V(VSS)))+1e-12)))-sqrt((V(VDD)-(0.5*(V(VSS)+V(nlin)+sqrt((V(nlin)-V(VSS))*(V(nlin)-V(VSS))+(1e-4*(V(VDD)-V(VSS)))*(1e-4*(V(VDD)-V(VSS)))+1e-12))))*(V(VDD)-(0.5*(V(VSS)+V(nlin)+sqrt((V(nlin)-V(VSS))*(V(nlin)-V(VSS))+(1e-4*(V(VDD)-V(VSS)))*(1e-4*(V(VDD)-V(VSS)))+1e-12))))+(1e-4*(V(VDD)-V(VSS)))*(1e-4*(V(VDD)-V(VSS)))+1e-12))}
.ends icm_opamp_vdd_vss

.subckt dut VCC VEE VSS
C1 net2 net1 1p
C2 net1 VSS 1p
R1 net3 net2 1k
R2 net1 VSS 1k
R3 net3 net0 1k
R4 net0 VSS 1k
RL net3 VSS 1k
X1 VCC VEE net1 net0 net3 icm_opamp_vdd_vss gain=1e6
.ends dut
