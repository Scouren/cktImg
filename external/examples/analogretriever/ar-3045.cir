* official Analog Canvas netlist; PDK X cards rewritten by convert.py
.model nch nmos
.model pch pmos

.subckt dut VDD VSS Vb Vin1 Vin2 Vout1 Vout2
I1 VDD net5 DC 1m
I2 VDD net3 DC 1m
I3 net4 VSS DC 1m
I4 net0 VSS DC 1m
ISS1 net2 VSS DC 1m
ISS2 VDD net1 DC 1m
M1 X Vin1 net2 VSS nch l=0.15 w=1 nf=1 m=1
M2 Y Vin2 net2 VSS nch l=0.15 w=1 nf=1 m=1
M3 Vout1 net5 X VSS nch l=0.15 w=1 nf=1 m=1
M4 Vout2 net3 Y VSS nch l=0.15 w=1 nf=1 m=1
M5 net4 X net1 VDD pch l=0.15 w=1 nf=1 m=1
M6 net0 Y net1 VDD pch l=0.15 w=1 nf=1 m=1
M7 net5 Vb net4 VSS nch l=0.15 w=1 nf=1 m=1
M8 net3 Vb net0 VSS nch l=0.15 w=1 nf=1 m=1
.ends dut
