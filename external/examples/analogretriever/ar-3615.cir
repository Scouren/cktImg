* official Analog Canvas netlist; PDK X cards rewritten by convert.py

.subckt dut VSS vO
.model DIODE D(IS=1e-14 N=1)
C1 VSS net1 1p
C2 vO net1 1p
D1 net0 vO DIODE
RL vO VSS 1k
vS net0 net1 DC 1
.ends dut
