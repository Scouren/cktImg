* official Analog Canvas netlist; PDK X cards rewritten by convert.py
.model nch nmos
.model pch pmos

.subckt opamp VDD VSS VIP VIN VOUT params: gain=1e6 vhigh=5 vlow=-5
Blin nlin 0 V={gain*(V(VIP)-V(VIN))}
Bcore VOUT 0 V={0.5*(vhigh+(0.5*(vlow+V(nlin)+sqrt((V(nlin)-vlow)*(V(nlin)-vlow)+(1e-4*(vhigh-vlow))*(1e-4*(vhigh-vlow))+1e-12)))-sqrt((vhigh-(0.5*(vlow+V(nlin)+sqrt((V(nlin)-vlow)*(V(nlin)-vlow)+(1e-4*(vhigh-vlow))*(1e-4*(vhigh-vlow))+1e-12))))*(vhigh-(0.5*(vlow+V(nlin)+sqrt((V(nlin)-vlow)*(V(nlin)-vlow)+(1e-4*(vhigh-vlow))*(1e-4*(vhigh-vlow))+1e-12))))+(1e-4*(vhigh-vlow))*(1e-4*(vhigh-vlow))+1e-12))}
.ends opamp

.subckt dut VDD VSS x y z
M1 net1 net1 VDD VDD pch l=0.15 w=1 nf=1 m=1
M2 z net1 VDD VDD pch l=0.15 w=1 nf=1 m=1
M3 net0 net0 VSS VSS nch l=0.15 w=1 nf=1 m=1
M4 z net0 VSS VSS nch l=0.15 w=1 nf=1 m=1
M5 net1 net2 y VSS nch l=0.15 w=1 nf=1 m=1
M6 net0 net2 y VDD pch l=0.15 w=1 nf=1 m=1
X1 0 0 x y net2 opamp gain=1e6
.ends dut
