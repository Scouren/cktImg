* official Analog Canvas netlist; PDK X cards rewritten by convert.py
.model qnpn npn

.subckt dut VSS
Q1 net1 net2 net3 VSS qnpn m=1
Q2 net1 net3 VSS VSS qnpn m=1
RL net1 VSS 1k
RS net0 net2 1k
Vi net0 VSS DC 1
.ends dut
