* official Analog Canvas netlist; PDK X cards rewritten by convert.py
.model qnpn npn

.subckt dut VSS vo
VB1 VSS net1 DC 1
VB2 net2 VSS DC 1
CB net5 VSS 1p
CC1 net6 net0 1p
CC2 net4 vo 1p
Q1 net4 net5 net0 VSS qnpn m=1
RB net5 VSS 1k
RC net4 net2 1k
RE net0 net1 1k
RL vo VSS 1k
RS net3 net6 1k
vs net3 VSS DC 1
.ends dut
