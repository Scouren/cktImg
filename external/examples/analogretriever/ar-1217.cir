* official Analog Canvas netlist; PDK X cards rewritten by convert.py
.model nch nmos

.subckt dut VDD VSS
M1 net0 net2 net1 VSS nch l=0.15 w=1 nf=1 m=1
R1 VDD net2 10kΩ
R2 net2 VSS 20kΩ
R3 VDD net0 1kΩ
RP net0 net1 1k
RS net1 VSS 200Ω
.ends dut
