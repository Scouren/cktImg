* official Analog Canvas netlist; PDK X cards rewritten by convert.py
.model qnpn npn

.subckt dut VCC VEE VB vI1 vI2 Voutp Voutn
Q1 Voutp vI1 net0 VEE qnpn m=1
Q2 Voutn vI2 net2 VEE qnpn m=1
Q3 net3 VB net1 VEE qnpn m=1
R1 VCC Voutp 10kΩ
R2 VCC Voutn 10kΩ
R3 net0 net3 1kΩ
R4 net2 net3 1kΩ
R5 net1 VEE 1.3kΩ
.ends dut
