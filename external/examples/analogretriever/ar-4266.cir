* official Analog Canvas netlist; PDK X cards rewritten by convert.py
.model qnpn npn

.subckt dut VCC VSS Iout
Q1 net0 net1 VSS VSS qnpn m=1
Q2 Iout net1 VSS VSS qnpn m=1
Q3 VCC net0 net1 VSS qnpn m=1
R1 VCC net0 1k
R2 net1 VSS 1k
.ends dut
