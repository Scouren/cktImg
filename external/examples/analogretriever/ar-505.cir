* official Analog Canvas netlist; PDK X cards rewritten by convert.py
.model qnpn npn

.subckt dut VSS Iout
Is VSS net0 DC 1m
Q1 net1 VSS net0 VSS qnpn m=1
Q2 Iout net1 VSS VSS qnpn m=1
R1 net1 VSS 5kΩ
RS net0 VSS 1k
.ends dut
