* official Analog Canvas netlist; PDK X cards rewritten by convert.py
.model qnpn npn

.subckt dut VCC VSS Vin Vout
I1 VCC Vout DC 1m
I2 net0 VSS DC 1m
Q1 VCC Vin net0 VSS qnpn m=1
Q2 Vout net1 net0 VSS qnpn m=1
R1 Vout net1 1k
R2 net1 VSS 1k
.ends dut
