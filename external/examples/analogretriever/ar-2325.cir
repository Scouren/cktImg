* official Analog Canvas netlist; PDK X cards rewritten by convert.py
.model nch nmos
.model pch pmos

.subckt dut VDD VSS IN+ IN- OUT- OUT+ VBIAS
IBIAS1 net1 VSS DC 1m
IBIAS2 VDD net0 DC 1m
IBIAS3 VDD net2 DC 1m
M1 net0 IN+ net1 VSS nch l=0.15 w=1 nf=1 m=1
M2 net2 IN- net1 VSS nch l=0.15 w=1 nf=1 m=1
M3 OUT- VBIAS net0 VDD pch l=0.15 w=1 nf=1 m=1
M4 OUT+ VBIAS net2 VDD pch l=0.15 w=1 nf=1 m=1
.ends dut
