* official Analog Canvas netlist; PDK X cards rewritten by convert.py

.subckt dut s gb d
C1 s gb 1p
C2 d gb 1p
G1 gb d s gb 1m
R1 s gb 1k
.ends dut
