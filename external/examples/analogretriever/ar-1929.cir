* official Analog Canvas netlist; PDK X cards rewritten by convert.py
.model nch nmos

.subckt dut VDD VSS
CB net1 net3 1p
CL1 net2 VSS 1p
CL2 net4 VSS 1p
I1 net2 VSS DC 1m
I2 net4 VSS DC 1m
ISS net0 VSS DC 1m
M1 net1 net2 net0 VSS nch l=0.15 w=1 nf=1 m=1
M2 net3 net4 net0 VSS nch l=0.15 w=1 nf=1 m=1
M3 VDD net1 net2 VSS nch l=0.15 w=1 nf=1 m=1
M4 VDD net3 net4 VSS nch l=0.15 w=1 nf=1 m=1
RD1 VDD net1 1k
RD2 VDD net3 1k
.ends dut
