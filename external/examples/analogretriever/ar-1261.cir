* official Analog Canvas netlist; PDK X cards rewritten by convert.py
.model nch nmos

.subckt dut VDD VSS Vin Vout
C1 VSS net0 1p
CB net1 VSS 1p
M1 Vout net1 Vin VSS nch l=0.15 w=1 nf=1 m=1
R1 net1 VSS 1k
R2 Vout net1 1k
R3 Vout net0 1k
R4 net0 Vin 1k
RD VDD Vout 1k
.ends dut
