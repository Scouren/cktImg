* official Analog Canvas netlist; PDK X cards rewritten by convert.py

.subckt dut VSS a b
C net0 b 1p
L1 a VSS 12mH
L2 b VSS 8.0mH
R1 net0 a 180Ω
Vs net0 VSS DC 0 SIN(0 12V 3kHz 0 0 0)
.ends dut
