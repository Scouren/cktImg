* official Analog Canvas netlist; PDK X cards rewritten by convert.py
.model nch nmos
.model pch pmos

.subckt dut VDD VSS Vb4 Vb3 Vb2 Vin Vout
M1 net1 Vin VSS VSS nch l=0.15 w=1 nf=1 m=1
M2 Vout Vb2 net1 VSS nch l=0.15 w=1 nf=1 m=1
M3 Vout Vb3 net0 VDD pch l=0.15 w=1 nf=1 m=1
M4 net0 Vb4 VDD VDD pch l=0.15 w=1 nf=1 m=1
Rp Vout net1 1k
.ends dut
