* official Analog Canvas netlist; PDK X cards rewritten by convert.py
.model nch nmos

.subckt dut VSS C D B A Vout
M1 net1 A VSS VSS nch l=0.15 w=1 nf=1 m=1
M2 Vout B net1 VSS nch l=0.15 w=1 nf=1 m=1
M3 Vout C net0 VSS nch l=0.15 w=1 nf=1 m=1
M4 net0 D VSS VSS nch l=0.15 w=1 nf=1 m=1
.ends dut
