* official Analog Canvas netlist; PDK X cards rewritten by convert.py
.model nch nmos

.subckt dut VDD VSS Vin Vout
C1 X Vout 1p
M1 VDD Vin X VSS nch l=0.15 w=1 nf=1 m=1
RG VDD Vin 1k
RL Vout VSS 50Ω
RS X VSS 1k
.ends dut
