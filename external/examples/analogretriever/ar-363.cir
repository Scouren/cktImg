* official Analog Canvas netlist; PDK X cards rewritten by convert.py

.subckt dut vop von
E1 net1 net4 vop von 1
F1 vop von V__icm_sense_389943dc1b4fb3de 1
R1 __icm_sense_node_389943dc1b4fb3de net0 1k
V__icm_sense_389943dc1b4fb3de net3 __icm_sense_node_389943dc1b4fb3de DC 0
R2 net0 net2 1k
R3 net2 net1 1k
R4 vop von 1k
R5 vop von 1k
R6 vop von 1k
V1 net3 net4 DC 1
.ends dut
