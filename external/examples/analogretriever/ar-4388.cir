* official Analog Canvas netlist; PDK X cards rewritten by convert.py
.model nch nmos
.model pch pmos

.subckt dut VDD VSS vin vO
M1 net0 vin VDD VDD pch l=0.15 w=1 nf=1 m=1
M2 VDD net0 vO VSS nch l=0.15 w=1 nf=1 m=1
R1 net0 VSS 35kΩ
R2 vO VSS 5kΩ
.ends dut
