* official Analog Canvas netlist; PDK X cards rewritten by convert.py
.model nch nmos
.model pch pmos

.subckt dut VDD VSS N1 N2 Iout VG
Is VSS N1 DC 1m
M1 net0 VG N1 VSS nch l=0.15 w=1 nf=1 m=1
M2 Iout net0 VDD VDD pch l=0.15 w=1 nf=1 m=1
RD VDD net0 1k
RF N1 N2 1k
RL Iout N2 1k
RM N2 VSS 1k
.ends dut
