* official Analog Canvas netlist; PDK X cards rewritten by convert.py
.model nch nmos

.subckt dut VDD VSS
C1 net1 X 1p
M1 net0 X VSS VSS nch l=0.15 w=1 nf=1 m=1
R1 VDD X 1k
R2 X VSS 1k
R3 net0 VSS 8
RD VDD net0 1kΩ
V1 net1 VSS DC 1
.ends dut
