* official Analog Canvas netlist; PDK X cards rewritten by convert.py
.model nch nmos
.model pch pmos

.subckt dut VDD VSS
Cdb1 vO VSS 1p
Cdb2 VDD vO 1p
Cg3 VSS vO 1p
Cg4 VDD vO 1p
Cgd1 vO net1 1p
Cgd2 vO net1 1p
Cw vO VSS 1p
M1 vO net1 VSS VSS nch l=0.15 w=1 nf=1 m=1
M2 vO net1 VDD VDD pch l=0.15 w=1 nf=1 m=1
M3 net0 vO VSS VSS nch l=0.15 w=1 nf=1 m=1
M4 net0 vO VDD VDD pch l=0.15 w=1 nf=1 m=1
VI net1 VSS DC 1
.ends dut
