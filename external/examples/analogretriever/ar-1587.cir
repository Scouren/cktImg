* official Analog Canvas netlist; PDK X cards rewritten by convert.py
.model qnpn npn

.subckt dut VCC VSS Vin1 Vin2 Vout1 Vout2
IEE P VSS DC 1m
Q1 net0 Vin1 P VSS qnpn m=1
Q2 net1 Vin2 P VSS qnpn m=1
Q3 VCC Vout1 net0 VSS qnpn m=1
Q4 VCC Vout2 net1 VSS qnpn m=1
R1 VCC Vout1 1k
R2 VCC Vout2 1k
.ends dut
