* official Analog Canvas netlist; PDK X cards rewritten by convert.py
.model qnpn npn

.subckt dut VCC VSS Vin Vout
C1 Vin net1 1p
Q1 Vout net0 VSS VSS qnpn m=1
R1 net1 net0 1kΩ
R2 net0 Vout 10kΩ
R3 VCC Vout 1kΩ
.ends dut
