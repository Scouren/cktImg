* official Analog Canvas netlist; PDK X cards rewritten by convert.py
.model qnpn npn

.subckt dut VCC VSS vo
CC1 net2 net1 1p
CC2 net3 vo 1p
CE net0 VSS 1p
is VSS net2 DC 1m
Q1 net3 net1 net0 VSS qnpn m=1
R1 VCC net1 1k
R2 net1 VSS 1k
RC VCC net3 1k
RE net0 VSS 1k
RL vo VSS 1k
rs net2 VSS 1k
.ends dut
