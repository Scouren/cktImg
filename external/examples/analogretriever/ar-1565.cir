* official Analog Canvas netlist; PDK X cards rewritten by convert.py
.model pch pmos

.subckt dut VDD VSS vout
M4 vout A VDD VDD pch l=0.15 w=1 nf=1 m=1
rO3 VDD A 1k
rO4 vout VSS 1k
RThev A E 1k
vThev E vout DC 1
.ends dut
