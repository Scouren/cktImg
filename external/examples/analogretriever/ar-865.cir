* official Analog Canvas netlist; PDK X cards rewritten by convert.py

.subckt dut VSS
G1 net0 P VSS P 1m
RC net0 VSS 1k
RE P VSS 1k
Rpi VSS P 1k
VX net0 VSS DC 1
.ends dut
