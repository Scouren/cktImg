* official Analog Canvas netlist; PDK X cards rewritten by convert.py

.subckt dut VSS
G1 VSS net0 net1 VSS 1m
G2 net1 VSS net1 VSS 1m
R1 net1 VSS 1k
R2 net0 net1 1k
Vo net0 VSS DC 1
.ends dut
