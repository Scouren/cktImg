* official Analog Canvas netlist; PDK X cards rewritten by convert.py

.subckt dut B C E
G1 C net0 B net0 1m
G2 C E net0 E 1m
Rgo1 C net0 1k
Rgo2 C E 1k
Rpi1 B net0 1k
Rpi2 net0 E 1k
.ends dut
