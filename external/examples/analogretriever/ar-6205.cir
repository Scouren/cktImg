* official Analog Canvas netlist; PDK X cards rewritten by convert.py
.model nch nmos

.subckt dut VDD VSS Vo
CC net1 net2 1p
I1 VDD net0 DC 1m
M1 net0 net2 VSS VSS nch l=0.15 w=1 nf=1 m=1
M2 VDD net0 Vo VSS nch l=0.15 w=1 nf=1 m=1
R1 net2 VSS 1k
R2 net2 Vo 1k
RL Vo VSS 1k
Rs net3 net1 1k
Vs net3 VSS DC 1
.ends dut
