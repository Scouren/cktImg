* official Analog Canvas netlist; PDK X cards rewritten by convert.py
.model nch nmos

.subckt dut VDD VSS Vin2 Vin1 Vout1 Vout2 Vcontn Vcontp
G1 net2 VSS Vcontp VSS 1m
G2 net0 VSS Vcontn VSS 1m
G3 net1 VSS Vcontn VSS 1m
M1 Vout1 Vin1 net2 VSS nch l=0.15 w=1 nf=1 m=1
M2 Vout2 Vin2 net2 VSS nch l=0.15 w=1 nf=1 m=1
M3 Vout1 VA net1 VSS nch l=0.15 w=1 nf=1 m=1
M4 Vout2 VB net1 VSS nch l=0.15 w=1 nf=1 m=1
M5 VA Vin2 net0 VSS nch l=0.15 w=1 nf=1 m=1
M6 VB Vin1 net0 VSS nch l=0.15 w=1 nf=1 m=1
R1 VDD Vout1 1k
R2 VDD Vout2 1k
R3 VDD VA 1k
R4 VDD VB 1k
.ends dut
