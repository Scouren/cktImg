* official Analog Canvas netlist; PDK X cards rewritten by convert.py
.model nch nmos

.subckt dut VDD VSS Vs Vo
M1 net0 Vs net2 VSS nch l=0.15 w=1 nf=1 m=1
M2 net1 net0 VSS VSS nch l=0.15 w=1 nf=1 m=1
M3 VDD net1 Vo VSS nch l=0.15 w=1 nf=1 m=1
RD1 VDD net0 10kΩ
RD2 VDD net1 10kΩ
RF net2 Vo 1k
RS1 net2 VSS 100Ω
RS2 Vo VSS 100Ω
.ends dut
