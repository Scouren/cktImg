* official Analog Canvas netlist; PDK X cards rewritten by convert.py
.model qnpn npn

.subckt dut VCC VEE VSS Vo Vin
CE net0 VSS 1p
I1 net0 VEE DC 1m
Q1 Vo Vin net1 VEE qnpn m=1
RC VCC Vo 1k
Re net1 net0 1k
Vsig Vin VSS DC 1
.ends dut
