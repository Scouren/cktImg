* official Analog Canvas netlist; PDK X cards rewritten by convert.py

.subckt dut VSS G vo
G1 VSS vo G vo 1m
G2 vo VSS vo VSS 1m
RL vo VSS 1k
Ro VSS vo 1k
RS net0 G 1k
Vs net0 VSS DC 1
.ends dut
