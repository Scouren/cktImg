* official Analog Canvas netlist; PDK X cards rewritten by convert.py
.model nch nmos

.subckt dut VDD VSS Vout
C1 Vout VSS 1p
G1 P VSS net0 VSS 1m
I1 VDD Vout DC 1m
M1 Vout VSS P VSS nch l=0.15 w=1 nf=1 m=1
Vt net0 VSS DC 1
.ends dut
