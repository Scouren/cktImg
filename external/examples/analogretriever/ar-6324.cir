* official Analog Canvas netlist; PDK X cards rewritten by convert.py
.model nch nmos
.model pch pmos
.model qnpn npn

.subckt dut VDD VSS vI vO
MN vO vI net1 VSS nch l=0.15 w=1 nf=1 m=1
MP net0 vI VDD VDD pch l=0.15 w=1 nf=1 m=1
Q1 VDD net0 vO VSS qnpn m=1
Q2 vO net1 VSS VSS qnpn m=1
R1 net0 VSS 1k
R2 net1 VSS 1k
.ends dut
