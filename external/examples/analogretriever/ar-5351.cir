* official Analog Canvas netlist; PDK X cards rewritten by convert.py

.subckt dut VSS
VB1 net1 VSS DC 3V
R1 net1 net0 680Ω
R2 net0 VSS 680Ω
R3 net0 VSS 330Ω
R4 net0 VSS 220Ω
.ends dut
