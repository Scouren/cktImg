* official Analog Canvas netlist; PDK X cards rewritten by convert.py
.model nch nmos

.subckt dut VDD VSS GND
M1 net3 net1 net2 VSS nch l=0.15 w=1 nf=1 m=1
M2 net2 net0 VSS VSS nch l=0.15 w=1 nf=1 m=1
M3 net0 net0 VSS VSS nch l=0.15 w=1 nf=1 m=1
M4 GND GND net0 VSS nch l=0.15 w=1 nf=1 m=1
RD VDD net3 1k
RG net1 GND 1k
.ends dut
