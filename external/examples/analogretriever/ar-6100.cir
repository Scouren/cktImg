* official Analog Canvas netlist; PDK X cards rewritten by convert.py

.subckt dut VSS Vo
Cmu Bp Vo 1p
Cpi Bp VSS 1p
Gm Vo VSS Bp VSS 1m
RB B VSS 1k
RC Vo VSS 1k
RL Vo VSS 1k
ro Vo VSS 1k
rpi Bp VSS 1k
Rsig net0 B 1k
rx B Bp 1k
Vsig net0 VSS DC 1
.ends dut
