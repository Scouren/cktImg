* official Analog Canvas netlist; PDK X cards rewritten by convert.py
.model nch nmos

.subckt dut VDD VSS GND Vi Vo
IR VDD net0 DC 1m
M1 VDD Vi Vo VSS nch l=0.15 w=1 nf=1 m=1
M2 Vo net0 VSS VSS nch l=0.15 w=1 nf=1 m=1
M3 net0 net0 VSS VSS nch l=0.15 w=1 nf=1 m=1
RL Vo GND 1k
.ends dut
