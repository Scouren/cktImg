* official Analog Canvas netlist; PDK X cards rewritten by convert.py

.subckt dut VSS
C1 net0 VSS 1p
C2 net2 VSS 1p
G1 net2 VSS net0 VSS 1m
G2 net1 VSS net2 VSS 1m
Ii VSS net0 DC 1m
RL1 net2 VSS 1k
RL2 net1 VSS 1k
Rpi1 net0 VSS 1k
Rpi2 net2 VSS 1k
.ends dut
