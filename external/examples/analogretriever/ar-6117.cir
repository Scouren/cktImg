* official Analog Canvas netlist; PDK X cards rewritten by convert.py
.model nch nmos

.subckt dut VDD VSS Vin1 Vin2 VBIAS Vo+ Vo-
M1 Vo+ Vin1 S VSS nch l=0.15 w=1 nf=1 m=1
M2 Vo- Vin2 S VSS nch l=0.15 w=1 nf=1 m=1
MS S VBIAS VSS VSS nch l=0.15 w=1 nf=1 m=1
RD1 VDD Vo+ 1k
RD2 VDD Vo- 1k
.ends dut
