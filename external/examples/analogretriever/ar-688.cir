* official Analog Canvas netlist; PDK X cards rewritten by convert.py

.subckt dut VSS Vout
.model DIODE D(IS=1e-14 N=1)
D1 VSS net0 DIODE
D2 Vout VSS DIODE
Iin VSS Vout DC 1m
R1 Vout net0 1k
.ends dut
