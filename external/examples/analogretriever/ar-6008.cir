* official Analog Canvas netlist; PDK X cards rewritten by convert.py
.model nch nmos
.model pch pmos

.subckt dut VDD VSS VG3 VG2 VG1 Vin1 Vin2 Vout1 Vout2
I1 net3 VSS DC 1m
M1 net0 Vin1 net3 VSS nch l=0.15 w=1 nf=1 m=1
M2 net4 Vin2 net3 VSS nch l=0.15 w=1 nf=1 m=1
M3 Vout1 VG1 net0 VSS nch l=0.15 w=1 nf=1 m=1
M4 Vout2 VG1 net4 VSS nch l=0.15 w=1 nf=1 m=1
M5 Vout1 VG2 net1 VDD pch l=0.15 w=1 nf=1 m=1
M6 Vout2 VG2 net2 VDD pch l=0.15 w=1 nf=1 m=1
M7 net1 VG3 VDD VDD pch l=0.15 w=1 nf=1 m=1
M8 net2 VG3 VDD VDD pch l=0.15 w=1 nf=1 m=1
.ends dut
