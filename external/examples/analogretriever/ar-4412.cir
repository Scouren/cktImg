* official Analog Canvas netlist; PDK X cards rewritten by convert.py
.model nch nmos

.subckt dut VDD VSS GND
C1 net1 net2 1p
C2 net0 net3 1p
M1 net0 net2 net4 GND nch l=0.15 w=1 nf=1 m=1
R1 VDD net2 30kΩ
R2 net2 VSS 20kΩ
RD VDD net0 2kΩ
RL net3 GND 2kΩ
RS net4 VSS 0.4kΩ
vi net1 GND DC 1
.ends dut
