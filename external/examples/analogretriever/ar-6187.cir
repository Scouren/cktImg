* official Analog Canvas netlist; PDK X cards rewritten by convert.py
.model qnpn npn

.subckt dut VCC VSS Vs Vo
I1 Vo VSS DC 1m
Q1 net1 Vs net0 VSS qnpn m=1
Q2 net2 net1 VSS VSS qnpn m=1
Q3 VCC net2 Vo VSS qnpn m=1
RC1 VCC net1 1k
RC2 VCC net2 1k
RE net0 VSS 1k
RF net0 Vo 1k
.ends dut
