* official Analog Canvas netlist; PDK X cards rewritten by convert.py

.subckt dut VCC VSS
I1 X VSS DC 1m
I2 Y VSS DC 1m
R1 VCC P 1k
RC1 P X 1k
RC2 P Y 1k
.ends dut
