* official Analog Canvas netlist; PDK X cards rewritten by convert.py
.model qnpn npn

.subckt dut VCC VSS vo
CB net3 VSS 1p
CC net0 vo 1p
IQ VCC net0 DC 1.0mA
Q1 net0 net3 net2 VSS qnpn m=1
RB net3 net0 100kΩ
RL vo VSS 2kΩ
RS net2 net1 50Ω
vs net1 VSS DC 1
.ends dut
