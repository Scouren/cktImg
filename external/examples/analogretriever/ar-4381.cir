* official Analog Canvas netlist; PDK X cards rewritten by convert.py
.model qnpn npn
.model qpnp pnp

.subckt dut VCC VEE v1 v2 vo
IQ net2 VEE DC 1m
Q1 net0 v1 net1 VEE qnpn m=1
Q2 vo v2 net3 VEE qnpn m=1
Q3 net0 net1 net2 VEE qnpn m=1
Q4 vo net3 net2 VEE qnpn m=1
Q5 net0 net0 VCC qpnp m=1
Q6 vo net0 VCC qpnp m=1
.ends dut
