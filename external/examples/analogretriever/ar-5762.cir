* official Analog Canvas netlist; PDK X cards rewritten by convert.py
.model qpnp pnp

.subckt dut VCC VSS B E
Q1 net0 B E qpnp m=1
R1 VCC E 1kΩ
R2 B net0 45kΩ
R3 net0 VSS 1.5kΩ
.ends dut
