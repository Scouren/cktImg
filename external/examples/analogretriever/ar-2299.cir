* official Analog Canvas netlist; PDK X cards rewritten by convert.py
.model nch nmos
.model pch pmos

.subckt dut VDD VSS Vin Vout
M1 net0 Vin VSS VSS nch l=0.18 w=5 nf=1 m=1
M2 Vout net0 VDD VDD pch l=0.18 w=10 nf=1 m=1
R1 VDD net0 1kΩ
R2 Vout VSS 500Ω
.ends dut
