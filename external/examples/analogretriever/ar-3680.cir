* official Analog Canvas netlist; PDK X cards rewritten by convert.py
.model pch pmos

.subckt dut VDD VSS
M1 net0 VG net1 VDD pch l=0.15 w=1 nf=1 m=1
R1 VDD VG 1k
R2 VG VSS 1k
RD net0 VSS 1k
RS VDD net1 1k
.ends dut
