* official Analog Canvas netlist; PDK X cards rewritten by convert.py

.subckt dut VSS Vo
CC net1 net0 1p
G1 Vo net2 net1 net2 1m
RB net1 VSS 1k
RC Vo VSS 1k
RE net2 VSS 1k
Rpi net1 net2 1k
RSi net3 net0 1k
Vi net3 VSS DC 1
.ends dut
