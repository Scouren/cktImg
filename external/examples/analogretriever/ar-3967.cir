* official Analog Canvas netlist; PDK X cards rewritten by convert.py

.subckt dut VSS
G1 VSS net0 VSS net0 1m
R12 VSS VSS 1k
RE net0 VSS 1k
ro net0 VSS 1k
rpi VSS net0 1k
Vx net0 VSS DC 1
.ends dut
