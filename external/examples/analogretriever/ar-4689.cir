* official Analog Canvas netlist; PDK X cards rewritten by convert.py

.subckt dut Vout1 Vout2
.model DIODE D(IS=1e-14 N=1)
C1 Vout1 net0 1p
C2 net0 Vout2 1p
D1 net1 Vout1 DIODE
D2 Vout2 net1 DIODE
R1 Vout1 Vout2 1k
Vin net1 net0 DC 1 SIN(0 1 1k 0 0 0)
.ends dut
