* official Analog Canvas netlist; PDK X cards rewritten by convert.py
.model nch nmos

.subckt dut VDD VSS GND vIN vOUT
CO net1 vOUT 1p
M1 net1 vIN net0 net0 nch l=0.15 w=1 nf=1 m=1
RD VDD net1 1k
RL vOUT GND 1k
RS net0 VSS 1k
RT net2 vIN 1k
VT net2 GND DC 1
.ends dut
