* official Analog Canvas netlist; PDK X cards rewritten by convert.py

.subckt dut VSS VCM VCSBIAS Vcmc Voc phi2 phi1
.model ideal_switch SW(RON=1 ROFF=1e12 VT=0.5 VH=0)
C1 net1 net0 1p
C2 Vcmc Voc 1p
E1 Voc VSS Vcmc VSS 1
S1 Voc net1 phi2 VSS ideal_switch
S2 VCM net1 phi1 VSS ideal_switch
S3 net0 Vcmc phi2 VSS ideal_switch
S4 net0 VCSBIAS phi1 VSS ideal_switch
.ends dut
