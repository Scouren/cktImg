* official Analog Canvas netlist; PDK X cards rewritten by convert.py
.model qnpn npn

.subckt dut VEE VSS v1 VREF vO1 vO2
Q1 vO1 v1 net0 VEE qnpn m=1
Q2 vO2 VREF net0 VEE qnpn m=1
RC1 VSS vO1 1k
RC2 VSS vO2 1k
RE net0 VEE 1k
.ends dut
