* official Analog Canvas netlist; PDK X cards rewritten by convert.py
.model pch pmos

.subckt dut VDD VSS GND vo
CC net3 vo 1p
CS net1 GND 1p
M1 net3 net2 net1 VDD pch l=0.15 w=1 nf=1 m=1
RD net3 VSS 1k
RS VDD net1 1k
Rsig net0 net2 1k
Vsig net0 GND DC 1
.ends dut
