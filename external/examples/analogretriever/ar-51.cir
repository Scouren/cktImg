* official Analog Canvas netlist; PDK X cards rewritten by convert.py

.subckt dut VSS
Gm VSS vo v1 VSS 1m
R vo VSS 1k
Ri v1 VSS 1k
RL vo VSS 1k
ro v1 vo 1k
vt v1 VSS DC 1
.ends dut
