* official Analog Canvas netlist; PDK X cards rewritten by convert.py
.model nch nmos
.model pch pmos

.subckt dut VDD VSS vin- vin+ vout
ISS P VSS DC 1m
M1 A vin- P VSS nch l=0.15 w=1 nf=1 m=1
M2 vout vin+ P VSS nch l=0.15 w=1 nf=1 m=1
M4 vout A VDD VDD pch l=0.15 w=1 nf=1 m=1
R3 VDD A 1k
RO4 VDD vout 1k
.ends dut
