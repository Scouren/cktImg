* official Analog Canvas netlist; PDK X cards rewritten by convert.py
.model nch nmos

.subckt dut VSS A D B C Vout
M1 Vout A net0 VSS nch l=0.15 w=1 nf=1 m=1
M2 net1 B VSS VSS nch l=0.15 w=1 nf=1 m=1
M3 net1 C VSS VSS nch l=0.15 w=1 nf=1 m=1
M4 net0 D net1 VSS nch l=0.15 w=1 nf=1 m=1
.ends dut
