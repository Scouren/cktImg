* official Analog Canvas netlist; PDK X cards rewritten by convert.py
.model nch nmos
.model pch pmos
.model qnpn npn

.subckt dut VDD VSS vI vO
MN vO vI net0 VSS nch l=0.15 w=1 nf=1 m=1
MP net1 vI VDD VDD pch l=0.15 w=1 nf=1 m=1
MR1 net1 vI VSS VSS nch l=0.15 w=1 nf=1 m=1
MR2 net0 net1 VSS VSS nch l=0.15 w=1 nf=1 m=1
Q1 VDD net1 vO VSS qnpn m=1
Q2 vO net0 VSS VSS qnpn m=1
.ends dut
