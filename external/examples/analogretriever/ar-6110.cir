* official Analog Canvas netlist; PDK X cards rewritten by convert.py
.model qnpn npn

.subckt dut VSS Vo
Ccs1 C1 VSS 1p
Cload Vo VSS 1p
Cmu1 net0 C1 1p
Cmu2 Vo VSS 1p
Cpi1 net0 VSS 1p
Cpi2 VSS C1 1p
Q1 C1 net0 VSS VSS qnpn m=1
Q2 Vo VSS C1 VSS qnpn m=1
RL Vo VSS 1k
Rsig net1 net0 1k
Vsig net1 VSS DC 1
.ends dut
