* official Analog Canvas netlist; PDK X cards rewritten by convert.py

.subckt dut VSS Vs
C1 net0 net1 1p
L1 net1 VSS 1n
L2 net1 VSS 1n
R1 Vs net0 3.3kΩ
R2 net1 VSS 10kΩ
.ends dut
