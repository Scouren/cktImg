* official Analog Canvas netlist; PDK X cards rewritten by convert.py
.model qpnp pnp

.subckt dut VCC VSS vO
CC net3 net2 1p
Q1 vO net2 net1 qpnp m=1
R1 VCC net2 1k
R2 net2 VSS 1k
RC vO VSS 1k
RE VCC net1 1k
RS net0 net3 0.25kΩ
Vs net0 VSS DC 1
.ends dut
