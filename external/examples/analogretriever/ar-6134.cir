* official Analog Canvas netlist; PDK X cards rewritten by convert.py

.subckt dut VSS Vsig Vo
Cmu1 B1 VSS 1p
Cmu2 VSS Vo 1p
Cpi1 B1 E 1p
Cpi2 E VSS 1p
G1 VSS E B1 E 1m
G2 Vo E VSS E 1m
RL Vo VSS 1k
Rpi1 B1 E 1k
Rpi2 E VSS 1k
Rsig Vsig B1 1k
.ends dut
