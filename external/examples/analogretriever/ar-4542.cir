* official Analog Canvas netlist; PDK X cards rewritten by convert.py
.model qpnp pnp

.subckt icm_opamp_vdd_vss VDD VSS VIP VIN VOUT params: gain=1e6
Blin nlin 0 V={gain*(V(VIP)-V(VIN))}
Bcore VOUT 0 V={0.5*(V(VDD)+(0.5*(V(VSS)+V(nlin)+sqrt((V(nlin)-V(VSS))*(V(nlin)-V(VSS))+(1e-4*(V(VDD)-V(VSS)))*(1e-4*(V(VDD)-V(VSS)))+1e-12)))-sqrt((V(VDD)-(0.5*(V(VSS)+V(nlin)+sqrt((V(nlin)-V(VSS))*(V(nlin)-V(VSS))+(1e-4*(V(VDD)-V(VSS)))*(1e-4*(V(VDD)-V(VSS)))+1e-12))))*(V(VDD)-(0.5*(V(VSS)+V(nlin)+sqrt((V(nlin)-V(VSS))*(V(nlin)-V(VSS))+(1e-4*(V(VDD)-V(VSS)))*(1e-4*(V(VDD)-V(VSS)))+1e-12))))+(1e-4*(V(VDD)-V(VSS)))*(1e-4*(V(VDD)-V(VSS)))+1e-12))}
.ends icm_opamp_vdd_vss

.subckt dut VCC VSS VO
.model icm_zener_D1 D(BV=5.6)
D1 net2 VCC icm_zener_D1
Q VO net0 net1 qpnp m=1
R1 net2 VSS 10kΩ
R2 VCC net1 5kΩ
RL VO VSS 1k
X1 VCC VSS net2 net1 net0 icm_opamp_vdd_vss gain=1e6
.ends dut
