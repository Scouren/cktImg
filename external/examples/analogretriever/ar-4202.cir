* official Analog Canvas netlist; PDK X cards rewritten by convert.py

.subckt opamp VDD VSS VIP VIN VOUT params: gain=1e6 vhigh=5 vlow=-5
Blin nlin 0 V={gain*(V(VIP)-V(VIN))}
Bcore VOUT 0 V={0.5*(vhigh+(0.5*(vlow+V(nlin)+sqrt((V(nlin)-vlow)*(V(nlin)-vlow)+(1e-4*(vhigh-vlow))*(1e-4*(vhigh-vlow))+1e-12)))-sqrt((vhigh-(0.5*(vlow+V(nlin)+sqrt((V(nlin)-vlow)*(V(nlin)-vlow)+(1e-4*(vhigh-vlow))*(1e-4*(vhigh-vlow))+1e-12))))*(vhigh-(0.5*(vlow+V(nlin)+sqrt((V(nlin)-vlow)*(V(nlin)-vlow)+(1e-4*(vhigh-vlow))*(1e-4*(vhigh-vlow))+1e-12))))+(1e-4*(vhigh-vlow))*(1e-4*(vhigh-vlow))+1e-12))}
.ends opamp

.subckt dut VSS vO1 vO2
R1 VSS net2 1k
R2 net2 net1 1k
R3 net1 net0 1k
R4 net0 vO2 1k
V1 net3 VSS DC 1
X1 0 VSS net3 net2 net1 opamp gain=1e6
X2 0 VSS net1 vO1 vO1 opamp gain=1e6
X3 0 VSS VSS net0 vO2 opamp gain=1e6
.ends dut
