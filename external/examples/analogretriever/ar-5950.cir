* official Analog Canvas netlist; PDK X cards rewritten by convert.py
.model qnpn npn

.subckt dut VCC VEE VSS vi vo
I1 VCC vo DC 1m
I2 net0 VEE DC 1m
Q1 VCC vi net0 VEE qnpn m=1
Q2 vo VSS net0 VEE qnpn m=1
.ends dut
