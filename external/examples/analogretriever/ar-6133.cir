* official Analog Canvas netlist; PDK X cards rewritten by convert.py
.model nch nmos

.subckt dut VDD VSS GND Vi Vo
I1 VDD Vo DC 1m
I2 net0 VSS DC 1m
M1 VDD Vi net0 GND nch l=0.15 w=1 nf=1 m=1
M2 Vo GND net0 GND nch l=0.15 w=1 nf=1 m=1
.ends dut
