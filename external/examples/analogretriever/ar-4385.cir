* official Analog Canvas netlist; PDK X cards rewritten by convert.py
.model nch nmos
.model qnpn npn

.subckt dut VDD VSS vo VBias1 VBias2 vi
IQ VDD vo DC 1m
M1 vo VBias1 net1 VSS nch l=0.15 w=1 nf=1 m=1
Q1 net0 vi VSS VSS qnpn m=1
Q2 net1 VBias2 net0 VSS qnpn m=1
.ends dut
