* official Analog Canvas netlist; PDK X cards rewritten by convert.py
.model qnpn npn
.model qpnp pnp

.subckt dut VEE VCC VSS Vin Vout
I1 VCC net0 DC 1m
Q0 net3 net1 VSS VEE qnpn m=1
Q1 VCC net0 Vout VEE qnpn m=1
Q2 VEE net3 Vout qpnp m=1
Q3 net0 net0 net2 VEE qnpn m=1
Q4 net3 net3 net2 qpnp m=1
R1 Vin net1 1kΩ
R2 net1 Vout 10kΩ
R3 Vout VSS 8Ω
.ends dut
