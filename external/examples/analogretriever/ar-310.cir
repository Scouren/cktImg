* official Analog Canvas netlist; PDK X cards rewritten by convert.py

.subckt dut VSS vo
Gm vo VSS net0 VSS 1m
I1 vo net0 DC 1m
R1 net0 VSS 1k
RL vo VSS 1k
Rpi net0 VSS 1k
.ends dut
