* official Analog Canvas netlist; PDK X cards rewritten by convert.py

.subckt dut VSS vo
Cf X vo 1p
Cin X VSS 1p
G1 vo VSS X VSS 1m
ii VSS X DC 1m
R X VSS 1k
RL vo VSS 1k
.ends dut
