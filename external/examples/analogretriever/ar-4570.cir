* official Analog Canvas netlist; PDK X cards rewritten by convert.py
.model nch nmos

.subckt dut VDD VSS vI vO1 vO2
.model NMOS nmos level=54
MD1 vO1 vI VSS VSS nch l=0.15 w=1 nf=1 m=1
MD2 vO2 vO1 VSS VSS nch l=0.15 w=1 nf=1 m=1
ML1 VDD vO1 vO1 VSS NMOS l=150n m=1 nf=1 w=1u
ML2 VDD vO2 vO2 VSS NMOS l=150n m=1 nf=1 w=1u
.ends dut
