* official Analog Canvas netlist; PDK X cards rewritten by convert.py
.model pch pmos
.model qnpn npn
.model qpnp pnp

.subckt dut VDD VSS VB1 VB2
.model DIODE D(IS=1e-14 N=1)
D1 VDD VB1 DIODE
D2 VB2 VSS DIODE
M8 VB2 VSS net2 VDD pch l=0.15 w=1 nf=1 m=1
Q1 net1 VB1 VDD qpnp m=1
Q6 net2 net1 VB1 qpnp m=1
Q7 net1 net2 net0 VSS qnpn m=1
R1 net0 VSS 8kΩ
.ends dut
