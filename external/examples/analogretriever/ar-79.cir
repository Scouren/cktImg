* official Analog Canvas netlist; PDK X cards rewritten by convert.py

.subckt dut VSS vo vi
G1 vo net0 VSS net0 1m
G2 vo net0 VSS net0 1m
G3 net0 VSS vi VSS 1m
R vo VSS 1k
R1 net0 VSS 1k
R2 vo net0 1k
.ends dut
