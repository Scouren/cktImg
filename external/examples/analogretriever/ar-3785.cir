* official Analog Canvas netlist; PDK X cards rewritten by convert.py

.subckt dut VDD VSS GND vo
.model NJF NJF(VTO=-2 BETA=1e-3 LAMBDA=0.01)
CC1 net0 net2 1p
CC2 net1 vo 1p
J1 VDD net2 net1 NJF m=1
RG net2 GND 50kΩ
RL vo GND 10kΩ
RS net1 VSS 1k
vi net0 GND DC 1
.ends dut
