* official Analog Canvas netlist; PDK X cards rewritten by convert.py
.model qnpn npn

.subckt dut VCC VSS vo
CC net2 net1 10uF
CL vo VSS 10pF
Q1 vo net1 VSS VSS qnpn m=1
RB VCC net1 1MegΩ
RC VCC vo 5.1kΩ
RL vo VSS 500kΩ
RS net0 net2 1kΩ
vi net0 VSS DC 1
.ends dut
