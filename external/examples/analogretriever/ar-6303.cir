* official Analog Canvas netlist; PDK X cards rewritten by convert.py
.model nch nmos
.model pch pmos

.subckt dut VDD VSS A B vO2
C vO1 VSS 1p
M1 A B vO1 VSS nch l=0.15 w=1 nf=1 m=1
MN vO2 vO1 VSS VSS nch l=0.15 w=1 nf=1 m=1
MP vO2 vO1 VDD VDD pch l=0.15 w=1 nf=1 m=1
MR vO1 vO2 VDD VDD pch l=0.15 w=1 nf=1 m=1
.ends dut
