* official Analog Canvas netlist; PDK X cards rewritten by convert.py

.subckt dut VSS vo
I2 VSS vo DC 1m
I4 VSS vo DC 1m
RL vo VSS 1k
ro2 vo VSS 1k
ro4 VSS vo 1k
.ends dut
