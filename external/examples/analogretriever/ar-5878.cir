* official Analog Canvas netlist; PDK X cards rewritten by convert.py
.model qnpn npn

.subckt dut VCC VSS Iout
Q1 net3 net3 net0 VSS qnpn m=1
Q2 net0 net0 net1 VSS qnpn m=1
Q3 Iout net3 net2 VSS qnpn m=1
R1 VCC net3 1k
R2 net1 VSS 1k
RE net2 VSS 1k
.ends dut
