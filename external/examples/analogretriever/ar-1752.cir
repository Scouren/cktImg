* official Analog Canvas netlist; PDK X cards rewritten by convert.py
.model nch nmos

.subckt dut VDD VSS Vin Vb1 Vb2 Vout
M1 net1 net0 VSS VSS nch l=0.15 w=1 nf=1 m=1
M2 Vout Vb1 net1 VSS nch l=0.15 w=1 nf=1 m=1
M3 VDD Vb2 net1 VSS nch l=0.15 w=1 nf=1 m=1
RD VDD Vout 1k
RG Vin net0 1k
.ends dut
