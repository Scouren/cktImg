* official Analog Canvas netlist; PDK X cards rewritten by convert.py
.model nch nmos

.subckt dut VDD VSS vX vY vZ vO
.model NMOS nmos level=54
ML VDD vO vO VSS NMOS l=150n m=1 nf=1 w=1u
MX vO vX VSS VSS nch l=0.15 w=1 nf=1 m=1
MY vO vY VSS VSS nch l=0.15 w=1 nf=1 m=1
MZ vO vZ VSS VSS nch l=0.15 w=1 nf=1 m=1
.ends dut
