* official Analog Canvas netlist; PDK X cards rewritten by convert.py
.model qnpn npn

.subckt dut V2n V2p
VB1 net0 V2n DC 1
Q1 net2 net2 V2n V2n qnpn m=1
Q2 V2p net2 net1 V2n qnpn m=1
R1 net0 net2 1k
R2 net0 V2p 1k
R3 net1 V2n 1k
.ends dut
