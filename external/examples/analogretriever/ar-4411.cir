* official Analog Canvas netlist; PDK X cards rewritten by convert.py

.subckt dut VSS Vo
G1 Vo net0 net1 net0 1m
RB net1 VSS 1k
RC Vo VSS 1k
RE net0 VSS 1k
RL Vo VSS 1k
Rpi net1 net0 1k
Vi net1 VSS DC 1
.ends dut
