* official Analog Canvas netlist; PDK X cards rewritten by convert.py
.model nch nmos

.subckt dut VSS vo
M1 vo vi net1 VSS nch l=0.15 w=1 nf=1 m=1
RD vo VSS 1k
Rs net1 VSS 1k
Rsig net0 vi 1k
Vsig net0 VSS DC 1
.ends dut
