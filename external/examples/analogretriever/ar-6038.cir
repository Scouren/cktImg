* official Analog Canvas netlist; PDK X cards rewritten by convert.py
.model qnpn npn
.model qpnp pnp

.subckt dut VCC VEE VSS Vin1 Vin2 VBIAS vo
I1 VCC net0 DC 1m
I2 VCC net4 DC 1m
I3 net3 VEE DC 1m
Q1 net0 Vin1 net3 VEE qnpn m=1
Q2 net4 Vin2 net3 VEE qnpn m=1
Q3 net1 VBIAS net0 qpnp m=1
Q4 vo VBIAS net4 qpnp m=1
Q5 vo net1 net2 VEE qnpn m=1
Q6 net1 net2 VEE VEE qnpn m=1
Q7 net2 net2 VEE VEE qnpn m=1
.ends dut
