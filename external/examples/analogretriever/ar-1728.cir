* official Analog Canvas netlist; PDK X cards rewritten by convert.py
.model qnpn npn

.subckt dut VCC VSS Vin Vout Vb
Q1 Vout Vb X VSS qnpn m=1
RB Vin X 1k
RC VCC Vout 1k
rO Vout X 1k
.ends dut
