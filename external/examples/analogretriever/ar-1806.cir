* official Analog Canvas netlist; PDK X cards rewritten by convert.py
.model nch nmos

.subckt dut VDD VSS Vin Vout Open
M1 X Vin net0 VSS nch l=0.15 w=1 nf=1 m=1
M2 Vout X VSS VSS nch l=0.15 w=1 nf=1 m=1
R1 VSS net0 1k
R2 net0 VSS 1k
R3 Vout Open 1k
R4 Open VSS 1k
RD1 VDD X 1k
RD2 VDD Vout 1k
.ends dut
