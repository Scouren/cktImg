* official Analog Canvas netlist; PDK X cards rewritten by convert.py
.model nch nmos
.model pch pmos

.subckt dut VDD VSS Vin Vout
ISS net1 VSS DC 1m
M1 VDD Vin net1 VSS nch l=0.15 w=1 nf=1 m=1
M2 net0 Vout net1 VSS nch l=0.15 w=1 nf=1 m=1
M3 Vout net0 VDD VDD pch l=0.15 w=1 nf=1 m=1
M4 net0 net0 VDD VDD pch l=0.15 w=1 nf=1 m=1
R1 Vout VSS 1k
.ends dut
