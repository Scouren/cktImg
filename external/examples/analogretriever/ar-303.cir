* official Analog Canvas netlist; PDK X cards rewritten by convert.py

.subckt dut VSS vo
Cgd G VSS 1p
Cgs G vo 1p
Csb vo VSS 1p
Gm VSS vo G vo 1m
Gmb vo VSS vo VSS 1m
RL vo VSS 1k
RS net0 G 1k
vi net0 VSS DC 1
.ends dut
