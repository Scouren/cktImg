* official Analog Canvas netlist; PDK X cards rewritten by convert.py
.model qnpn npn

.subckt dut VCC VSS Vin Vout
Q1 Vout net0 Vin VSS qnpn m=1
R1 Vout net0 1k
R2 net0 VSS 1k
RC VCC Vout 1k
.ends dut
