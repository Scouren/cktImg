* official Analog Canvas netlist; PDK X cards rewritten by convert.py
.model qnpn npn

.subckt dut VCC VSS Vin Vout
C1 Vin net1 1p
C2 net0 Vout 1p
Q1 VCC net1 net0 VSS qnpn m=1
R1 VCC net1 10kΩ
R2 net0 VSS 1kΩ
R3 Vout VSS 100Ω
.ends dut
