* official Analog Canvas netlist; PDK X cards rewritten by convert.py

.subckt dut VSS Vin Vout
C1 net0 Vout 1p
C2 Vout VSS 1p
R1 Vin net0 1k
R2 Vout VSS 1k
.ends dut
