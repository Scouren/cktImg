* official Analog Canvas netlist; PDK X cards rewritten by convert.py
.model pch pmos

.subckt dut VDD VSS GND vo
CC1 net1 net0 1p
CC2 net2 vo 1p
IQ VDD net2 DC 1m
M1 VSS net0 net2 VDD pch l=0.15 w=1 nf=1 m=1
RG net0 GND 200kΩ
RL vo GND 1k
Vi net1 GND DC 1
.ends dut
