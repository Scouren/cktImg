* official Analog Canvas netlist; PDK X cards rewritten by convert.py
.model nch nmos
.model pch pmos

.subckt dut VDD VSS Vin
.model DIODE D(IS=1e-14 N=1)
D1 net2 net0 DIODE
ISS net3 VSS DC 1m
M1 net2 X VDD VDD pch l=0.15 w=1 nf=1 m=1
M3 X Vin net3 VSS nch l=0.15 w=1 nf=1 m=1
M4 net1 net0 net3 VSS nch l=0.15 w=1 nf=1 m=1
M5 X net1 VDD VDD pch l=0.15 w=1 nf=1 m=1
M6 net1 net1 VDD VDD pch l=0.15 w=1 nf=1 m=1
RM net0 VSS 1k
.ends dut
