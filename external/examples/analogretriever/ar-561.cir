* official Analog Canvas netlist; PDK X cards rewritten by convert.py

.subckt opamp_differential VDD VSS VIP VIN VOP VON params: gain=1e6 vocm=0
VCM ncm 0 DC {vocm}
EPLUS VOP ncm VIP VIN {gain/2}
EMINUS VON ncm VIN VIP {gain/2}
.ends opamp_differential

.subckt dut VSS Vo1 Vo2 Vin1 Vin2
C1 Vo1 Vo2 6pF
C2 Vo1 VSS 7pF
C3 Vo2 VSS 7pF
X1 0 VSS Vin1 Vin2 Vo1 Vo2 opamp_differential gain=1e6 vocm=0
.ends dut
