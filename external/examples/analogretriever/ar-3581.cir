* official Analog Canvas netlist; PDK X cards rewritten by convert.py
.model qnpn npn

.subckt dut VCC VSS VIN VOUT
.model DIODE D(IS=1e-14 N=1)
DL net2 VOUT DIODE
QD net3 net1 net4 VSS qnpn m=1
QE net1 net0 VIN VSS qnpn m=1
QL VCC net3 net2 VSS qnpn m=1
QS VOUT net4 VSS VSS qnpn m=1
RB VCC net0 1k
RC VCC net3 1k
RE net4 VSS 1k
.ends dut
