* official Analog Canvas netlist; PDK X cards rewritten by convert.py
.model nch nmos

.subckt dut VDD VSS GND vo
CC1 net4 net3 1p
CC2 net2 net0 1p
CC3 net1 vo 1p
M1 VDD net3 net2 VSS nch l=0.15 w=1 nf=1 m=1
M2 net1 GND net0 VSS nch l=0.15 w=1 nf=1 m=1
RD net1 VDD 5kΩ
RG net3 GND 400kΩ
RL vo GND 2kΩ
RS1 net2 VSS 10kΩ
RS2 net0 VSS 10kΩ
Vi net4 GND DC 1
.ends dut
