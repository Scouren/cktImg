* official Analog Canvas netlist; PDK X cards rewritten by convert.py

.subckt dut VSS
C1 net0 net3 0.01uF
C2 net3 net1 0.022uF
R1 net2 net0 100kΩ
R2 net1 VSS 47kΩ
V1 net2 VSS DC 0 SIN(0 50 100 0 0 0)
.ends dut
