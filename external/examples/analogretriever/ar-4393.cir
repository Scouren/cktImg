* official Analog Canvas netlist; PDK X cards rewritten by convert.py
.model nch nmos

.subckt dut VDD VSS GND v1 v2 vO2 vO3
M1 net1 v1 net2 VSS nch l=0.15 w=1 nf=1 m=1
M2 vO2 v2 net2 VSS nch l=0.15 w=1 nf=1 m=1
M3 vO3 vO2 net3 VSS nch l=0.15 w=1 nf=1 m=1
M4 net0 net0 VSS VSS nch l=0.15 w=1 nf=1 m=1
M5 net2 net0 VSS VSS nch l=0.15 w=1 nf=1 m=1
R1 VDD net0 55kΩ
R2 VDD net1 40kΩ
R3 VDD vO2 40kΩ
R5 net3 GND 6kΩ
RD2 VDD vO3 4kΩ
.ends dut
