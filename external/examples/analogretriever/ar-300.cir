* official Analog Canvas netlist; PDK X cards rewritten by convert.py

.subckt dut VSS vo
Cin net1 vo 1p
Gm VSS vo net1 vo 1m
rin net1 vo 1k
RL vo VSS 1k
RS net0 net2 1k
rx net2 net1 1k
vi net0 VSS DC 1
.ends dut
