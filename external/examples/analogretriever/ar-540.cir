* official Analog Canvas netlist; PDK X cards rewritten by convert.py
.model nch nmos
.model pch pmos

.subckt dut VDD VSS VB1 Vi1 Vi2 VB2 VBB4 VBB3 Vo1 Vo2 Vcmc
M1 net2 Vi1 net1 VDD pch l=0.15 w=1 nf=1 m=1
M11 net2 Vcmc VSS VSS nch l=0.15 w=1 nf=1 m=1
M12 net3 Vcmc VSS VSS nch l=0.15 w=1 nf=1 m=1
M1A Vo1 VBB3 net2 VSS nch l=0.15 w=1 nf=1 m=1
M2 net3 Vi2 net1 VDD pch l=0.15 w=1 nf=1 m=1
M2A Vo2 VBB3 net3 VSS nch l=0.15 w=1 nf=1 m=1
M3 net0 VB2 VDD VDD pch l=0.15 w=1 nf=1 m=1
M3A Vo1 VBB4 net0 VDD pch l=0.15 w=1 nf=1 m=1
M4 net4 VB2 VDD VDD pch l=0.15 w=1 nf=1 m=1
M4A Vo2 VBB4 net4 VDD pch l=0.15 w=1 nf=1 m=1
M5 net1 VB1 VDD VDD pch l=0.15 w=1 nf=1 m=1
.ends dut
