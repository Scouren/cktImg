* official Analog Canvas netlist; PDK X cards rewritten by convert.py
.model nch nmos

.subckt dut VDD VSS Vout Vin
C1 net0 X 1p
M1 Vout net1 X VSS nch l=0.15 w=1 nf=1 m=1
R1 VDD net1 1k
R2 net1 VSS 1k
R3 X VSS 1k
RD VDD Vout 1k
RS Vin net0 1k
.ends dut
