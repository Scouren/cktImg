* official Analog Canvas netlist; PDK X cards rewritten by convert.py
.model nch nmos

.subckt dut VDD VSS Vout
C1 net1 net0 1p
M1 Vout net0 VSS VSS nch l=0.15 w=1 nf=1 m=1
R1 VDD net0 1k
R2 net0 VSS 1k
RD VDD Vout 1k
V1 net1 VSS DC 1
.ends dut
