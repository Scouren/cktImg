* official Analog Canvas netlist; PDK X cards rewritten by convert.py
.model qnpn npn

.subckt dut VCC VSS VIN VOUT
C1 VIN net0 1p
CE net4 VSS 1p
CO net3 VOUT 1p
Q1 net3 net0 net2 VSS qnpn m=1
Q2 net3 net2 net4 VSS qnpn m=1
RB1 VCC net0 1k
RB2 net0 VSS 1k
RC VCC net3 1k
RE net4 VSS 1k
RL VOUT VSS 1k
RT net1 VIN 1k
VT net1 VSS DC 1
.ends dut
