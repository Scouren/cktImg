* official Analog Canvas netlist; PDK X cards rewritten by convert.py
.model nch nmos
.model pch pmos

.subckt dut VDD VSS VG
.model DIODE D(IS=1e-14 N=1)
D1 net2 net0 DIODE
Ii VSS net3 DC 1m
M1 net1 VG net3 VSS nch l=0.15 w=1 nf=1 m=1
M2 net2 net1 VDD VDD pch l=0.15 w=1 nf=1 m=1
RD1 VDD net1 525Ω
RD2 net0 VSS 250Ω
RF net3 net0 500Ω
.ends dut
