* official Analog Canvas netlist; PDK X cards rewritten by convert.py
.model nch nmos
.model pch pmos

.subckt dut VDD VSS Vb Vin Vout
I1 net0 VSS DC 1mA
M1 net2 Vin VSS VSS nch l=0.15 w=1 nf=1 m=1
M2 Vout Vb net2 VSS nch l=0.15 w=1 nf=1 m=1
M3 Vout Vb net1 VDD pch l=0.15 w=1 nf=1 m=1
M4 net1 net0 VDD VDD pch l=0.15 w=1 nf=1 m=1
M5 net0 net0 VDD VDD pch l=0.15 w=1 nf=1 m=1
.ends dut
