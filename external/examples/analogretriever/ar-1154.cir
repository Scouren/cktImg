* official Analog Canvas netlist; PDK X cards rewritten by convert.py
.model nch nmos

.subckt dut VDD VSS
M1 Y X net0 VSS nch l=0.15 w=1 nf=1 m=1
R1 VDD X 4kΩ
R2 X VSS 10kΩ
RD VDD Y 1k
RS net0 VSS 1kΩ
.ends dut
