* official Analog Canvas netlist; PDK X cards rewritten by convert.py

.subckt dut VSS G S D
CGB G VSS 1p
CGDOV D G 1p
CGS S G 1p
G1 D S G S 1m
R1 D S 1k
.ends dut
