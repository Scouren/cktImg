* official Analog Canvas netlist; PDK X cards rewritten by convert.py
.model qnpn npn

.subckt dut VCC VSS Vin Vout
C1 Vin net2 0.5pF
C2 net1 VSS 0.5pF
I1 Vout VSS DC 1mA
Q1 net0 net2 net1 VSS qnpn m=1
Q2 VCC net0 Vout VSS qnpn m=1
R1 VCC net2 50kΩ
R2 VCC net0 1kΩ
R3 net1 VSS 100Ω
.ends dut
