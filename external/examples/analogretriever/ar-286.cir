* official Analog Canvas netlist; PDK X cards rewritten by convert.py

.subckt dut VSS vo
Cf v1 vo 1p
Cin v1 VSS 1p
G1 vo VSS v1 VSS 1m
rin v1 VSS 1k
RL vo VSS 1k
RS net0 net1 1k
rx net1 v1 1k
vi net0 VSS DC 1
.ends dut
