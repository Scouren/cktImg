* official Analog Canvas netlist; PDK X cards rewritten by convert.py
.model qnpn npn

.subckt dut VCC VSS Iout
IREF VCC net1 DC 1m
Q1 net1 net1 net2 VSS qnpn m=1
Q2 net2 net2 VSS VSS qnpn m=1
Q3 Iout net1 net0 VSS qnpn m=1
RE net0 VSS 1k
.ends dut
