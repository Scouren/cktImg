* official Analog Canvas netlist; PDK X cards rewritten by convert.py
.model qnpn npn
.model qpnp pnp

.subckt dut VEE VCC VSS v1 v2 vO
.model DIODE D(IS=1e-14 N=1)
D1 net1 net6 DIODE
D2 net6 net8 DIODE
Q1 net4 v1 net5 VEE qnpn m=1
Q10 net8 VB net9 VEE qnpn m=1
Q11 VCC net1 vO VEE qnpn m=1
Q12 VEE net8 vO qpnp m=1
Q2 net2 v2 net5 VEE qnpn m=1
Q3 net5 VB net3 VEE qnpn m=1
Q4 VB VB VEE VEE qnpn m=1
Q5 net4 net0 VCC qpnp m=1
Q6 net2 net0 VCC qpnp m=1
Q7 VEE net4 net0 qpnp m=1
Q8 net1 net7 VCC qpnp m=1
Q9 VEE net2 net7 qpnp m=1
R1 VCC VB 1k
R2 net3 VEE 1k
R3 net9 VEE 1k
RL vO VSS 1k
.ends dut
