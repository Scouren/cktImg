* official Analog Canvas netlist; PDK X cards rewritten by convert.py
.model nch nmos

.subckt dut VDD VSS Vout Vb
CX X VSS 1p
CY Vout VSS 1p
I1 VDD Vout DC 1m
M1 X net1 VSS VSS nch l=0.15 w=1 nf=1 m=1
M2 Vout Vb X VSS nch l=0.15 w=1 nf=1 m=1
rO2 Vout X 1k
RS net0 net1 1k
Vin net0 VSS DC 1
.ends dut
