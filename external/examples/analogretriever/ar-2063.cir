* official Analog Canvas netlist; PDK X cards rewritten by convert.py
.model nch nmos
.model pch pmos

.subckt dut VDD VSS C A B Vout
M1 Vout A net0 VSS nch l=0.15 w=1 nf=1 m=1
M2 net0 B VSS VSS nch l=0.15 w=1 nf=1 m=1
M3 Vout C VSS VSS nch l=0.15 w=1 nf=1 m=1
M4 Vout B net1 VDD pch l=0.15 w=1 nf=1 m=1
M5 Vout A net1 VDD pch l=0.15 w=1 nf=1 m=1
M6 net1 C VDD VDD pch l=0.15 w=1 nf=1 m=1
.ends dut
