* official Analog Canvas netlist; PDK X cards rewritten by convert.py
.model nch nmos

.subckt dut VDD VSS GND
IREF1 VDD net1 DC 1m
M1 net0 GND net2 VSS nch l=0.15 w=1 nf=1 m=1
M2 net2 net1 VSS VSS nch l=0.15 w=1 nf=1 m=1
M3 net1 net1 VSS VSS nch l=0.15 w=1 nf=1 m=1
RD VDD net0 8kΩ
.ends dut
