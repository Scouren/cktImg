* official Analog Canvas netlist; PDK X cards rewritten by convert.py
.model qnpn npn

.subckt dut VCC VSS vi vo
C1 vi net0 1p
C2 net1 vo 1p
Q1 net1 net0 net2 VSS qnpn m=1
Q2 net1 net2 VSS VSS qnpn m=1
R1 net0 net1 2MegΩ
R2 VCC net1 2kΩ
.ends dut
