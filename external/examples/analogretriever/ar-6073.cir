* official Analog Canvas netlist; PDK X cards rewritten by convert.py
.model nch nmos
.model qnpn npn
.model qpnp pnp

.subckt dut VCC VDD VEE vid+ vid- vo
M5 net3 net0 VEE VEE nch l=0.15 w=1 nf=1 m=1
M6 net0 net0 VEE VEE nch l=0.15 w=1 nf=1 m=1
M7 net4 net2 net0 VEE nch l=0.15 w=1 nf=1 m=1
M8 net2 net2 net3 VEE nch l=0.15 w=1 nf=1 m=1
Q1 net1 vid+ net4 VEE qnpn m=1
Q2 vo vid- net4 VEE qnpn m=1
Q3 net1 net1 VCC qpnp m=1
Q4 vo net1 VCC qpnp m=1
R net2 VDD 144kΩ
.ends dut
