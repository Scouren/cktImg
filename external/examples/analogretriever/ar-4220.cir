* official Analog Canvas netlist; PDK X cards rewritten by convert.py
.model qnpn npn

.subckt dut VCC VEE VSS vI vO
CE net0 VSS 1p
IO net0 VEE DC 1m
Q1 vO vI net0 VEE qnpn m=1
RC VCC vO 1k
.ends dut
