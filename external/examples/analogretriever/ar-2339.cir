* official Analog Canvas netlist; PDK X cards rewritten by convert.py
.model nch nmos

.subckt dut VSS Iout1 Iout2 VBIAS2 VBIAS1
M1 net1 VBIAS1 VSS VSS nch l=0.15 w=1 nf=1 m=1
M2 net0 VBIAS1 VSS VSS nch l=0.15 w=1 nf=1 m=1
M3 Iout1 VBIAS2 net1 VSS nch l=0.15 w=1 nf=1 m=1
M4 Iout2 VBIAS2 net0 VSS nch l=0.15 w=1 nf=1 m=1
.ends dut
