* official Analog Canvas netlist; PDK X cards rewritten by convert.py
.model qnpn npn

.subckt dut VCC VSS Iout1 Iout2 Iout3
Q1 Iout1 net0 net1 VSS qnpn m=1
Q2 Iout2 net0 net3 VSS qnpn m=2
Q3 Iout3 net0 net2 VSS qnpn m=4
QR net0 net0 net4 VSS qnpn m=1
R1 VCC net0 6.3kΩ
RE1 net1 VSS 1k
RE2 net3 VSS 1k
RE3 net2 VSS 1k
RER net4 VSS 3kΩ
.ends dut
