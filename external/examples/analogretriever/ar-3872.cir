* official Analog Canvas netlist; PDK X cards rewritten by convert.py
.model qnpn npn
.model qpnp pnp

.subckt dut VCC VEE VSS VE1 VE2 VC2
VB1 net0 VSS DC 1
Q1 VC1 net1 VE1 VEE qnpn m=1
Q2 VC2 VC1 VE2 qpnp m=1
RC1 VCC VC1 5kΩ
RC2 VC2 VEE 1.5kΩ
RE1 VE1 VEE 2kΩ
RE2 VCC VE2 2kΩ
RTH net0 net1 1k
.ends dut
