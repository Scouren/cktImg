* official Analog Canvas netlist; PDK X cards rewritten by convert.py
.model nch nmos
.model pch pmos

.subckt dut VDD VSS X Y Vb M3_S M4_S VC1 VC2
C1 net4 VC1 1p
C2 net2 VC2 1p
I1 net0 VSS DC 1m
M1 M3_S net3 net0 VSS nch l=0.15 w=1 nf=1 m=1
M2 M4_S net1 net0 VSS nch l=0.15 w=1 nf=1 m=1
M3 X Vb M3_S VDD pch l=0.15 w=1 nf=1 m=1
M4 Y Vb M4_S VDD pch l=0.15 w=1 nf=1 m=1
R1 net3 net4 1k
R2 net1 net2 1k
R3 X net3 1k
R4 Y net1 1k
.ends dut
