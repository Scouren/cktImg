* official Analog Canvas netlist; PDK X cards rewritten by convert.py
.model qnpn npn

.subckt dut VCC VEE VSS vo
Q1 VCC net2 net1 VEE qnpn m=1
Q2 VCC net1 vo VEE qnpn m=1
RE vo VEE 1k
Rsig net0 net2 1k
vsig net0 VSS DC 1
.ends dut
