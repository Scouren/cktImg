* official Analog Canvas netlist; PDK X cards rewritten by convert.py
.model nch nmos

.subckt dut VDD VSS Vin Vout
C1 net1 VSS 50pF
C2 net2 X 10pF
M1 net2 net0 net1 VSS nch l=0.15 w=1 nf=1 m=1
M2 Vout X VSS VSS nch l=0.15 w=1 nf=1 m=1
RD1 VDD net2 1kΩ
RD2 VDD Vout 1kΩ
RF X Vout 10kΩ
RS Vin net0 200Ω
RS1 net1 VSS 200Ω
.ends dut
