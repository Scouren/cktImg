* official Analog Canvas netlist; PDK X cards rewritten by convert.py
.model nch nmos
.model pch pmos

.subckt dut VDD VSS GND v1 v2 vo
CL vo GND 1p
IQ net2 VSS DC 1m
M1 net3 v1 net2 VSS nch l=0.15 w=1 nf=1 m=1
M2 net0 v2 net2 VSS nch l=0.15 w=1 nf=1 m=1
M3 net3 net3 VDD VDD pch l=0.15 w=1 nf=1 m=1
M4 net0 net0 VDD VDD pch l=0.15 w=1 nf=1 m=1
M5 net1 net3 VDD VDD pch l=0.15 w=1 nf=1 m=1
M6 vo net0 VDD VDD pch l=0.15 w=1 nf=1 m=1
M7 net1 net1 VSS VSS nch l=0.15 w=1 nf=1 m=1
M8 vo net1 VSS VSS nch l=0.15 w=1 nf=1 m=1
.ends dut
