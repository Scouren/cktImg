* official Analog Canvas netlist; PDK X cards rewritten by convert.py
.model qnpn npn

.subckt dut VSS
Cmu1 net2 VSS 1p
Cmu2 net0 net1 1p
Cpi1 net2 net1 1p
Cpi2 net1 VSS 1p
Q1 VSS net2 net1 VSS qnpn m=1
Q2 net0 net1 VSS VSS qnpn m=1
RL net0 VSS 1k
Rsig VSS net2 1k
.ends dut
