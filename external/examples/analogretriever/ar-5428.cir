* official Analog Canvas netlist; PDK X cards rewritten by convert.py

.subckt dut VSS Vs
L1 net0 VSS 50mH
L2 net0 VSS 50mH
R1 Vs net1 56Ω
R2 net1 VSS 22Ω
R3 net1 net0 33Ω
.ends dut
