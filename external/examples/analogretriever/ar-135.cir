* official Analog Canvas netlist; PDK X cards rewritten by convert.py

.subckt dut VSS vo vi
G1 VSS vo vo VSS 1m
G2 VSS vo vo VSS 1m
G3 vo VSS vi VSS 1m
R1 vo VSS 1k
R2 VSS vo 1k
.ends dut
