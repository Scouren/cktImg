* official Analog Canvas netlist; PDK X cards rewritten by convert.py
.model qnpn npn

.subckt dut VCC VSS vo
C1 net2 net0 1p
CB net1 vo 1p
Q1 VCC net0 vo VSS qnpn m=1
R1 net3 net2 10kΩ
R2 VCC net1 20kΩ
R3 net1 VSS 20kΩ
R4 net0 net1 10kΩ
R5 vo VSS 2kΩ
Vsig net3 VSS DC 1
.ends dut
