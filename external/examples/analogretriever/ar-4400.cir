* official Analog Canvas netlist; PDK X cards rewritten by convert.py

.subckt dut VSS Vi Vo
E1 net0 VSS Vi net1 1
R1 net1 VSS 1k
R2 net1 Vo 1k
Ri Vi net1 1k
Ro net0 Vo 1k
.ends dut
