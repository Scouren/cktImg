* official Analog Canvas netlist; PDK X cards rewritten by convert.py
.model nch nmos

.subckt dut
Cds net2 net0 1p
Cgd net1 net2 1p
Cgs net1 net0 1p
M1 net2 net1 net0 net0 nch l=0.15 w=1 nf=1 m=1
.ends dut
