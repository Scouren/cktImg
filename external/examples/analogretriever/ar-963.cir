* official Analog Canvas netlist; PDK X cards rewritten by convert.py
.model qnpn npn

.subckt dut VCC VSS vout VB
I1 net2 VSS DC 1m
Q1 vout net1 net2 VSS qnpn m=1
Q2 VCC net0 net2 VSS qnpn m=1
R1 net0 VB 1k
RC VCC vout 1k
Vin net1 VSS DC 1
.ends dut
