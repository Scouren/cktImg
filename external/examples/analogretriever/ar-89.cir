* official Analog Canvas netlist; PDK X cards rewritten by convert.py
.model nch nmos

.subckt dut VDD VSS GND voc1 voc2
ITAIL net1 VSS DC 1m
M1 voc1 net0 net1 GND nch l=0.15 w=1 nf=1 m=1
M2 voc2 net0 net1 GND nch l=0.15 w=1 nf=1 m=1
RD1 VDD voc1 1k
RD2 VDD voc2 1k
RTAIL net1 VSS 1k
vic net0 GND DC 1
.ends dut
