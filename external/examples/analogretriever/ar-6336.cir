* official Analog Canvas netlist; PDK X cards rewritten by convert.py
.model nch nmos
.model pch pmos

.subckt dut VDD VSS phi S R Q_bar
M1 Q_bar Q VSS VSS nch l=0.15 w=1 nf=1 m=1
M2 Q_bar Q VDD VDD pch l=0.15 w=1 nf=1 m=1
M3 Q Q_bar VSS VSS nch l=0.15 w=1 nf=1 m=1
M4 Q Q_bar VDD VDD pch l=0.15 w=1 nf=1 m=1
M5 net0 S VSS VSS nch l=0.15 w=1 nf=1 m=1
M6 Q_bar phi net0 VSS nch l=0.15 w=1 nf=1 m=1
M7 net1 R VSS VSS nch l=0.15 w=1 nf=1 m=1
M8 Q phi net1 VSS nch l=0.15 w=1 nf=1 m=1
.ends dut
