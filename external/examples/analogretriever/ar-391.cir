* official Analog Canvas netlist; PDK X cards rewritten by convert.py

.subckt dut VSS vbe vo
G1 net0 net0 vbe VSS 40mS
It vo VSS DC 1m
RC vo VSS 10kΩ
RF vbe vo 20kΩ
Ro vo VSS 1MegΩ
Rpi vbe VSS 5kΩ
.ends dut
