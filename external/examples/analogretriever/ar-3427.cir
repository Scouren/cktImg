* official Analog Canvas netlist; PDK X cards rewritten by convert.py
.model nch nmos

.subckt dut VDD VSS GND Vin Vout VGG
CO net1 Vout 1p
CS net2 GND 1p
M1 VDD VGG net1 net1 nch l=0.15 w=1 nf=1 m=1
M2 net1 Vin net2 net2 nch l=0.15 w=1 nf=1 m=1
RS net2 VSS 1k
RT net0 Vin 1k
VT net0 GND DC 1
.ends dut
