* official Analog Canvas netlist; PDK X cards rewritten by convert.py

.subckt dut VDD VB VI VO
.model DIODE D(IS=1e-14 N=1)
D1 VO net0 DIODE
D2 VB VO DIODE
R1 VI net0 0.5kΩ
R2 VDD VO 9.5kΩ
.ends dut
