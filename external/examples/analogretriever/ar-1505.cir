* official Analog Canvas netlist; PDK X cards rewritten by convert.py
.model qnpn npn

.subckt dut VCC VSS Vin1 Vin2 Vout1 Vout2
I1 VCC Vout1 DC 1m
I2 VCC Vout2 DC 1m
IEE P VSS DC 1m
Q1 Vout1 Vin1 P VSS qnpn m=1
Q2 Vout2 Vin2 P VSS qnpn m=1
.ends dut
