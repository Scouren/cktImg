* official Analog Canvas netlist; PDK X cards rewritten by convert.py
.model qnpn npn

.subckt dut VCC VEE VSS vO
CC net0 net3 1p
CE net1 VSS 1p
Q1 vO net3 net2 VEE qnpn m=1
RB net3 VSS 50kΩ
RC VCC vO 1k
RE net1 VEE 1k
RS net2 net1 100Ω
vs net0 VSS DC 1
.ends dut
