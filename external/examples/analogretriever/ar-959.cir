* official Analog Canvas netlist; PDK X cards rewritten by convert.py
.model qnpn npn

.subckt dut VSS vout
Q1 vout net0 net1 VSS qnpn m=1
R1 net0 VSS 1k
R2 VSS vout 1k
RC VSS vout 1k
RE net1 VSS 1k
RS net2 net0 1k
Vin net2 VSS DC 1
.ends dut
