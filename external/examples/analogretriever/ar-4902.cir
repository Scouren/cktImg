* official Analog Canvas netlist; PDK X cards rewritten by convert.py
.model qnpn npn
.model qpnp pnp

.subckt dut VCC VSS Vin
C1 Vin net1 1p
C2 Vin net3 1p
C3 net0 net4 1p
Q1 VCC net1 net0 VSS qnpn m=1
Q2 VSS net3 net0 qpnp m=1
R1 VCC net1 1k
R2 net1 net2 1k
R3 net2 net3 1k
R4 net3 VSS 1k
RL net4 VSS 1k
.ends dut
