* official Analog Canvas netlist; PDK X cards rewritten by convert.py

.subckt dut VSS
CE net1 VSS 1p
R1 VSS net0 1k
R2 net0 net1 1k
RE net1 VSS 1k
.ends dut
