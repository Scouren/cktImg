* official Analog Canvas netlist; PDK X cards rewritten by convert.py
.model qnpn npn
.model qpnp pnp

.subckt dut VCC1 VCC2 VEE VSS
Q1 net0 net0 VCC1 qpnp m=1
Q2 net5 net5 VEE VEE qnpn m=1
Q3 net4 net0 net6 qpnp m=1
Q4 net1 net0 VCC1 qpnp m=1
Q5 net1 net1 VSS VEE qnpn m=1
Q6 net2 net1 net3 VEE qnpn m=1
R1 net0 net5 10kΩ
R2 net4 VSS 1kΩ
R3 VCC2 net2 0.8kΩ
RE1 VCC1 net6 300Ω
RE2 net3 VSS 500Ω
.ends dut
