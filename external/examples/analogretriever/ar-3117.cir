* official Analog Canvas netlist; PDK X cards rewritten by convert.py
.model nch nmos

.subckt voltage_amplifier VDD VSS VIN VOUT params: gain=1
ECORE VOUT 0 VIN 0 {gain}
.ends voltage_amplifier

.subckt dut VSS Vout
Cc net1 X 1p
CL Vout VSS 1p
Iin VSS X DC 1m
M1 Vout X VSS VSS nch l=0.15 w=1 nf=1 m=1
R1 net1 net0 1k
RL Vout VSS 1k
Rs X VSS 1k
X1 0 VSS Vout net0 voltage_amplifier gain=1
.ends dut
