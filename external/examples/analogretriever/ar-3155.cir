* official Analog Canvas netlist; PDK X cards rewritten by convert.py

.subckt voltage_amplifier VDD VSS VIN VOUT params: gain=1
ECORE VOUT 0 VIN 0 {gain}
.ends voltage_amplifier

.subckt dut VSS Vout
C1 net0 X 1p
C2 X Vout 1p
Cin X VSS 1p
CL Vout VSS 1p
Vin net0 VSS DC 1
Vt net1 VSS DC 1
X1 0 VSS net1 Vout voltage_amplifier gain=1
.ends dut
