* official Analog Canvas netlist; PDK X cards rewritten by convert.py
.model nch nmos
.model pch pmos

.subckt dut VDD VSS VF
C1 net2 X 1p
C2 X VSS 1p
ISS net0 VSS DC 1m
M1 net1 VSS net0 VSS nch l=0.15 w=1 nf=1 m=1
M2 VF X net0 VSS nch l=0.15 w=1 nf=1 m=1
M3 net1 net1 VDD VDD pch l=0.15 w=1 nf=1 m=1
M4 VF net1 VDD VDD pch l=0.15 w=1 nf=1 m=1
Vt net2 VSS DC 1
.ends dut
