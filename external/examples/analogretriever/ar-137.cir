* official Analog Canvas netlist; PDK X cards rewritten by convert.py
.model nch nmos
.model pch pmos

.subckt dut VDD VSS Vic
IREF1 net0 VSS DC 1m
IREF2 VDD net2 DC 1m
M1 net3 Vic net1 VSS nch l=0.15 w=1 nf=1 m=1
M3 net3 net0 VDD VDD pch l=0.15 w=1 nf=1 m=1
M5 net0 net0 VDD VDD pch l=0.15 w=1 nf=1 m=1
M6 net2 net2 VSS VSS nch l=0.15 w=1 nf=1 m=1
M8 net1 net2 VSS VSS nch l=0.15 w=1 nf=1 m=1
.ends dut
