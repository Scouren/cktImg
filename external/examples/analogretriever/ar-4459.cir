* official Analog Canvas netlist; PDK X cards rewritten by convert.py
.model nch nmos
.model pch pmos

.subckt dut VDD VSS GND v1 v2 vo
IREF GND VB DC 1m
M1 net1 v1 net0 VSS nch l=0.15 w=1 nf=1 m=1
M10 net0 VB VSS VSS nch l=0.15 w=1 nf=1 m=1
M11 VB VB VSS VSS nch l=0.15 w=1 nf=1 m=1
M2 vo1 v2 net0 VSS nch l=0.15 w=1 nf=1 m=1
M3 net1 net1 VDD VDD pch l=0.15 w=1 nf=1 m=1
M4 vo1 net1 VDD VDD pch l=0.15 w=1 nf=1 m=1
M5 vo2 vo1 VDD VDD pch l=0.15 w=1 nf=1 m=1
M6 VDD vo2 vo VSS nch l=0.15 w=1 nf=1 m=1
M7 VSS net2 vo VDD pch l=0.15 w=1 nf=1 m=1
M8 vo2 vo2 net2 VSS nch l=0.15 w=1 nf=1 m=1
M9 net2 VB VSS VSS nch l=0.15 w=1 nf=1 m=1
.ends dut
