* official Analog Canvas netlist; PDK X cards rewritten by convert.py
.model qnpn npn

.subckt dut VCC VSS vo
C1 net1 net3 1p
C2 net2 vo 1p
Q1 net2 net3 net0 VSS qnpn m=1
R1 VCC net3 1k
R2 net3 VSS 1k
RC VCC net2 1k
RE net0 VSS 1k
RL vo VSS 1k
vi net1 VSS DC 1
.ends dut
