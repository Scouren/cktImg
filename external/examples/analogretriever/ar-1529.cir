* official Analog Canvas netlist; PDK X cards rewritten by convert.py

.subckt dut VSS G1 G2
Gm1 net1 P G1 P 1m
Gm2 net0 P G2 P 1m
RD1 VSS net1 1k
RD2 VSS net0 1k
Vin1 G1 VSS DC 1
Vin2 G2 VSS DC 1
.ends dut
