* official Analog Canvas netlist; PDK X cards rewritten by convert.py
.model qnpn npn
.model qpnp pnp

.subckt dut VCC VEE VSS vI vO Q2_E Q4_C
IBIAS net0 VEE DC 1m
Q1 vO vI net2 qpnp m=1
Q2 vO vI Q2_E VSS qnpn m=1
Q3 net1 net2 vO VSS qnpn m=1
Q4 Q4_C Q2_E vO qpnp m=1
Q5 net0 net1 VCC qpnp m=1
Q6 net2 net0 VCC qpnp m=1
Q7 net0 net0 VCC qpnp m=1
R VCC net1 1k
RL vO VSS 1k
.ends dut
