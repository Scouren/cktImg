* official Analog Canvas netlist; PDK X cards rewritten by convert.py
.model nch nmos
.model pch pmos

.subckt dut VDD VSS A B C F
CL F VSS 1p
M1 F A VDD VDD pch l=0.15 w=1 nf=1 m=1
M2 F B VDD VDD pch l=0.15 w=1 nf=1 m=1
M3 F C VDD VDD pch l=0.15 w=1 nf=1 m=1
M4 F A net0 VSS nch l=0.15 w=1 nf=1 m=1
M5 net0 B net1 VSS nch l=0.15 w=1 nf=1 m=1
M6 net1 C VSS VSS nch l=0.15 w=1 nf=1 m=1
.ends dut
