* official Analog Canvas netlist; PDK X cards rewritten by convert.py

.subckt dut
VB1 net1 net0 DC 1
R1 net0 A 1k
R2 A B 1k
R3 A B 1k
R4 net1 B 1k
.ends dut
