* official Analog Canvas netlist; PDK X cards rewritten by convert.py
.model qnpn npn

.subckt dut VCC VSS Iout
Q1 net1 net0 VSS VSS qnpn m=1
Q2 Iout net1 net0 VSS qnpn m=1
R1 VCC net1 1k
R2 net0 VSS 1k
.ends dut
