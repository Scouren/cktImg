* official Analog Canvas netlist; PDK X cards rewritten by convert.py
.model qnpn npn
.model qpnp pnp

.subckt dut VCC VSS vOUT
.model DIODE D(IS=1e-14 N=1)
C1 vIN net2 1p
CB net4 VSS 1p
Co net5 vOUT 1p
D1 net2 net0 DIODE
D2 net0 net4 DIODE
Q1 VCC net2 net1 VSS qnpn m=1
Q2 net5 net4 net1 qpnp m=1
RB1 VCC net2 1k
RB2 net4 VSS 1k
RC net5 VSS 1k
RL vOUT VSS 1k
RT net3 vIN 1k
VT net3 VSS DC 1
.ends dut
