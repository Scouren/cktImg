* official Analog Canvas netlist; PDK X cards rewritten by convert.py

.subckt dut
C net0 net1 1p
I1 net0 net1 DC 1m
L net0 net2 1n
RL net0 net1 1k
RS net2 net1 1k
.ends dut
