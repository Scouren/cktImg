* official Analog Canvas netlist; PDK X cards rewritten by convert.py
.model pch pmos

.subckt dut VDD VSS GND vO
CS net2 GND 1p
M1 vO net0 net2 VDD pch l=0.15 w=1 nf=1 m=1
RD vO VSS 1kΩ
RG net0 GND 100kΩ
Ri net1 net0 2kΩ
RS VDD net2 1.2kΩ
vi net1 GND DC 1
.ends dut
