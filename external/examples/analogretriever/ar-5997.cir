* official Analog Canvas netlist; PDK X cards rewritten by convert.py
.model qnpn npn

.subckt dut VCC VCC2 VEE VSS vo
C1 net3 VSS 1p
I1 net0 VEE DC 0.5mA
I2 net3 VEE DC 0.5mA
Q1 VCC2 net2 net0 VEE qnpn m=1
Q2 vo net0 net3 VEE qnpn m=1
R1 net1 net2 10kΩ
R2 VCC vo 10kΩ
vsig net1 VSS DC 1
.ends dut
