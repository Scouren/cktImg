* official Analog Canvas netlist; PDK X cards rewritten by convert.py
.model qnpn npn

.subckt dut VCC VSS
Q1 net0 net1 net2 VSS qnpn m=1
R1 VCC net0 500Ω
R2 net1 net0 20kΩ
R3 net2 VSS 400Ω
.ends dut
