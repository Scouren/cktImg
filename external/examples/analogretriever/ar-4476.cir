* official Analog Canvas netlist; PDK X cards rewritten by convert.py
.model nch nmos
.model pch pmos

.subckt dut VDD VSS vG5 vG9 vo
M5 net2 vG5 VDD VDD pch l=0.15 w=1 nf=1 m=1
M6 VDD net2 vo VSS nch l=0.15 w=1 nf=1 m=1
M7 VSS net0 vo VDD pch l=0.15 w=1 nf=1 m=1
M8N net1 net1 net0 VSS nch l=0.15 w=1 nf=1 m=1
M8P net1 net1 net2 VDD pch l=0.15 w=1 nf=1 m=1
M9 net0 vG9 VSS VSS nch l=0.15 w=1 nf=1 m=1
.ends dut
