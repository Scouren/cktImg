* official Analog Canvas netlist; PDK X cards rewritten by convert.py

.subckt dut
VB1 net2 net0 DC 5V
R1 net2 net0 1.0kΩ
R2 net2 net1 6.8kΩ
R3 net2 net1 3.3kΩ
R4 net0 net1 10kΩ
R5 net0 net1 5.6kΩ
.ends dut
