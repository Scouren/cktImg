* official Analog Canvas netlist; PDK X cards rewritten by convert.py
.model qpnp pnp

.subckt dut VCC VEE VSS vo
CC net1 vo 1p
Q1 VEE net0 net1 qpnp m=1
RE VCC net1 3.3kΩ
RL vo VSS 1kΩ
vs net0 VSS DC 1
.ends dut
