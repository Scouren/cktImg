* official Analog Canvas netlist; PDK X cards rewritten by convert.py
.model qnpn npn

.subckt dut VCC VSS Vin Vout
Q1 net3 Vin net0 VSS qnpn m=1
Q2 net1 net2 net0 VSS qnpn m=1
Q3 VCC net3 Vout VSS qnpn m=1
R1 VCC net3 1k
R2 VCC net1 1k
R3 net0 VSS 1k
R4 Vout VSS 1k
VREF net2 VSS DC 1
.ends dut
