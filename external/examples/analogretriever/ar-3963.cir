* official Analog Canvas netlist; PDK X cards rewritten by convert.py
.model qpnp pnp

.subckt dut VCC VSS vo
CC1 net2 net1 1p
CC2 net3 vo 1p
CE net0 VSS 1p
Q1 net3 net1 net0 qpnp m=1
R1 VCC net1 1k
R2 net1 VSS 1k
RC net3 VSS 4kΩ
RE VCC net0 1kΩ
RL vo VSS 1k
vs net2 VSS DC 1
.ends dut
