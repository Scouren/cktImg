* official Analog Canvas netlist; PDK X cards rewritten by convert.py
.model qnpn npn

.subckt dut VCC VSS
CB net2 VSS 1p
Q1 net0 net2 net1 VSS qnpn m=1
R1 VCC net2 1k
R2 net2 VSS 1k
RC VCC net0 1k
RE net1 VSS 1k
.ends dut
