* official Analog Canvas netlist; PDK X cards rewritten by convert.py
.model nch nmos
.model pch pmos

.subckt dut VDD VSS
M1 X net1 net2 VSS nch l=0.15 w=1 nf=1 m=1
M2 Y net1 net2 VSS nch l=0.15 w=1 nf=1 m=1
M3 X net0 VDD VDD pch l=0.15 w=1 nf=1 m=1
M4 Y VSS VDD VDD pch l=0.15 w=1 nf=1 m=1
RO3 VDD X 1k
Vn3 net0 VSS DC 1
.ends dut
