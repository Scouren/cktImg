* official Analog Canvas netlist; PDK X cards rewritten by convert.py
.model qnpn npn

.subckt dut VCC VSS Iout
Q1 Iout net0 VSS VSS qnpn m=1
Q2 Iout net0 VSS VSS qnpn m=1
Q3 Iout net0 VSS VSS qnpn m=1
QR net0 net0 VSS VSS qnpn m=1
R1 VCC net0 1k
.ends dut
