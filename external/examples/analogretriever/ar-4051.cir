* official Analog Canvas netlist; PDK X cards rewritten by convert.py
.model qpnp pnp

.subckt dut VCC VEE VSS vo
CC1 net0 net2 1p
CC2 net4 vo 1p
CE net1 VSS 1p
Q1 net4 net2 net1 qpnp m=1
R1 VCC net2 320kΩ
R2 net2 VEE 280kΩ
RC net4 VEE 5kΩ
RE VCC net1 10kΩ
RL vo VSS 2kΩ
RS net3 net0 0.1kΩ
vs net3 VSS DC 1
.ends dut
