* official Analog Canvas netlist; PDK X cards rewritten by convert.py
.model qnpn npn
.model qpnp pnp

.subckt dut VCC VEE VSS vIN1 vIN2 Output
IBIAS net2 VEE DC 1m
Q1 net1 vIN1 net2 VEE qnpn m=1
Q2 Output vIN2 net2 VEE qnpn m=1
Q3 net1 net0 VCC qpnp m=1
Q4 Output net0 VCC qpnp m=1
VREF net0 VSS DC 1
.ends dut
