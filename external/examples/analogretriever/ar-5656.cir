* official Analog Canvas netlist; PDK X cards rewritten by convert.py

.subckt dut VDD VSS GND V
.model DIODE D(IS=1e-14 N=1)
D1 net0 V DIODE
D2 net0 GND DIODE
I1 VDD net0 DC 10mA
I2 V VSS DC 3mA
.ends dut
