* official Analog Canvas netlist; PDK X cards rewritten by convert.py
.model nch nmos

.subckt dut VSS VDD GND Vo1 Vo2
ITAIL net1 VSS DC 1m
M1 Vo1 net2 net1 GND nch l=0.15 w=1 nf=1 m=1
M2 Vo2 net0 net1 GND nch l=0.15 w=1 nf=1 m=1
RD1 VDD Vo1 1k
RD2 VDD Vo2 1k
RTAIL net1 VSS 1k
Vi1 net2 GND DC 1
Vi2 net0 GND DC 1
.ends dut
