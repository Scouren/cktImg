* official Analog Canvas netlist; PDK X cards rewritten by convert.py
.model nch nmos
.model pch pmos

.subckt dut VDD VSS GND v1 v2 vo
C net1 vo 1p
M1 net2 v1 net4 VSS nch l=0.15 w=1 nf=1 m=1
M2 net1 v2 net4 VSS nch l=0.15 w=1 nf=1 m=1
M3 net2 net2 VDD VDD pch l=0.15 w=1 nf=1 m=1
M4 net1 net2 VDD VDD pch l=0.15 w=1 nf=1 m=1
M5 VDD VDD net0 VSS nch l=0.15 w=1 nf=1 m=1
M6 net0 net0 net3 VSS nch l=0.15 w=1 nf=1 m=1
M7 net3 net3 VSS VSS nch l=0.15 w=1 nf=1 m=1
M8 net4 net3 VSS VSS nch l=0.15 w=1 nf=1 m=1
RL vo GND 1k
.ends dut
