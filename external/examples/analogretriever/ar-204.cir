* official Analog Canvas netlist; PDK X cards rewritten by convert.py
.model nch nmos
.model pch pmos

.subckt dut VDD VSS Vi Vo
IBIAS net2 VSS DC 1m
ITAIL net3 VSS DC 1m
M1 Vo net1 VDD VDD pch l=0.15 w=1 nf=1 m=1
M11 net1 Vi net3 VSS nch l=0.15 w=1 nf=1 m=1
M12 net0 Vo net3 VSS nch l=0.15 w=1 nf=1 m=1
M13 net0 net0 VDD VDD pch l=0.15 w=1 nf=1 m=1
M14 net1 net0 VDD VDD pch l=0.15 w=1 nf=1 m=1
M15 VSS net2 net0 VDD pch l=0.15 w=1 nf=1 m=1
M16 VSS net2 net1 VDD pch l=0.15 w=1 nf=1 m=1
M17 net2 net0 VDD VDD pch l=0.15 w=1 nf=1 m=1
.ends dut
