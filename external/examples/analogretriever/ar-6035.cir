* official Analog Canvas netlist; PDK X cards rewritten by convert.py
.model nch nmos
.model pch pmos

.subckt dut VSS
M1 net0 VSS net2 VSS nch l=0.15 w=1 nf=1 m=1
M2 net1 VSS net2 VSS nch l=0.15 w=1 nf=1 m=1
M3 net0 net0 VSS VSS pch l=0.15 w=1 nf=1 m=1
M4 net1 net0 VSS VSS pch l=0.15 w=1 nf=1 m=1
ro1 net0 net2 1k
ro2 net1 net2 1k
ro3 VSS net0 1k
ro4 VSS net1 1k
Vx net1 VSS DC 1
.ends dut
