* official Analog Canvas netlist; PDK X cards rewritten by convert.py
.model nch nmos
.model pch pmos

.subckt dut VDD VSS GND Vin Vo
IBIAS net0 VSS DC 1m
M1 Vo Vin GND GND nch l=0.15 w=1 nf=1 m=1
M2 Vo net0 VDD VDD pch l=0.15 w=1 nf=1 m=1
M3 net0 net0 VDD VDD pch l=0.15 w=1 nf=1 m=1
Rsig net1 Vin 1k
Vsig net1 GND DC 1
.ends dut
