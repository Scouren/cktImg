* official Analog Canvas netlist; PDK X cards rewritten by convert.py
.model qnpn npn

.subckt dut VDD VSS Vin Vout
I1 VDD Vout DC 1m
Q1 net1 Vin net2 VSS qnpn m=1
Q2 Vout net1 net0 VSS qnpn m=1
R1 Vout net2 1k
R2 net2 VSS 1k
RD1 VDD net1 1k
RP net0 VSS 1k
.ends dut
