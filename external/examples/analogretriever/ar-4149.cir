* official Analog Canvas netlist; PDK X cards rewritten by convert.py
.model qnpn npn

.subckt dut VCC VSS vo
C net0 net1 1p
L1 net2 VSS 1n
L2 vo VSS 1n
Q1 VCC net1 net2 VSS qnpn m=1
R1 VCC net1 1k
R2 net1 VSS 1k
RL vo VSS 1k
Vi net0 VSS DC 1
KTF1 L1 L2 1
.ends dut
