* official Analog Canvas netlist; PDK X cards rewritten by convert.py
.model nch nmos
.model pch pmos

.subckt dut VDD VSS GND VIN+ VIN- VOUT
CC net5 VOUT 1p
CL VOUT GND 1p
IBIAS net4 VSS DC 1m
M1 net2 VIN+ net1 net1 pch l=0.15 w=1 nf=1 m=1
M2 net5 VIN- net1 net1 pch l=0.15 w=1 nf=1 m=1
M3 net2 net2 VSS VSS nch l=0.15 w=1 nf=1 m=1
M4 net5 net2 VSS VSS nch l=0.15 w=1 nf=1 m=1
M5 VOUT net5 VSS VSS nch l=0.15 w=1 nf=1 m=1
MB11 net1 net0 VDD VDD pch l=0.15 w=1 nf=1 m=1
MB12 VOUT net0 VDD VDD pch l=0.15 w=1 nf=1 m=1
MP1 net3 net0 VDD VDD pch l=0.15 w=1 nf=1 m=1
MP2 net0 net4 net3 VDD pch l=0.15 w=1 nf=1 m=1
RBIAS net0 net4 1k
.ends dut
