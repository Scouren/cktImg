* official Analog Canvas netlist; PDK X cards rewritten by convert.py

.subckt dut VSS Vout
.model DIODE D(IS=1e-14 N=1)
D2 Vout VSS DIODE
Iin VSS net0 DC 1m
R1 net0 Vout 1kΩ
R2 Vout VSS 2kΩ
.ends dut
