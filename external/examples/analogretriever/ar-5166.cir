* official Analog Canvas netlist; PDK X cards rewritten by convert.py

.subckt opamp VDD VSS VIP VIN VOUT params: gain=1e6 vhigh=5 vlow=-5
Blin nlin 0 V={gain*(V(VIP)-V(VIN))}
Bcore VOUT 0 V={0.5*(vhigh+(0.5*(vlow+V(nlin)+sqrt((V(nlin)-vlow)*(V(nlin)-vlow)+(1e-4*(vhigh-vlow))*(1e-4*(vhigh-vlow))+1e-12)))-sqrt((vhigh-(0.5*(vlow+V(nlin)+sqrt((V(nlin)-vlow)*(V(nlin)-vlow)+(1e-4*(vhigh-vlow))*(1e-4*(vhigh-vlow))+1e-12))))*(vhigh-(0.5*(vlow+V(nlin)+sqrt((V(nlin)-vlow)*(V(nlin)-vlow)+(1e-4*(vhigh-vlow))*(1e-4*(vhigh-vlow))+1e-12))))+(1e-4*(vhigh-vlow))*(1e-4*(vhigh-vlow))+1e-12))}
.ends opamp

.subckt dut VSS vin Vgate vout
.model NJF NJF(VTO=-2 BETA=1e-3 LAMBDA=0.01)
C1 vout net0 8.2nF
C2 net0 net1 8.2nF
J1 net0 Vgate VSS NJF m=1
R1 vin net0 18kΩ
R2 vout net1 36kΩ
X1 0 VSS VSS net1 vout opamp gain=1e6
.ends dut
