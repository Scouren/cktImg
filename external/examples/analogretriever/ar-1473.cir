* official Analog Canvas netlist; PDK X cards rewritten by convert.py
.model qnpn npn

.subckt Circuit P N
.ends Circuit

.subckt dut VCC VSS
IREF VCC net0 DC 1m
Q1 net1 net0 VSS VSS qnpn m=1
QREF net0 net0 VSS VSS qnpn m=1
X1 VCC net1 Circuit
.ends dut
