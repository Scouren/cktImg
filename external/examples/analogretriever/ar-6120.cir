* official Analog Canvas netlist; PDK X cards rewritten by convert.py
.model nch nmos
.model pch pmos

.subckt dut VSS Vin1 Vin2
CL VSS VSS 1p
Cm Vg3 VSS 1p
M1 Vg3 Vin1 net0 VSS nch l=0.15 w=1 nf=1 m=1
M2 VSS Vin2 net0 VSS nch l=0.15 w=1 nf=1 m=1
M3 Vg3 Vg3 VSS VSS pch l=0.15 w=1 nf=1 m=1
M4 VSS Vg3 VSS VSS pch l=0.15 w=1 nf=1 m=1
.ends dut
