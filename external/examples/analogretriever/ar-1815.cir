* official Analog Canvas netlist; PDK X cards rewritten by convert.py
.model nch nmos
.model pch pmos

.subckt dut VDD VSS Vb
Iin VSS net0 DC 1m
M1 X Vb net0 VSS nch l=0.15 w=1 nf=1 m=1
M2 net2 X VDD VDD pch l=0.15 w=1 nf=1 m=1
RD VDD X 1k
RF net0 net1 1k
RF2 VSS net3 1k
RL net2 net3 1k
RM net1 VSS 1k
RM2 net3 VSS 1k
RO2 net2 VSS 1k
.ends dut
