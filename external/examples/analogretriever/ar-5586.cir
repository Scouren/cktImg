* official Analog Canvas netlist; PDK X cards rewritten by convert.py

.subckt opamp VDD VSS VIP VIN VOUT params: gain=1e6 vhigh=5 vlow=-5
Blin nlin 0 V={gain*(V(VIP)-V(VIN))}
Bcore VOUT 0 V={0.5*(vhigh+(0.5*(vlow+V(nlin)+sqrt((V(nlin)-vlow)*(V(nlin)-vlow)+(1e-4*(vhigh-vlow))*(1e-4*(vhigh-vlow))+1e-12)))-sqrt((vhigh-(0.5*(vlow+V(nlin)+sqrt((V(nlin)-vlow)*(V(nlin)-vlow)+(1e-4*(vhigh-vlow))*(1e-4*(vhigh-vlow))+1e-12))))*(vhigh-(0.5*(vlow+V(nlin)+sqrt((V(nlin)-vlow)*(V(nlin)-vlow)+(1e-4*(vhigh-vlow))*(1e-4*(vhigh-vlow))+1e-12))))+(1e-4*(vhigh-vlow))*(1e-4*(vhigh-vlow))+1e-12))}
.ends opamp

* Potentiometer: end 1 to wiper r*pos, wiper to end 2 r*(1-pos)
.subckt potentiometer n1 nw n2 params: r=10k pos=0.5
R1 n1 nw {max(r*pos,1m)}
R2 nw n2 {max(r*(1-pos),1m)}
.ends potentiometer

.subckt dut VSS vI vO
R1 vI net2 1k
R2 net2 net0 1k
R3 net1 VSS 1k
X1 net1 net0 vO potentiometer pos=0.5 r=10k
X2 0 VSS VSS net2 vO opamp gain=1e6
.ends dut
