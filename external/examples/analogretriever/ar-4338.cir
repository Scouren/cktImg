* official Analog Canvas netlist; PDK X cards rewritten by convert.py
.model qnpn npn

.subckt dut VCC VEE VSS vO1 vO2
Q1 vO1 net1 net2 VEE qnpn m=1
Q2 vO2 net0 net2 VEE qnpn m=1
RC1 VCC vO1 1k
RC2 VCC vO2 1k
RE net2 VEE 1k
V1 net1 VSS DC 1
V2 net0 VSS DC 1
.ends dut
