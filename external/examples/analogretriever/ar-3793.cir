* official Analog Canvas netlist; PDK X cards rewritten by convert.py
.model nch nmos

.subckt dut VDD VSS GND vo
CC net1 vo 1p
CS net2 GND 1p
M1 net1 net0 net2 GND nch l=0.15 w=1 nf=1 m=1
RD VDD net1 1k
RG net0 GND 1k
RL vo GND 40kΩ
RS net2 VSS 1k
Vi net0 GND DC 1
.ends dut
