* official Analog Canvas netlist; PDK X cards rewritten by convert.py
.model qnpn npn
.model qpnp pnp

.subckt dut VCC VEE VSS vI vO
IBias VCC net1 DC 1m
Q1 net1 net0 vI VEE qnpn m=1
Qn VCC net1 vO VEE qnpn m=1
Qp VEE vI vO qpnp m=1
R1 net1 net0 1k
R2 net0 vI 1k
RL vO VSS 1k
.ends dut
