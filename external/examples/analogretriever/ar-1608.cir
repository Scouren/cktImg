* official Analog Canvas netlist; PDK X cards rewritten by convert.py
.model nch nmos
.model pch pmos

.subckt dut VDD VSS Vb3 Vb2 Vb1 Vin1 Vin2 Vout1 Vout2
ISS net1 VSS DC 1m
M1 net2 Vin1 net1 VSS nch l=0.15 w=1 nf=1 m=1
M2 net3 Vin2 net1 VSS nch l=0.15 w=1 nf=1 m=1
M3 Vout1 Vb1 net2 VSS nch l=0.15 w=1 nf=1 m=1
M4 Vout2 Vb1 net3 VSS nch l=0.15 w=1 nf=1 m=1
M5 net0 Vb2 Vout1 VSS nch l=0.15 w=1 nf=1 m=1
M6 net4 Vb2 Vout2 VSS nch l=0.15 w=1 nf=1 m=1
M7 net0 Vb3 VDD VDD pch l=0.15 w=1 nf=1 m=1
M8 net4 Vb3 VDD VDD pch l=0.15 w=1 nf=1 m=1
.ends dut
