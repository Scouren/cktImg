* official Analog Canvas netlist; PDK X cards rewritten by convert.py
.model qnpn npn
.model qpnp pnp

.subckt dut VCC VEE VSS Vin- Vin+ vo
C net2 net3 1p
I1 VCC net1 DC 0.1mA
I2 VCC net2 DC 1mA
Q1 net0 Vin- net1 qpnp m=1
Q2 net3 Vin+ net1 qpnp m=1
Q3 net0 net0 VEE VSS qnpn m=1
Q4 net3 net0 VEE VSS qnpn m=1
Q5 net2 net3 VEE VSS qnpn m=1
Q6 vo net3 VEE VSS qnpn m=1
Q7 VCC net2 vo VSS qnpn m=1
RL vo VSS 1k
.ends dut
