* official Analog Canvas netlist; PDK X cards rewritten by convert.py
.model qnpn npn

.subckt dut VCC VSS Vb Vout
I1 VCC net2 DC 1m
I2 VCC Vout DC 1m
Iin VSS net0 DC 1m
Q1 net2 Vb net0 VSS qnpn m=1
Q2 Vout net2 VSS VSS qnpn m=1
R1 Vout net1 1k
R2 net1 VSS 1k
RF net0 net1 1k
.ends dut
