* official Analog Canvas netlist; PDK X cards rewritten by convert.py
.model nch nmos
.model pch pmos

.subckt dut VDD VSS V2i+ V2i- BIAS Vg11
M21 net2 V2i+ VDD VDD pch l=0.15 w=1 nf=1 m=1
M22 Vg11 V2i- VDD VDD pch l=0.15 w=1 nf=1 m=1
M23 net2 BIAS net1 VSS nch l=0.15 w=1 nf=1 m=1
M24 Vg11 BIAS net0 VSS nch l=0.15 w=1 nf=1 m=1
M25 net1 net2 VSS VSS nch l=0.15 w=1 nf=1 m=1
M26 net0 net2 VSS VSS nch l=0.15 w=1 nf=1 m=1
.ends dut
