* official Analog Canvas netlist; PDK X cards rewritten by convert.py

.subckt dut VSS Bc Cc Ec
G1 VSS net0 Bc net0 1m
G2 Cc Ec net0 Ec 1m
R1 Bc net0 1k
R2 net0 Ec 1k
R3 Cc Ec 1k
.ends dut
