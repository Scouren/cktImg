* official Analog Canvas netlist; PDK X cards rewritten by convert.py
.model nch nmos
.model pch pmos

.subckt dut VSS Vin Vout
CDB1 Vout VSS 1p
CDB2 VSS Vout 1p
CGD1 net0 Vout 1p
CGD2 VSS Vout 1p
CGS1 net0 VSS 1p
CSB2 VSS VSS 1p
M1 Vout net0 VSS VSS nch l=0.15 w=1 nf=1 m=1
M2 Vout VSS VSS VSS pch l=0.15 w=1 nf=1 m=1
RS Vin net0 1k
.ends dut
