* official Analog Canvas netlist; PDK X cards rewritten by convert.py
.model qnpn npn

.subckt dut VSS vo
Q1 net4 net2 net3 VSS qnpn m=1
Q2 net1 net4 VSS VSS qnpn m=1
Q3 VSS net1 vo VSS qnpn m=1
R1 net0 net2 1k
R2 vo VSS 1k
RE net3 VSS 1k
RF net3 vo 1k
RL1 net4 VSS 1k
RL2 net1 VSS 1k
V1 net0 VSS DC 1
.ends dut
