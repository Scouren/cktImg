* official Analog Canvas netlist; PDK X cards rewritten by convert.py
.model qnpn npn

.subckt dut VCC VSS Vin Vout
C1 net0 Vin 1uF
C2 Vout net2 1uF
C3 net1 VSS 10uF
Q1 net2 net0 net1 VSS qnpn m=1
R1 VCC net0 100kΩ
R2 net0 VSS 10kΩ
RC VCC net2 4.7kΩ
RE net1 VSS 1.0kΩ
.ends dut
