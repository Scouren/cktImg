* official Analog Canvas netlist; PDK X cards rewritten by convert.py
.model nch nmos
.model pch pmos
.model qpnp pnp

.subckt dut VDD VSS Iout
M1 net0 net0 net1 VSS nch l=0.15 w=1 nf=1 m=1
M2 net2 net0 net3 VSS nch l=0.15 w=1 nf=1 m=1
M3 net0 net2 VDD VDD pch l=0.15 w=1 nf=1 m=1
M4 net2 net2 VDD VDD pch l=0.15 w=1 nf=1 m=1
M5 Iout net2 VDD VDD pch l=0.15 w=1 nf=1 m=1
Q6 VSS VSS net1 qpnp m=1
R net3 VSS 1k
.ends dut
