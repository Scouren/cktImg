* official Analog Canvas netlist; PDK X cards rewritten by convert.py
.model nch nmos

.subckt dut VDD VSS VBIAS VIN VOUT
IBIAS VDD VOUT DC 1m
M1 CP VIN VSS VSS nch l=0.15 w=1 nf=1 m=1
M2 VOUT VBIAS CP VSS nch l=0.15 w=1 nf=1 m=1
RL VDD VOUT 1k
.ends dut
