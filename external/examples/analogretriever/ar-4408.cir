* official Analog Canvas netlist; PDK X cards rewritten by convert.py

.subckt dut VSS
G1 net3 VSS net0 VSS 1m
G2 net1 net2 net3 net2 1m
Ii VSS net0 DC 1m
RB1 net0 VSS 1k
RC2 net1 VSS 1k
RCB net3 VSS 1k
RE2 net2 VSS 1k
RF net0 net2 1k
RL net1 VSS 1k
Rpi1 net0 VSS 1k
Rpi2 net3 net2 1k
RS net0 VSS 1k
.ends dut
