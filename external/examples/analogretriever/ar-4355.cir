* official Analog Canvas netlist; PDK X cards rewritten by convert.py
.model qnpn npn

.subckt dut VCC VEE v1 v2
Q1 net2 v1 net1 VEE qnpn m=1
Q2 net4 v2 net1 VEE qnpn m=1
Q3 net3 net3 VEE VEE qnpn m=1
Q4 net1 net3 net0 VEE qnpn m=1
R1 VCC net3 1k
R2 net0 VEE 1k
RC1 VCC net2 1k
RC2 VCC net4 1k
.ends dut
