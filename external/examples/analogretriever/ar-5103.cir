* official Analog Canvas netlist; PDK X cards rewritten by convert.py

.subckt icm_opamp_vdd_vss VDD VSS VIP VIN VOUT params: gain=1e6
Blin nlin 0 V={gain*(V(VIP)-V(VIN))}
Bcore VOUT 0 V={0.5*(V(VDD)+(0.5*(V(VSS)+V(nlin)+sqrt((V(nlin)-V(VSS))*(V(nlin)-V(VSS))+(1e-4*(V(VDD)-V(VSS)))*(1e-4*(V(VDD)-V(VSS)))+1e-12)))-sqrt((V(VDD)-(0.5*(V(VSS)+V(nlin)+sqrt((V(nlin)-V(VSS))*(V(nlin)-V(VSS))+(1e-4*(V(VDD)-V(VSS)))*(1e-4*(V(VDD)-V(VSS)))+1e-12))))*(V(VDD)-(0.5*(V(VSS)+V(nlin)+sqrt((V(nlin)-V(VSS))*(V(nlin)-V(VSS))+(1e-4*(V(VDD)-V(VSS)))*(1e-4*(V(VDD)-V(VSS)))+1e-12))))+(1e-4*(V(VDD)-V(VSS)))*(1e-4*(V(VDD)-V(VSS)))+1e-12))}
.ends icm_opamp_vdd_vss

.subckt dut VCC VEE VSS
iin VSS net2 DC 0 SIN(0 2.1213m 1k 0 0 0)
R1 net1 VSS 1Ω
R2 net2 net1 1kΩ
RL net0 net1 1Ω
X1 VCC VEE VSS net2 net0 icm_opamp_vdd_vss gain=1e6
.ends dut
