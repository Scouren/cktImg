* official Analog Canvas netlist; PDK X cards rewritten by convert.py
.model qnpn npn

.subckt dut VCC VEE VSS Vin1 Vin2
IBIAS net0 VEE DC 1m
Q1 vo1 Vin1 net0 VEE qnpn m=1
Q2 vo2 Vin2 net0 VEE qnpn m=1
RC1 VCC vo1 1k
RC2 VCC vo2 1k
RL1 vo1 VSS 1k
RL2 vo2 VSS 1k
.ends dut
