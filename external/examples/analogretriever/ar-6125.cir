* official Analog Canvas netlist; PDK X cards rewritten by convert.py
.model qnpn npn

.subckt dut VCC VEE VSS Vin Vout
I1 net0 VEE DC 1m
I2 VCC Vout DC 1m
Q1 VCC Vin net0 VEE qnpn m=1
Q2 Vout net0 VSS VEE qnpn m=1
.ends dut
