* official Analog Canvas netlist; PDK X cards rewritten by convert.py
.model nch nmos

.subckt dut VDD VSS Vin Vout
Ci Vin net0 1p
CL Vout VSS 1p
I1 Vout VSS DC 1m
M1 VDD net0 Vout VSS nch l=0.15 w=1 nf=1 m=1
Ri VDD net0 1k
.ends dut
