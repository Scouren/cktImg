* official Analog Canvas netlist; PDK X cards rewritten by convert.py
.model nch nmos

.subckt dut VDD VSS Vin1 Vin2 Vout1 Vout2
I1 VDD Vout1 DC 1m
I2 VDD Vout2 DC 1m
ISS1 P VSS DC 1m
ISS2 Q VSS DC 1m
M1 Vout1 Vin1 P VSS nch l=0.15 w=1 nf=1 m=1
M2 Vout2 Vin2 P VSS nch l=0.15 w=1 nf=1 m=1
M3 Vout1 Vout1 Q VSS nch l=0.15 w=1 nf=1 m=1
M4 Vout2 Vout2 Q VSS nch l=0.15 w=1 nf=1 m=1
.ends dut
