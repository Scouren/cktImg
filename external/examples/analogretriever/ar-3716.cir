* official Analog Canvas netlist; PDK X cards rewritten by convert.py
.model pch pmos

.subckt dut VDD VSS GND VS
IQ VDD VS DC 0.4mA
M1 net1 net0 VS VDD pch l=0.15 w=1 nf=1 m=1
RD net1 VSS 5kΩ
RG net0 GND 50kΩ
.ends dut
