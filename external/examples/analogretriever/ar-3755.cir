* official Analog Canvas netlist; PDK X cards rewritten by convert.py
.model nch nmos

.subckt dut VDD VSS vo
CC1 net2 net0 1p
CC2 net1 vo 1p
M1 net1 net0 VSS VSS nch l=0.15 w=1 nf=1 m=1
RD VDD net1 10kΩ
RG net0 net1 5MegΩ
RL vo VSS 5kΩ
Vi net2 VSS DC 1
.ends dut
