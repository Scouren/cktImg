* official Analog Canvas netlist; PDK X cards rewritten by convert.py
.model pch pmos
.model qnpn npn

.subckt dut VDD VSS v1 v2 vo
IQ VDD net1 DC 300uA
M1 net0 v1 net1 VDD pch l=0.15 w=1 nf=1 m=1
M2 vo1 v2 net1 VDD pch l=0.15 w=1 nf=1 m=1
Q1 vo vo1 net2 VSS qnpn m=1
RC VDD vo 1k
RD1 net0 VSS 1k
RD2 vo1 VSS 1k
RE net2 VSS 0.4kΩ
.ends dut
