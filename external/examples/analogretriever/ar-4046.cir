* official Analog Canvas netlist; PDK X cards rewritten by convert.py

.subckt dut VSS G S Vo
CL Vo VSS 1p
G1 S Vo S G 1m
RD Vo VSS 1k
RG G VSS 200kΩ
RL Vo VSS 1k
RS S VSS 1k
Vi G VSS DC 1
.ends dut
