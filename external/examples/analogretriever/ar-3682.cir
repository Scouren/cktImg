* official Analog Canvas netlist; PDK X cards rewritten by convert.py
.model nch nmos

.subckt dut VDD VSS GND vD
CS net1 GND 1p
IQ net1 VSS DC 1m
M1 vD net0 net1 VSS nch l=0.15 w=1 nf=1 m=1
RD VDD vD 1k
RG net0 GND 1k
Vi net0 GND DC 1
.ends dut
