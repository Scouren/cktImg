* official Analog Canvas netlist; PDK X cards rewritten by convert.py
.model nch nmos

.subckt dut VDD VSS vo
CC1 net0 net3 1p
CC2 net2 net1 1p
M1 vo net2 VSS VSS nch l=0.15 w=1 nf=1 m=1
R1 VDD net2 350kΩ
R2 net2 VSS 150kΩ
RD VDD vo 2kΩ
RF net1 vo 1k
RS net3 net2 20kΩ
vi net0 VSS DC 1
.ends dut
