* official Analog Canvas netlist; PDK X cards rewritten by convert.py
.model qnpn npn

.subckt voltage_amplifier VDD VSS VIN VOUT params: gain=1
ECORE VOUT 0 VIN 0 {gain}
.ends voltage_amplifier

.subckt dut VCC VEE VSS Vin Vout
I1 net1 VEE DC 2mA
Q1 net0 Vin net1 VEE qnpn m=1
Q2 VMID VSS net1 VEE qnpn m=1
R1 VCC net0 1kΩ
R2 VCC VMID 1kΩ
RL Vout VSS 1k
X1 0 VSS VMID Vout voltage_amplifier gain=1
.ends dut
