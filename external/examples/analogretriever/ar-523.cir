* official Analog Canvas netlist; PDK X cards rewritten by convert.py
.model nch nmos
.model pch pmos

.subckt dut VDD VSS VB VCM Voc Vcmc
M21 Vcmc VCM net1 VDD pch l=0.15 w=1 nf=1 m=1
M22 net0 Voc net1 VDD pch l=0.15 w=1 nf=1 m=1
M23 Vcmc Vcmc VSS VSS nch l=0.15 w=1 nf=1 m=1
M24 net0 net0 VSS VSS nch l=0.15 w=1 nf=1 m=1
M25 net1 VB VDD VDD pch l=0.15 w=1 nf=1 m=1
.ends dut
