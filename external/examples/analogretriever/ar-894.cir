* official Analog Canvas netlist; PDK X cards rewritten by convert.py
.model qnpn npn

.subckt dut VSS vout
Q1 vout net1 net0 VSS qnpn m=1
R1 net1 VSS 1k
R2 net1 VSS 1k
RC vout VSS 1k
RE net0 VSS 1k
vin net1 VSS DC 1
.ends dut
