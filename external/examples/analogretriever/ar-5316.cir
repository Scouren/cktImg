* official Analog Canvas netlist; PDK X cards rewritten by convert.py

.subckt dut A D
R1 A B 1k
R2 B net0 1k
R3 net0 C 1k
R4 B C 1k
R5 D C 1k
.ends dut
