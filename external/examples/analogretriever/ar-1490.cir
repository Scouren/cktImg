* official Analog Canvas netlist; PDK X cards rewritten by convert.py
.model qnpn npn

.subckt dut VCC VSS X Y vinp vinn
Q1 X vinp VSS VSS qnpn m=1
Q2 Y vinn VSS VSS qnpn m=1
RC1 VCC X 1k
RC2 VCC Y 1k
.ends dut
