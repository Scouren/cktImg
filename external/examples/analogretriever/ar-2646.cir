* official Analog Canvas netlist; PDK X cards rewritten by convert.py
.model nch nmos

.subckt dut VDD VSS Iout1 Iout2
IREF VDD net0 DC 1m
M1 net0 net0 VSS VSS nch l=0.15 w=1 nf=1 m=1
M2 net0 net0 VSS VSS nch l=0.15 w=1 nf=1 m=1
M3 Iout1 net0 VSS VSS nch l=0.15 w=1 nf=1 m=1
M4 Iout1 net0 VSS VSS nch l=0.15 w=1 nf=1 m=1
M5 Iout1 net0 VSS VSS nch l=0.15 w=1 nf=1 m=1
M6 Iout1 net0 VSS VSS nch l=0.15 w=1 nf=1 m=1
M7 Iout2 net0 VSS VSS nch l=0.15 w=1 nf=1 m=1
.ends dut
