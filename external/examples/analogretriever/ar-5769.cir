* official Analog Canvas netlist; PDK X cards rewritten by convert.py
.model qnpn npn

.subckt dut VEE VSS E
I E VEE DC 1m
Q1 VSS net0 E VEE qnpn m=1
R1 net0 E 6.8kΩ
R2 VSS net0 68kΩ
.ends dut
