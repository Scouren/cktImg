* official Analog Canvas netlist; PDK X cards rewritten by convert.py

.subckt dut VSS Vout
C1 Vout VSS 1p
L1 Vout VSS 1n
R1 net0 Vout 1k
R2 Vout VSS 1k
Vin net0 VSS DC 1
.ends dut
