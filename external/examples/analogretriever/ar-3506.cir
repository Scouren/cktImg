* official Analog Canvas netlist; PDK X cards rewritten by convert.py
.model qnpn npn

.subckt dut VCC VSS VIN VOUT
C1 VIN net4 1p
CB net5 VSS 1p
CE net0 VSS 1p
CO net2 VOUT 1p
Q1 net1 net4 net0 VSS qnpn m=1
Q2 net2 net5 net1 VSS qnpn m=1
RB1 VCC net5 1k
RB2 net5 net4 1k
RB3 net4 VSS 1k
RC VCC net2 1k
RE net0 VSS 1k
RL VOUT VSS 1k
RT net3 VIN 1k
VT net3 VSS DC 1
.ends dut
