* official Analog Canvas netlist; PDK X cards rewritten by convert.py
.model qnpn npn

.subckt dut VCC VSS vout
C1 net2 net1 1p
C2 net3 vout 1p
Q1 net3 net1 net4 VSS qnpn m=1
R1 VCC net1 1k
R2 net1 VSS 1k
RC VCC net3 1k
RE net4 VSS 1k
RL vout VSS 1k
RS net0 net2 1k
Vin net0 VSS DC 1
.ends dut
