* official Analog Canvas netlist; PDK X cards rewritten by convert.py

.subckt dut VSS
Cc net0 VSS 1p
Cstray net0 VSS 1p
ic net0 VSS DC 1m
RC net0 VSS 1k
RL net0 VSS 1k
.ends dut
