* official Analog Canvas netlist; PDK X cards rewritten by convert.py

.subckt dut VSS vo
F1 vo B V__icm_sense_bb587ca2bc1842c3 1
R1 __icm_sense_node_bb587ca2bc1842c3 E 1k
V__icm_sense_bb587ca2bc1842c3 B __icm_sense_node_bb587ca2bc1842c3 DC 0
RB1 B VSS 1k
RB2 B VSS 1k
RC vo VSS 1k
Re E VSS 1k
RL vo VSS 1k
Rsig net0 B 1k
Vsig net0 VSS DC 1
.ends dut
