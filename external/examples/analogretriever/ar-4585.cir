* official Analog Canvas netlist; PDK X cards rewritten by convert.py
.model qnpn npn

.subckt dut VCC VEE vY vX VR vO1 vO2
Q1 vO1 vX net0 VEE qnpn m=1
Q2 vO1 vY net0 VEE qnpn m=1
QR vO2 VR net0 VEE qnpn m=1
RC1 VCC vO1 1k
RC2 VCC vO2 1k
RE net0 VEE 1k
.ends dut
