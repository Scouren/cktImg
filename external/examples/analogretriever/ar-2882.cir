* official Analog Canvas netlist; PDK X cards rewritten by convert.py
.model nch nmos
.model pch pmos

.subckt dut VDD VSS
M1 X net2 net0 VSS nch l=0.15 w=1 nf=1 m=1
M2 Y net2 net0 VSS nch l=0.15 w=1 nf=1 m=1
M3 X net1 VDD VDD pch l=0.15 w=1 nf=1 m=1
M4 Y net3 VDD VDD pch l=0.15 w=1 nf=1 m=1
V1 net1 VSS DC 1
V2 net3 VSS DC 1
.ends dut
