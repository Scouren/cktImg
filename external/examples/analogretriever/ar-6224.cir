* official Analog Canvas netlist; PDK X cards rewritten by convert.py
.model qnpn npn

.subckt dut VCC VEE Iout
.model icm_zener_D1 D(BV=5.6)
D1 VEE net0 icm_zener_D1
Q1 VCC net0 net2 VEE qnpn m=1
Q2 Iout net1 VEE VEE qnpn m=1
R1 net2 net1 1k
R2 net1 VEE 1k
R3 VCC net0 1k
.ends dut
