* official Analog Canvas netlist; PDK X cards rewritten by convert.py

.subckt dut VDD VSS Vin Vout
.model NJF NJF(VTO=-2 BETA=1e-3 LAMBDA=0.01)
C1 Vin net1 1p
C2 net2 VSS 1p
C3 net0 net4 1p
C4 net3 VSS 1p
C5 net5 Vout 1p
J1 net0 net1 net2 NJF m=1
J2 net5 net4 net3 NJF m=1
R1 net1 VSS 1k
R2 net2 VSS 1k
R3 VDD net0 1k
R4 net4 VSS 1k
R5 net3 VSS 1k
R6 VDD net5 1k
R7 Vout VSS 1k
.ends dut
