* official Analog Canvas netlist; PDK X cards rewritten by convert.py
.model qnpn npn

.subckt dut VCC VSS
Ii VSS net1 DC 1m
Q14 VCC net1 net0 VSS qnpn m=1
Q15 net1 net0 VSS VSS qnpn m=1
R net0 VSS 1k
.ends dut
