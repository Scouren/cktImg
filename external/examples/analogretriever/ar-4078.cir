* official Analog Canvas netlist; PDK X cards rewritten by convert.py

.subckt dut VSS
Cmu1 net1 net2 1p
Cpi1 net1 VSS 1p
Cpi2 net2 VSS 1p
Gm1 net2 VSS net1 VSS 1m
R2 net2 VSS 1k
RB1 net1 VSS 1k
Ro1 net2 VSS 1k
Rpi1 net1 VSS 1k
RS net0 net1 1k
Vi net0 VSS DC 1
.ends dut
