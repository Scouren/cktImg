* official Analog Canvas netlist; PDK X cards rewritten by convert.py
.model nch nmos

.subckt dut VDD VSS VF
C1 X VSS 1p
C2 net0 X 1p
I1 VDD VF DC 1m
M1 VF X VSS VSS nch l=0.15 w=1 nf=1 m=1
Vt net0 VSS DC 1
.ends dut
