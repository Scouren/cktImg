* official Analog Canvas netlist; PDK X cards rewritten by convert.py
.model qnpn npn

.subckt dut VCC VSS Vo
C1 VSS Vo 1p
C2 net1 VSS 1p
C3 net1 net0 1p
C4 net2 VSS 1p
L net1 Vo 1n
LRFC VCC net1 1n
Q1 Vo net0 net2 VSS qnpn m=1
RB1 net1 net0 1k
RB2 net0 VSS 1k
RE net2 VSS 1k
.ends dut
