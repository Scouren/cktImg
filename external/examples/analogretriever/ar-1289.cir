* official Analog Canvas netlist; PDK X cards rewritten by convert.py
.model nch nmos

.subckt dut VDD VSS Vin Vout
C1 Vin net0 1p
I1 VDD Vout DC 1m
M1 Vout net1 VSS VSS nch l=0.15 w=1 nf=1 m=1
R1 net0 net1 1kΩ
R2 net1 Vout 10kΩ
.ends dut
