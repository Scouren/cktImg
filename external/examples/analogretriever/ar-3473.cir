* official Analog Canvas netlist; PDK X cards rewritten by convert.py
.model qnpn npn

.subckt dut VCC VEE Iout1 Iout2
Q1 Iout1 net2 net1 VEE qnpn m=1
Q2 Iout2 net2 net0 VEE qnpn m=1
R1 VCC net2 1k
R2 net2 VEE 1k
R3 net1 VEE 1k
R4 net0 VEE 1k
.ends dut
