* official Analog Canvas netlist; PDK X cards rewritten by convert.py

.subckt dut VSS vid vod
E1 vod VSS vid VSS 1
R net0 net1 1k
R3 vid vod 1k
V1 net1 vid DC 1
Vsd net0 VSS DC 1
.ends dut
