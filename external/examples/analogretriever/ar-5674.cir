* official Analog Canvas netlist; PDK X cards rewritten by convert.py

.subckt dut VDD VSS vI vO
.model DIODE D(IS=1e-14 N=1)
D1 vO net0 DIODE
D2 net1 vO DIODE
D3 VSS net1 DIODE
R1 vI vO 3kΩ
R2 VDD net0 1kΩ
R3 net1 VSS 1kΩ
.ends dut
