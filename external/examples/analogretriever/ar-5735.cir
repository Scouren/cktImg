* official Analog Canvas netlist; PDK X cards rewritten by convert.py
.model nch nmos

.subckt dut VDD VSS V2
M1 net0 net0 VSS VSS nch l=0.15 w=1 nf=1 m=1
M2 VDD VDD net0 VSS nch l=0.15 w=1 nf=1 m=1
M3 V2 net0 VSS VSS nch l=0.15 w=1 nf=1 m=1
M4 VDD VDD V2 VSS nch l=0.15 w=1 nf=1 m=1
.ends dut
