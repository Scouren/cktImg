* official Analog Canvas netlist; PDK X cards rewritten by convert.py
.model nch nmos
.model pch pmos

.subckt dut VDD VSS Y A_bar B A B_bar
M1 net1 A_bar VDD VDD pch l=0.15 w=1 nf=1 m=1
M2 Y B net1 VDD pch l=0.15 w=1 nf=1 m=1
M3 net2 A VDD VDD pch l=0.15 w=1 nf=1 m=1
M4 Y B_bar net2 VDD pch l=0.15 w=1 nf=1 m=1
M5 Y A net0 VSS nch l=0.15 w=1 nf=1 m=1
M6 net0 B VSS VSS nch l=0.15 w=1 nf=1 m=1
M7 Y A_bar net3 VSS nch l=0.15 w=1 nf=1 m=1
M8 net3 B_bar VSS VSS nch l=0.15 w=1 nf=1 m=1
.ends dut
