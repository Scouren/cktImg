* official Analog Canvas netlist; PDK X cards rewritten by convert.py

.subckt dut VSS
C net1 VSS 0.022uF
L net0 VSS 5.0mH
R1 net1 VSS 5.1kΩ
RW net1 net0 25Ω
V1 net1 VSS DC 0 SIN(0 1 15.9kHz 0 0 0)
.ends dut
