* official Analog Canvas netlist; PDK X cards rewritten by convert.py
.model nch nmos
.model pch pmos

.subckt dut VDD VSS vB vB_bar VR vO
C vO VSS 1p
M1 net0 vB net1 VSS nch l=0.15 w=1 nf=1 m=1
M2 vO vB_bar net1 VSS nch l=0.15 w=1 nf=1 m=1
M3 net0 net0 VDD VDD pch l=0.15 w=1 nf=1 m=1
M4 vO net0 VDD VDD pch l=0.15 w=1 nf=1 m=1
M5 net1 VR VSS VSS nch l=0.15 w=1 nf=1 m=1
.ends dut
