* official Analog Canvas netlist; PDK X cards rewritten by convert.py
.model qnpn npn

.subckt dut VEE VSS Vin1 Vin2 Iout1 Iout2
IEE net1 VEE DC 1m
In1 VSS net0 DC 1m
In2 VSS Vin2 DC 1m
Q1 Iout1 net0 net1 VEE qnpn m=1
Q2 Iout2 Vin2 net1 VEE qnpn m=1
Vn net0 Vin1 DC 1
.ends dut
