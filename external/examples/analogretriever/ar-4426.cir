* official Analog Canvas netlist; PDK X cards rewritten by convert.py

.subckt dut VSS
C1 net1 VSS 1p
G1 net0 VSS net1 VSS 1m
Ii VSS net1 DC 1m
RB net1 VSS 1k
RC net0 VSS 1k
RL net0 VSS 1k
Rpi net1 VSS 1k
.ends dut
