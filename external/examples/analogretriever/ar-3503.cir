* official Analog Canvas netlist; PDK X cards rewritten by convert.py
.model qnpn npn

.subckt dut VCC VEE VSS vIN vOUT
CE1 net4 VEE 1p
CE2 net1 VEE 1p
Q1 net2 vIN net4 VEE qnpn m=1
Q2 net5 net2 net1 VEE qnpn m=1
Q3 VCC net5 net0 VEE qnpn m=1
RB1 VCC vIN 1k
RB2 vIN VEE 1k
RC1 VCC net2 1k
RC2 VCC net5 1k
RE1 net4 VEE 1k
RE2 net1 VEE 1k
RE3 net0 vOUT 1k
RE4 vOUT VEE 1k
RL vOUT VSS 1k
RT vIN net3 1k
VT net3 VSS DC 1
.ends dut
