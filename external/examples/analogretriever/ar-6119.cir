* official Analog Canvas netlist; PDK X cards rewritten by convert.py
.model nch nmos

.subckt dut VSS Vicm Vocm
CSS net0 VSS 1p
M1 Vocm Vicm net0 VSS nch l=0.15 w=1 nf=1 m=1
RD VSS Vocm 1k
RSS net0 VSS 1k
.ends dut
