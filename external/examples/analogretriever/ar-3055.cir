* official Analog Canvas netlist; PDK X cards rewritten by convert.py
.model nch nmos
.model pch pmos

.subckt dut VDD VSS Vb1 Vb2 Vb3 Vb4 P
M10 net0 Vb1 VDD VDD pch l=0.15 w=1 nf=1 m=1
M11 Vout1 Vb2 net1 VDD pch l=0.15 w=1 nf=1 m=1
M12 Vout2 Vb2 net0 VDD pch l=0.15 w=1 nf=1 m=1
M13 Vout1 Vb3 net2 VSS nch l=0.15 w=1 nf=1 m=1
M14 Vout2 Vb3 net3 VSS nch l=0.15 w=1 nf=1 m=1
M15 net2 Vb4 VSS VSS nch l=0.15 w=1 nf=1 m=1
M16 net3 Vb4 VSS VSS nch l=0.15 w=1 nf=1 m=1
M7 P Vout1 VSS VSS nch l=0.15 w=1 nf=1 m=1
M8 P Vout2 VSS VSS nch l=0.15 w=1 nf=1 m=1
M9 net1 Vb1 VDD VDD pch l=0.15 w=1 nf=1 m=1
.ends dut
