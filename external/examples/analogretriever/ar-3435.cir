* official Analog Canvas netlist; PDK X cards rewritten by convert.py
.model nch nmos
.model pch pmos

.subckt dut VDD VSS GND vIN vOUT
CO net4 vOUT 1p
CS net1 GND 1p
M1 net4 vIN net1 VSS nch l=0.15 w=1 nf=1 m=1
M2 net2 GND net0 VSS nch l=0.15 w=1 nf=1 m=1
M3 net4 net2 VDD VDD pch l=0.15 w=1 nf=1 m=1
M4 net2 net2 VDD VDD pch l=0.15 w=1 nf=1 m=1
RS1 net1 VSS 1k
RS2 net0 VSS 1k
RT net3 vIN 1k
VT net3 GND DC 1
.ends dut
