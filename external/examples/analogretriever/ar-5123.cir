* official Analog Canvas netlist; PDK X cards rewritten by convert.py
.model qpnp pnp

.subckt icm_opamp_vdd_vss VDD VSS VIP VIN VOUT params: gain=1e6
Blin nlin 0 V={gain*(V(VIP)-V(VIN))}
Bcore VOUT 0 V={0.5*(V(VDD)+(0.5*(V(VSS)+V(nlin)+sqrt((V(nlin)-V(VSS))*(V(nlin)-V(VSS))+(1e-4*(V(VDD)-V(VSS)))*(1e-4*(V(VDD)-V(VSS)))+1e-12)))-sqrt((V(VDD)-(0.5*(V(VSS)+V(nlin)+sqrt((V(nlin)-V(VSS))*(V(nlin)-V(VSS))+(1e-4*(V(VDD)-V(VSS)))*(1e-4*(V(VDD)-V(VSS)))+1e-12))))*(V(VDD)-(0.5*(V(VSS)+V(nlin)+sqrt((V(nlin)-V(VSS))*(V(nlin)-V(VSS))+(1e-4*(V(VDD)-V(VSS)))*(1e-4*(V(VDD)-V(VSS)))+1e-12))))+(1e-4*(V(VDD)-V(VSS)))*(1e-4*(V(VDD)-V(VSS)))+1e-12))}
.ends icm_opamp_vdd_vss

.subckt dut VCC VEE VSS vin vout
.model NJF NJF(VTO=-2 BETA=1e-3 LAMBDA=0.01)
C1 vout net3 1p
C2 net0 VEE 1p
J1 net2 net0 VSS NJF m=1
Q2 net0 net3 VSS qpnp m=1
R1 VSS net1 1kΩ
R2 net1 vout 47kΩ
R3 vin net2 100kΩ
R4 net3 VSS 1k
R5 net0 VEE 1k
X1 VCC VEE net2 net1 vout icm_opamp_vdd_vss gain=1e6
.ends dut
