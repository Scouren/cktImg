* official Analog Canvas netlist; PDK X cards rewritten by convert.py
.model qnpn npn

.subckt dut VSS
Is VSS net3 DC 1m
Q1 net0 net3 VSS VSS qnpn m=1
Q2 net2 net0 net1 VSS qnpn m=1
R1 net3 VSS 1k
R2 net2 VSS 1k
RE net1 VSS 1k
RF net3 net1 1k
RL1 net0 VSS 1k
.ends dut
