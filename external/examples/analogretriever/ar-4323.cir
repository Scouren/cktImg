* official Analog Canvas netlist; PDK X cards rewritten by convert.py
.model nch nmos
.model qnpn npn

.subckt dut VDD VSS Iout
IREF VDD net2 DC 1m
M5 net2 net2 net4 VSS nch l=0.15 w=1 nf=1 m=1
M6 Iout net2 net3 VSS nch l=0.15 w=1 nf=1 m=1
Q1 net1 net1 VSS VSS qnpn m=1
Q2 net0 net1 VSS VSS qnpn m=1
Q3 net4 net4 net1 VSS qnpn m=1
Q4 net3 net4 net0 VSS qnpn m=1
.ends dut
