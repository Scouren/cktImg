* official Analog Canvas netlist; PDK X cards rewritten by convert.py
.model nch nmos
.model pch pmos

.subckt dut VDD VSS Inp Inn Out
M1 net1 Inp net0 VSS nch l=0.15 w=1 nf=1 m=1
M2 net2 Inn net0 VSS nch l=0.15 w=1 nf=1 m=1
M3 net1 net1 VDD VDD pch l=0.15 w=1 nf=1 m=1
M4 net2 net1 VDD VDD pch l=0.15 w=1 nf=1 m=1
M5 VDD net2 Out VSS nch l=0.15 w=1 nf=1 m=1
M6 VB VB VSS VSS nch l=0.15 w=1 nf=1 m=1
M7 net0 VB VSS VSS nch l=0.15 w=1 nf=1 m=1
M8 Out VB VSS VSS nch l=0.15 w=1 nf=1 m=1
R1 VDD VB 80kΩ
.ends dut
