* official Analog Canvas netlist; PDK X cards rewritten by convert.py
.model qpnp pnp

.subckt dut VCC VSS vo
CC1 net2 net1 1p
CC2 net0 vo 1p
Q1 VSS net1 net0 qpnp m=1
R1 VCC net1 1k
R2 net1 VSS 1k
RE VCC net0 1k
RL vo VSS 500Ω
vs net2 VSS DC 1
.ends dut
