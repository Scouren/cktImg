* official Analog Canvas netlist; PDK X cards rewritten by convert.py
.model qnpn npn

.subckt dut VCC VSS vout
C1 net3 net2 1p
CB net1 VSS 1p
Q1 vout net1 net2 VSS qnpn m=1
R1 vout net1 1k
R2 net1 VSS 1k
RC VCC vout 1k
RS net0 net3 1k
Vin net0 VSS DC 1
.ends dut
