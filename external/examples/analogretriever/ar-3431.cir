* official Analog Canvas netlist; PDK X cards rewritten by convert.py
.model nch nmos

.subckt dut VDD VSS vIN vOUT
CI net2 vIN 1p
CO net0 vOUT 1p
MD net0 vIN VSS VSS nch l=0.15 w=1 nf=1 m=1
ML VDD net0 net0 VSS nch l=0.15 w=1 nf=1 m=1
RG vIN net0 1k
RT net1 net2 1k
VT net1 VSS DC 1
.ends dut
