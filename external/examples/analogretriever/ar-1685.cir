* official Analog Canvas netlist; PDK X cards rewritten by convert.py
.model nch nmos

.subckt dut VDD VSS Vin Vb Vout
C2 Vout VSS 1p
CDB1 VDD VSS 1p
CGD1 VDD X 1p
CGD2 Vout Vb 1p
CGS1 X Vout 1p
CGS2 Vb VSS 1p
CSB2 VSS VSS 1p
M1 VDD X Vout VSS nch l=0.15 w=1 nf=1 m=1
M2 Vout Vb VSS VSS nch l=0.15 w=1 nf=1 m=1
RS Vin X 1k
.ends dut
