* official Analog Canvas netlist; PDK X cards rewritten by convert.py
.model nch nmos

.subckt dut VSS vin vout
M1 vout vin VSS VSS nch l=0.15 w=1 nf=1 m=1
RM2 VSS vout 1k
RO1 vout VSS 1k
RO2 VSS vout 1k
.ends dut
