* official Analog Canvas netlist; PDK X cards rewritten by convert.py
.model qnpn npn
.model qpnp pnp

.subckt dut VCC VSS Vin Vout
Q1 Vout net0 net1 VSS qnpn m=1
Q2 VSS VSS net1 qpnp m=1
RB Vin net0 1k
RC VCC Vout 1k
.ends dut
