* official Analog Canvas netlist; PDK X cards rewritten by convert.py
.model qnpn npn
.model qpnp pnp

.subckt dut VCC VSS Vin- Vin+ OUTPUT
.model DIODE D(IS=1e-14 N=1)
D3 net3 VSS DIODE
D7 VCC net1 DIODE
Q1 net3 Vin- net2 qpnp m=1
Q2 net0 Vin+ net2 qpnp m=1
Q4 net0 net3 VSS VSS qnpn m=1
Q5 OUTPUT net0 VSS VSS qnpn m=1
Q6 net2 net1 VCC qpnp m=1
R1 net1 VSS 1k
.ends dut
