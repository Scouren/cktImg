* official Analog Canvas netlist; PDK X cards rewritten by convert.py

.subckt dut VSS
VB1 net2 VSS DC 1
R1 net2 A 100Ω
R2 A net1 47Ω
R3 net1 VSS 47Ω
R4 A net0 68Ω
R5 A net0 39Ω
R6 net0 VSS 75Ω
.ends dut
