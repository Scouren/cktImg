* official Analog Canvas netlist; PDK X cards rewritten by convert.py
.model qnpn npn
.model qpnp pnp

.subckt dut VCC VEE VSS Vin Vout
.model DIODE D(IS=1e-14 N=1)
D1 1 Vin DIODE
D2 Vin 2 DIODE
I1 VCC 1 DC 1m
I2 2 VEE DC 1m
Q1 VCC 1 Vout VSS qnpn m=1
Q2 VEE 2 Vout qpnp m=1
RL Vout VSS 1k
.ends dut
