* official Analog Canvas netlist; PDK X cards rewritten by convert.py
.model qnpn npn

.subckt dut VSS vo
C1 net0 VSS 1p
Q2 net0 net2 VSS VSS qnpn m=1
Q4 vo net0 VSS VSS qnpn m=1
RL1 VSS net0 1k
RL2 vo VSS 1k
RS net1 net2 1k
Vs net1 VSS DC 1
.ends dut
