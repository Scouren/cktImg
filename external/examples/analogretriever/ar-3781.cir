* official Analog Canvas netlist; PDK X cards rewritten by convert.py

.subckt dut VSS Vgs1 Vo
Gm1 net0 VSS Vgs1 VSS 1m
Gm2 Vo net0 VSS net0 1m
R32 Vgs1 VSS 1k
RD Vo VSS 1k
Vi Vgs1 VSS DC 1
.ends dut
