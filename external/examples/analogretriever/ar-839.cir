* official Analog Canvas netlist; PDK X cards rewritten by convert.py
.model qnpn npn

.subckt dut VCC VSS
Q1 Y X VSS VSS qnpn m=1
R1 VCC X 17kΩ
R2 X VSS 8kΩ
RC VCC Y 5kΩ
.ends dut
