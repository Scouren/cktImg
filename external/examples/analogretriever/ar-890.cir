* official Analog Canvas netlist; PDK X cards rewritten by convert.py
.model qnpn npn

.subckt dut VCC VSS
C1 net1 X 1p
C2 net0 net2 1p
Q1 net0 X VSS VSS qnpn m=1
R1 net2 VSS 8
RB VCC X 100kΩ
RC VCC net0 1kΩ
V1 net1 VSS DC 1
.ends dut
