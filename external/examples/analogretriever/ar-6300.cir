* official Analog Canvas netlist; PDK X cards rewritten by convert.py
.model nch nmos
.model pch pmos

.subckt dut VDD VSS A B C D Y
MNA Y A net1 VSS nch l=0.15 w=1 nf=1 m=1
MNB net1 B net0 VSS nch l=0.15 w=1 nf=1 m=1
MNC net0 C net2 VSS nch l=0.15 w=1 nf=1 m=1
MND net2 D VSS VSS nch l=0.15 w=1 nf=1 m=1
MP Y VSS VDD VDD pch l=0.15 w=1 nf=1 m=1
.ends dut
