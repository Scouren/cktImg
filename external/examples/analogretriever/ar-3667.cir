* official Analog Canvas netlist; PDK X cards rewritten by convert.py

.subckt dut VSS V1 V2
.model DIODE D(IS=1e-14 N=1)
D1 net1 net0 DIODE
R1 V1 net0 10kΩ
R2 net0 VSS 10kΩ
R3 net1 VSS 10kΩ
R4 net1 V2 10kΩ
.ends dut
