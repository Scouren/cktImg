* official Analog Canvas netlist; PDK X cards rewritten by convert.py
.model nch nmos

.subckt dut VDD VSS Vin Vout
C1 Vout VF 1p
C2 VF VSS 1p
M1 Vout VF Vin VSS nch l=0.15 w=1 nf=1 m=1
RD VDD Vout 1k
.ends dut
