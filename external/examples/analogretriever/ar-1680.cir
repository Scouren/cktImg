* official Analog Canvas netlist; PDK X cards rewritten by convert.py
.model nch nmos
.model pch pmos

.subckt dut VDD VSS Vin Vout Vb
C1 X VSS 1p
C2 Vout VSS 1p
CSB2 VDD VSS 1p
M1 Vout Vb X VSS nch l=0.15 w=1 nf=1 m=1
M2 Vout Vout VDD VDD pch l=0.15 w=1 nf=1 m=1
RS Vin X 1k
.ends dut
