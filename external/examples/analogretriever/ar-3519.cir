* official Analog Canvas netlist; PDK X cards rewritten by convert.py
.model qnpn npn
.model qpnp pnp

.subckt dut VCC VEE VSS Vin Vout
.model DIODE D(IS=1e-14 N=1)
D1 net0 net2 DIODE
D2 net2 net3 DIODE
ILS net3 VEE DC 1m
Q3 VCC Vin net1 VEE qnpn m=1
Q4 VCC net0 Vout VEE qnpn m=1
Q5 VEE net3 Vout qpnp m=1
RE3 net1 net0 1k
RE4 Vout VEE 1k
RE5 VCC Vout 1k
RL Vout VSS 1k
.ends dut
