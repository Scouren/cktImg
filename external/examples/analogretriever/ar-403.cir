* official Analog Canvas netlist; PDK X cards rewritten by convert.py

.subckt dut VSS vo
E1 net0 VSS net1 VSS 1
Ri net1 VSS 1k
RL vo VSS 1k
Ro net0 vo 1k
vs net1 VSS DC 1
.ends dut
