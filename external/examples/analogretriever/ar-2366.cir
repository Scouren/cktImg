* official Analog Canvas netlist; PDK X cards rewritten by convert.py

.subckt opamp_differential VDD VSS VIP VIN VOP VON params: gain=1e6 vocm=0
VCM ncm 0 DC {vocm}
EPLUS VOP ncm VIP VIN {gain/2}
EMINUS VON ncm VIN VIP {gain/2}
.ends opamp_differential

.subckt dut VSS VIN+ VIN- VOUT+ VOUT-
CD1 net0 VIN+ 1p
CD2 net1 VIN- 1p
CF1 VOUT+ net0 1p
CF2 VOUT- net1 1p
CL1 VSS VOUT+ 1p
CL2 VOUT- VSS 1p
CS1 net0 VIN+ 1p
CS2 net1 VIN- 1p
X1 0 VSS net0 net1 VOUT- VOUT+ opamp_differential gain=1e6 vocm=0
.ends dut
