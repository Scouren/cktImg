* official Analog Canvas netlist; PDK X cards rewritten by convert.py
.model nch nmos

.subckt dut VDD VSS
.model NMOS_DEP nmos level=54 vth0=-1
M1 net1 net0 VSS VSS nch l=0.15 w=1 nf=1 m=1
M2 net0 net1 VSS VSS nch l=0.15 w=1 nf=1 m=1
M3 VDD net1 net1 VSS nmos_dep l=150n m=1 nf=1 w=1u
M4 VDD net0 net0 VSS nmos_dep l=150n m=1 nf=1 w=1u
.ends dut
