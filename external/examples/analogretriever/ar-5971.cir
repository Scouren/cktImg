* official Analog Canvas netlist; PDK X cards rewritten by convert.py
.model qnpn npn

.subckt dut VCC VSS C
I1 VCC C DC 0.1mA
isig VSS net0 DC 1m
Q1 C VSS net0 VSS qnpn m=1
Rsig net0 VSS 10kΩ
.ends dut
