* official Analog Canvas netlist; PDK X cards rewritten by convert.py
.model nch nmos
.model pch pmos

.subckt dut VDD VSS Vo2 Vi1 Vi2 Vo1 VB1 VB2
M1 net0 Vi1 net2 VSS nch l=0.15 w=1 nf=1 m=1
M2 net1 Vi2 net2 VSS nch l=0.15 w=1 nf=1 m=1
M3 net0 net0 VDD VDD pch l=0.15 w=1 nf=1 m=1
M4 net1 net1 VDD VDD pch l=0.15 w=1 nf=1 m=1
M5 net2 VB1 VSS VSS nch l=0.15 w=1 nf=1 m=1
M6 Vo1 net1 VDD VDD pch l=0.15 w=1 nf=1 m=1
M7 Vo1 VB2 VSS VSS nch l=0.15 w=1 nf=1 m=1
M8 Vo2 net0 VDD VDD pch l=0.15 w=1 nf=1 m=1
M9 Vo2 VB2 VSS VSS nch l=0.15 w=1 nf=1 m=1
.ends dut
