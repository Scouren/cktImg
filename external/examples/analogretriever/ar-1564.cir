* official Analog Canvas netlist; PDK X cards rewritten by convert.py
.model nch nmos

.subckt dut VSS
ISS P VSS DC 1m
M1 net0 VSS P VSS nch l=0.15 w=1 nf=1 m=1
M2 net1 VSS P VSS nch l=0.15 w=1 nf=1 m=1
rO1 net0 P 1k
rO2 net1 P 1k
vX net1 net0 DC 1
.ends dut
