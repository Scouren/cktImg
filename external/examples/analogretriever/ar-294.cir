* official Analog Canvas netlist; PDK X cards rewritten by convert.py

.subckt dut VSS vo
Cgd v1 vo 1p
Cgs v1 VSS 1p
G1 vo VSS v1 VSS 1m
RL vo VSS 1k
RS net0 v1 1k
Vi net0 VSS DC 1
.ends dut
