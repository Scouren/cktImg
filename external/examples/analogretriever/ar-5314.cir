* official Analog Canvas netlist; PDK X cards rewritten by convert.py

.subckt dut A C
R1 net1 B 1k
R2 B net0 1k
R3 B C 1k
R4 A net1 1k
R5 net0 C 1k
R6 A B 1k
.ends dut
