* official Analog Canvas netlist; PDK X cards rewritten by convert.py
.model nch nmos

.subckt dut VDD VSS
M1 net1 net2 net0 VSS nch l=0.15 w=1 nf=1 m=1
R1 VDD net2 14kΩ
R2 net2 VSS 6kΩ
RD VDD net1 1.2kΩ
RS net0 VSS 0.5kΩ
.ends dut
