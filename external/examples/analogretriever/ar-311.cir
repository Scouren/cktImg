* official Analog Canvas netlist; PDK X cards rewritten by convert.py

.subckt dut VSS vo
Gm VSS vo net0 vo 1m
I1 vo net0 DC 1m
Rb net1 net0 1k
RL vo VSS 1k
Rpi net0 vo 1k
RS net1 VSS 1k
.ends dut
