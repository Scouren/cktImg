* official Analog Canvas netlist; PDK X cards rewritten by convert.py
.model qnpn npn

.subckt dut VCC VEE v1 v2
Q1 net1 v1 net0 VEE qnpn m=1
Q2 net3 v2 net0 VEE qnpn m=1
Q3 net2 net2 VEE VEE qnpn m=1
Q4 net0 net2 VEE VEE qnpn m=1
R1 VCC net2 18.6kΩ
RC1 VCC net1 8kΩ
RC2 VCC net3 8kΩ
.ends dut
