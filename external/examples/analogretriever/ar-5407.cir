* official Analog Canvas netlist; PDK X cards rewritten by convert.py

.subckt dut VSS
C1 net3 net4 0.015uF
C2 net1 VSS 0.047uF
R1 net4 net2 1.0kΩ
R2 net2 net0 680Ω
R3 net0 net1 1.0kΩ
R4 net1 VSS 910Ω
Vs net3 VSS DC 0 SIN(0 1 1k 0 0 0)
.ends dut
