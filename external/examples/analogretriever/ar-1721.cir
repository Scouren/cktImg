* official Analog Canvas netlist; PDK X cards rewritten by convert.py
.model nch nmos

.subckt dut VDD VSS Vin Vout
CL1 X VSS 1p
CL2 Vout VSS 1p
M1 X Vin VSS VSS nch l=0.15 w=1 nf=1 m=1
M2 Vout X VSS VSS nch l=0.15 w=1 nf=1 m=1
RD1 VDD X 1k
RD2 VDD Vout 1k
.ends dut
