* official Analog Canvas netlist; PDK X cards rewritten by convert.py

.subckt dut
C1 net2 net3 0.1uF
C2 net1 net0 0.22uF
R1 net3 net0 100Ω
R2 net3 net0 100Ω
V1 net2 net1 DC 0 SIN(0 1 1k 0 0 0)
.ends dut
