* official Analog Canvas netlist; PDK X cards rewritten by convert.py

.subckt dut VDD VSS GND
M1 GND net1 net0 VDD dpmos l=150n m=1 nf=1 w=1u
R1 VDD net1 1k
R2 net1 VSS 1k
RS VDD net0 2kΩ
.ends dut
