* official Analog Canvas netlist; PDK X cards rewritten by convert.py

.subckt dut VSS vout
G1 vout net1 net0 net1 1m
RB VSS net0 1k
RC vout VSS 1k
rpi net0 net1 1k
vX net1 VSS DC 1
.ends dut
