* official Analog Canvas netlist; PDK X cards rewritten by convert.py
.model qnpn npn
.model qpnp pnp

.subckt dut VCC VEE
Q1 net1 net0 net4 qpnp m=1
Q2 net3 net1 net2 VEE qnpn m=1
R1 VCC net0 50kΩ
R2 net0 VEE 100kΩ
RC1 net1 VEE 1k
RC2 VCC net3 1k
RE1 VCC net4 1k
RE2 net2 VEE 1k
.ends dut
