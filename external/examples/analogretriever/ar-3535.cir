* official Analog Canvas netlist; PDK X cards rewritten by convert.py
.model qnpn npn

.subckt dut VCC VSS vOUT
CI net0 net2 10uF
Q1 net3 net2 VSS VSS qnpn m=1
Q2 VCC net3 net1 VSS qnpn m=1
Q3 VCC net1 vOUT VSS qnpn m=1
R1 VCC net3 2kΩ
R2 net1 VSS 3.3kΩ
R3 vOUT VSS 2.6kΩ
RB VCC net2 265kΩ
VIN net0 VSS DC 1
.ends dut
