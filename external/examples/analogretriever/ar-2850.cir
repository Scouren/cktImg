* official Analog Canvas netlist; PDK X cards rewritten by convert.py
.model nch nmos
.model pch pmos

.subckt dut VDD VSS Vn_out
In_R1 VDD Vn_out DC 1m
M1 Vn_out net1 VSS VSS nch l=0.15 w=1 nf=1 m=1
M2 Vn_out net0 VDD VDD pch l=0.15 w=1 nf=1 m=1
RD VDD Vn_out 1k
Vn1 net1 VSS DC 1
Vn2 net0 VSS DC 1
.ends dut
