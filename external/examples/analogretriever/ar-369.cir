* official Analog Canvas netlist; PDK X cards rewritten by convert.py
.model qnpn npn

.subckt dut VSS vo
E1 net5 VSS vo VSS 1
Q1 net3 net4 net0 VSS qnpn m=1
Q2 net1 net3 VSS VSS qnpn m=1
Q3 VSS net1 vo VSS qnpn m=1
R1 net2 net4 1k
R2 net0 net5 1k
R3 vo VSS 1k
R4 vo VSS 1k
RL1 net3 VSS 1k
RL2 net1 VSS 1k
Vs net2 VSS DC 1
.ends dut
