* official Analog Canvas netlist; PDK X cards rewritten by convert.py
.model nch nmos

.subckt dut VDD VSS
I1 VDD net1 DC 0.2mA
Is VSS net2 DC 1m
M1 net1 net2 VSS VSS nch l=0.15 w=1 nf=1 m=1
M2 VDD net1 net0 VSS nch l=0.15 w=1 nf=1 m=1
R1 net0 VSS 3.5kΩ
R2 net2 net0 14kΩ
.ends dut
