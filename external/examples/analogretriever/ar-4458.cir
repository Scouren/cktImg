* official Analog Canvas netlist; PDK X cards rewritten by convert.py
.model nch nmos
.model pch pmos

.subckt dut VDD VSS v1 v2 vo
C1 net2 vo 1p
M1 net1 v1 net3 VDD pch l=0.15 w=1 nf=1 m=1
M2 net2 v2 net3 VDD pch l=0.15 w=1 nf=1 m=1
M3 net1 net1 VSS VSS nch l=0.15 w=1 nf=1 m=1
M4 net2 net1 VSS VSS nch l=0.15 w=1 nf=1 m=1
M5 net0 net0 VDD VDD pch l=0.15 w=1 nf=1 m=1
M6 net3 net0 VDD VDD pch l=0.15 w=1 nf=1 m=1
M7 vo net2 VSS VSS nch l=0.15 w=1 nf=1 m=1
M8 vo net0 VDD VDD pch l=0.15 w=1 nf=1 m=1
Rset net0 VSS 1k
.ends dut
