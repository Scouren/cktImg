* official Analog Canvas netlist; PDK X cards rewritten by convert.py
.model qnpn npn

.subckt dut VCC VSS vIN vOUT
C1 vIN net2 1p
CO net1 vOUT 1p
Q VCC net2 net1 VSS qnpn m=1
RB1 VCC net2 1k
RB2 net2 VSS 1k
RE net1 VSS 1k
RL vOUT VSS 1k
RT net0 vIN 1k
vT net0 VSS DC 1
.ends dut
