* official Analog Canvas netlist; PDK X cards rewritten by convert.py
.model qnpn npn

.subckt dut VSS vo
Is VSS net0 DC 1m
Q1 vo net0 VSS VSS qnpn m=1
RL vo VSS 1k
RS net0 VSS 1k
.ends dut
