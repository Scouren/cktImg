* official Analog Canvas netlist; PDK X cards rewritten by convert.py
.model nch nmos
.model pch pmos

.subckt dut VDD VSS vin vO
M1 net0 vin VSS VSS nch l=0.15 w=1 nf=1 m=1
M2 VSS net0 vO VDD pch l=0.15 w=1 nf=1 m=1
R1 VDD net0 1k
R2 VDD vO 1k
.ends dut
