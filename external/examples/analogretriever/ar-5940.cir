* official Analog Canvas netlist; PDK X cards rewritten by convert.py
.model qnpn npn

.subckt dut VCC VSS Iout1 Iout2
Q1 net0 net0 VSS VSS qnpn m=1
Q2 Iout1 net0 VSS VSS qnpn m=1
Q3 net1 net1 VSS VSS qnpn m=1
Q4 Iout2 net1 net2 VSS qnpn m=1
R1 VCC net0 1k
R2 VCC net1 1k
R3 net2 VSS 1k
.ends dut
