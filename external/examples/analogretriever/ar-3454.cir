* official Analog Canvas netlist; PDK X cards rewritten by convert.py

.subckt dut VSS gD vout
G1 vout VSS gD VSS 1m
G2 VSS vout VSS vout 1m
R1 vout VSS 1k
R2 vout VSS 1k
Vin gD VSS DC 1
.ends dut
