* official Analog Canvas netlist; PDK X cards rewritten by convert.py
.model nch nmos
.model pch pmos

.subckt dut VDD VSS Vin Vout
C1 Vout VSS 100fF
I1 net0 VSS DC 1mA
M1 X Vin VSS VSS nch l=0.15 w=1 nf=1 m=1
M2 X net0 VDD VDD pch l=0.15 w=1 nf=1 m=1
M3 Y X VSS VSS nch l=0.15 w=1 nf=1 m=1
M4 Y net0 VDD VDD pch l=0.15 w=1 nf=1 m=1
M5 Vout Y VSS VSS nch l=0.15 w=1 nf=1 m=1
M6 Vout net0 VDD VDD pch l=0.15 w=1 nf=1 m=1
M7 net0 net0 VDD VDD pch l=0.15 w=1 nf=1 m=1
.ends dut
