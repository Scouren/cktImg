* official Analog Canvas netlist; PDK X cards rewritten by convert.py

.subckt dut VCC VEE vI1 vO1 vI2 vO2
.model DIODE D(IS=1e-14 N=1)
D1 __icm_sense_node_8b778658920b5f2f net0 DIODE
V__icm_sense_8b778658920b5f2f vI1 __icm_sense_node_8b778658920b5f2f DC 0
D2 __icm_sense_node_b583126b252f0156 net0 DIODE
V__icm_sense_b583126b252f0156 vI2 __icm_sense_node_b583126b252f0156 DC 0
F1 vO1 vI1 V__icm_sense_8b778658920b5f2f 1
F2 vO2 vI2 V__icm_sense_b583126b252f0156 1
IBIAS net0 VEE DC 1m
RC1 VCC vO1 1k
RC2 VCC vO2 1k
.ends dut
