* official Analog Canvas netlist; PDK X cards rewritten by convert.py
.model nch nmos
.model pch pmos

.subckt dut VDD VSS Vout Vb
I1 VDD Vout DC 1m
I2 net0 VSS DC 1m
Iin VSS net0 DC 1m
M1 Vout net0 VSS VSS nch l=0.15 w=1 nf=1 m=1
M2 net0 Vb Vout VDD pch l=0.15 w=1 nf=1 m=1
.ends dut
