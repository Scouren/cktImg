* official Analog Canvas netlist; PDK X cards rewritten by convert.py
.model qpnp pnp

.subckt dut VCC VEE VSS vo
CC1 Vin net1 1p
CC2 net0 vo 1p
Q1 net0 VSS net1 qpnp m=1
RC net0 VEE 5kΩ
RE VCC net1 10kΩ
Vi Vin VSS DC 1
.ends dut
