* official Analog Canvas netlist; PDK X cards rewritten by convert.py
.model nch nmos

.subckt dut VDD VSS
M1 net1 net0 net2 VSS nch l=0.15 w=1 nf=1 m=1
RD VDD net1 1k
RG net0 net1 1k
RS net2 VSS 1k
.ends dut
