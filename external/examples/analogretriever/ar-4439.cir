* official Analog Canvas netlist; PDK X cards rewritten by convert.py
.model nch nmos
.model pch pmos

.subckt dut VDD VSS VG
.model DIODE D(IS=1e-14 N=1)
D1 net2 net0 DIODE
Ii VSS net1 DC 1m
IQ net0 VSS DC 16mA
M1 net3 VG net1 VSS nch l=0.15 w=1 nf=1 m=1
M2 net2 net3 VDD VDD pch l=0.15 w=1 nf=1 m=1
RD net3 VDD 525Ω
RF net1 net0 500Ω
.ends dut
