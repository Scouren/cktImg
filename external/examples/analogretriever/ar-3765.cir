* official Analog Canvas netlist; PDK X cards rewritten by convert.py
.model pch pmos

.subckt dut VDD VSS GND vo
CC1 net1 net2 1p
CC2 net0 vo 1p
CG net3 GND 1p
M1 net0 net3 net2 VDD pch l=0.15 w=1 nf=1 m=1
RD net0 VSS 1k
RG net3 GND 1k
RL vo GND 1k
RS net2 VDD 1k
Vi net1 GND DC 1
.ends dut
