* official Analog Canvas netlist; PDK X cards rewritten by convert.py
.model qnpn npn

.subckt dut VCC VSS vout VX
Q1 VCC net0 net1 VSS qnpn m=1
Q2 vout net1 VX VSS qnpn m=1
RB VSS net0 1k
RC VCC vout 1k
.ends dut
