* official Analog Canvas netlist; PDK X cards rewritten by convert.py
.model qnpn npn

.subckt dut VSS vout
C1 vout VSS 1p
C2 VSS vf 1p
L vout vf 1n
Q1 vout vf VSS VSS qnpn m=1
.ends dut
