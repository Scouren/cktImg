* official Analog Canvas netlist; PDK X cards rewritten by convert.py

.subckt dut A B
R1 A net0 1k
R2 A net0 1k
R3 net0 B 1k
R4 net0 B 1k
.ends dut
