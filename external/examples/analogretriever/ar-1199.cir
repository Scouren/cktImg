* official Analog Canvas netlist; PDK X cards rewritten by convert.py
.model nch nmos

.subckt dut VDD VSS Vin Vout Vb
C1 Vin net0 1p
C2 net1 Vout 1p
M1 VDD net0 net1 VSS nch l=0.15 w=1 nf=1 m=1
M2 net1 Vb VSS VSS nch l=0.15 w=1 nf=1 m=1
RG VDD net0 1k
.ends dut
