* official Analog Canvas netlist; PDK X cards rewritten by convert.py
.model nch nmos
.model pch pmos

.subckt dut VDD VSS VIN+ VIN- VBIAS4 VBIAS3 VBIAS2 VBIAS1 VBIAS0 VOUT- VOUT+ VCMFB
M1 net4 VIN+ net2 net2 pch l=0.15 w=1 nf=1 m=1
M10 net3 VBIAS3 VDD VDD pch l=0.15 w=1 nf=1 m=1
M2 net0 VIN- net2 net2 pch l=0.15 w=1 nf=1 m=1
M3P net4 VBIAS0 VSS VSS nch l=0.15 w=1 nf=1 m=1
M3PP net4 VCMFB VSS VSS nch l=0.15 w=1 nf=1 m=1
M4P net0 VBIAS0 VSS VSS nch l=0.15 w=1 nf=1 m=1
M4PP net0 VCMFB VSS VSS nch l=0.15 w=1 nf=1 m=1
M5 VOUT- VBIAS1 net4 VSS nch l=0.15 w=1 nf=1 m=1
M6 VOUT+ VBIAS1 net0 VSS nch l=0.15 w=1 nf=1 m=1
M7 VOUT- VBIAS2 net1 VDD pch l=0.15 w=1 nf=1 m=1
M8 VOUT+ VBIAS2 net3 VDD pch l=0.15 w=1 nf=1 m=1
M9 net1 VBIAS3 VDD VDD pch l=0.15 w=1 nf=1 m=1
MB1 net2 VBIAS4 VDD VDD pch l=0.15 w=1 nf=1 m=1
.ends dut
