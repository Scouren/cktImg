* official Analog Canvas netlist; PDK X cards rewritten by convert.py
.model nch nmos

.subckt dut VSS Vi Vo
M1 Vd1 Vi net1 VSS nch l=0.15 w=1 nf=1 m=1
M2 Vo Vd1 VSS VSS nch l=0.15 w=1 nf=1 m=1
R1 net1 VSS 1k
R2 net1 VSS 1k
R3 Vo net0 1k
R4 net0 VSS 1k
RD1 VSS Vd1 1k
RD2 VSS Vo 1k
.ends dut
