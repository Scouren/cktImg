* official Analog Canvas netlist; PDK X cards rewritten by convert.py
.model qnpn npn

.subckt dut VCC VSS Vin
C1 Vin net1 1p
Q1 net0 Vb net1 VSS qnpn m=1
R1 VCC Vb 1k
R2 Vb VSS 1k
RC VCC net0 1k
RE net1 VSS 1k
.ends dut
