* official Analog Canvas netlist; PDK X cards rewritten by convert.py
.model nch nmos
.model pch pmos
.model qnpn npn

.subckt dut VDD VSS GND vo VB2
IREF net2 net5 DC 1m
M1 net6 v1 net0 VDD pch l=0.15 w=1 nf=1 m=1
M10 net3 net3 VDD VDD pch l=0.15 w=1 nf=1 m=1
M11 net0 net2 VDD VDD pch l=0.15 w=1 nf=1 m=1
M12 net2 net2 VDD VDD pch l=0.15 w=1 nf=1 m=1
M13 net5 net5 VSS VSS nch l=0.15 w=1 nf=1 m=1
M2 net1 v2 net0 VDD pch l=0.15 w=1 nf=1 m=1
M3 net1 net5 VSS VSS nch l=0.15 w=1 nf=1 m=1
M4 net6 net5 VSS VSS nch l=0.15 w=1 nf=1 m=1
M7 net4 net4 net7 VDD pch l=0.15 w=1 nf=1 m=1
M8 vo net4 net3 VDD pch l=0.15 w=1 nf=1 m=1
M9 net7 net3 VDD VDD pch l=0.15 w=1 nf=1 m=1
Q5 net4 VB2 net1 VSS qnpn m=1
Q6 vo VB2 net6 VSS qnpn m=1
V1 GND v1 DC 1
V2 v2 GND DC 1
.ends dut
