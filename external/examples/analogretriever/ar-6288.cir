* official Analog Canvas netlist; PDK X cards rewritten by convert.py
.model nch nmos
.model pch pmos

.subckt dut VDD VSS Y A B C D
M1 net1 A VDD VDD pch l=0.15 w=1 nf=1 m=1
M2 net0 B net1 VDD pch l=0.15 w=1 nf=1 m=1
M3 net2 C net0 VDD pch l=0.15 w=1 nf=1 m=1
M4 Y D net2 VDD pch l=0.15 w=1 nf=1 m=1
M5 Y A VSS VSS nch l=0.15 w=1 nf=1 m=1
M6 Y B VSS VSS nch l=0.15 w=1 nf=1 m=1
M7 Y C VSS VSS nch l=0.15 w=1 nf=1 m=1
M8 Y D VSS VSS nch l=0.15 w=1 nf=1 m=1
.ends dut
