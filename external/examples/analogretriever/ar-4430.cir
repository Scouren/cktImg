* official Analog Canvas netlist; PDK X cards rewritten by convert.py
.model qnpn npn

.subckt dut VCC VEE VSS vo
I1 net2 VEE DC 1mA
I2 vo VEE DC 2mA
Q1 VCC net4 net2 VSS qnpn m=1
Q2 net0 net1 net2 VSS qnpn m=1
Q3 VCC net0 vo VSS qnpn m=1
R1 net1 VSS 10kΩ
R2 net1 vo 50kΩ
RC VCC net0 22.6kΩ
RL vo VSS 4kΩ
RS net3 net4 1kΩ
vi net3 VSS DC 1
.ends dut
