* official Analog Canvas netlist; PDK X cards rewritten by convert.py
.model nch nmos
.model qnpn npn
.model qpnp pnp

.subckt dut VCC VEE VSS vIN1 vIN2 vOUT
.model DIODE D(IS=1e-14 N=1)
D1 net4 net5 DIODE
D2 net5 net3 DIODE
IBIAS1 net6 VEE DC 1m
IBIAS2 net2 VEE DC 1m
ILS net3 VEE DC 1m
M1A net1 vIN1 net6 net6 nch l=0.15 w=1 nf=1 m=1
M1B net0 vIN2 net6 net6 nch l=0.15 w=1 nf=1 m=1
Q2 net2 net0 VCC qpnp m=1
Q3 VCC net2 net4 VEE qnpn m=1
Q4 VCC net4 vOUT VEE qnpn m=1
Q5 VEE net3 vOUT qpnp m=1
Q6A net1 net1 VCC qpnp m=1
Q6B net0 net1 VCC qpnp m=1
RL vOUT VSS 1k
.ends dut
