* official Analog Canvas netlist; PDK X cards rewritten by convert.py
.model nch nmos
.model pch pmos

.subckt dut VDD VSS VBias vI vO
IREF net3 VSS DC 1m
M1 net0 vI VSS VSS nch l=0.15 w=1 nf=1 m=1
M2 vO VBias net0 VSS nch l=0.15 w=1 nf=1 m=1
M3 vO net3 net1 VDD pch l=0.15 w=1 nf=1 m=1
M4 net1 net2 VDD VDD pch l=0.15 w=1 nf=1 m=1
M5 net3 net3 net2 VDD pch l=0.15 w=1 nf=1 m=1
M6 net2 net2 VDD VDD pch l=0.15 w=1 nf=1 m=1
.ends dut
