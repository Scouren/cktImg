* official Analog Canvas netlist; PDK X cards rewritten by convert.py

.subckt dut A B
.model DIODE D(IS=1e-14 N=1)
D1 A net0 DIODE
D2 A net0 DIODE
D3 net0 net1 DIODE
RS net1 B 1k
.ends dut
