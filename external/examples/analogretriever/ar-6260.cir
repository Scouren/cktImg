* official Analog Canvas netlist; PDK X cards rewritten by convert.py
.model qnpn npn
.model qpnp pnp

.subckt dut VCC VSS VBIAS3 VB vO1 vO2 VBIAS2 VBIAS1 Vinn Vinp
Q1 VY1 Vinp net1 qpnp m=1
Q10 vO2 VBIAS3 VX2 qpnp m=1
Q2 VY2 Vinn net1 qpnp m=1
Q3 VX1 Vinn net0 VSS qnpn m=1
Q4 VX2 Vinp net0 VSS qnpn m=1
Q5 net1 VBIAS1 VCC qpnp m=1
Q6 net0 VBIAS2 VSS VSS qnpn m=1
Q7 vO1 VB VY1 VSS qnpn m=1
Q8 vO2 VB VY2 VSS qnpn m=1
Q9 vO1 VBIAS3 VX1 qpnp m=1
R10 VCC VX2 1k
R7 VY1 VSS 1k
R8 VY2 VSS 1k
R9 VCC VX1 1k
.ends dut
