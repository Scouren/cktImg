* official Analog Canvas netlist; PDK X cards rewritten by convert.py
.model nch nmos

.subckt dut VDD VSS Vout Vb
M1 Vout Vb X VSS nch l=0.15 w=1 nf=1 m=1
M2 X X VSS VSS nch l=0.15 w=1 nf=1 m=1
RD VDD Vout 1k
RS net0 X 1k
Vin net0 VSS DC 1
.ends dut
