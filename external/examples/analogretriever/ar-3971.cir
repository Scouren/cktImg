* official Analog Canvas netlist; PDK X cards rewritten by convert.py
.model qnpn npn

.subckt dut VCC VEE VSS vo
C net3 VSS 1p
CC1 net2 net0 1p
CC2 net4 vo 1p
Q1 net3 net0 net4 VEE qnpn m=1
RB net0 VSS 100kΩ
RC VCC net3 10kΩ
RE net4 VEE 10kΩ
RL vo VSS 1k
RS net1 net2 1k
vs net1 VSS DC 1
.ends dut
