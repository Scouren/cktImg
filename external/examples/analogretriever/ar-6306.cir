* official Analog Canvas netlist; PDK X cards rewritten by convert.py
.model nch nmos
.model pch pmos

.subckt dut VDD VSS vI C C_bar vO Vout
MN1 net0 vI VSS VSS nch l=0.15 w=1 nf=1 m=1
MN2 vO C net0 VSS nch l=0.15 w=1 nf=1 m=1
MN3 Vout vO VSS VSS nch l=0.15 w=1 nf=1 m=1
MP1 net0 vI VDD VDD pch l=0.15 w=1 nf=1 m=1
MP2 vO C_bar net0 VDD pch l=0.15 w=1 nf=1 m=1
MP3 Vout vO VDD VDD pch l=0.15 w=1 nf=1 m=1
.ends dut
