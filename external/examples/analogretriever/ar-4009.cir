* official Analog Canvas netlist; PDK X cards rewritten by convert.py
.model qpnp pnp

.subckt dut VCC VEE VSS vo
CC1 net0 net2 1p
CC2 net1 vo 1p
IEo VCC net1 DC 0.5mA
Q1 VEE net2 net1 qpnp m=1
RB net2 VSS 10kΩ
RL vo VSS 0.5kΩ
vs net0 VSS DC 1
.ends dut
