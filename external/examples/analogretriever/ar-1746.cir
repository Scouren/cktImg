* official Analog Canvas netlist; PDK X cards rewritten by convert.py
.model nch nmos

.subckt dut VDD VSS Vin Vout Vb
I1 VDD Vout DC 1m
M1 Vout Vb net0 VSS nch l=0.15 w=1 nf=1 m=1
M2 Vout Vout VSS VSS nch l=0.15 w=1 nf=1 m=1
RS Vin net0 1k
.ends dut
