* official Analog Canvas netlist; PDK X cards rewritten by convert.py
.model qnpn npn

.subckt dut VCC VSS vo
CC1 net0 net1 1p
CC2 net2 vo 1p
Q1 VCC net1 net2 VSS qnpn m=1
R1 VCC net1 1k
R2 net1 VSS 1k
RE net2 VSS 1k
RL vo VSS 1k
vs net0 VSS DC 1
.ends dut
