* official Analog Canvas netlist; PDK X cards rewritten by convert.py
.model nch nmos

.subckt dut VSS vo
M1 net2 net1 VSS VSS nch l=0.15 w=1 nf=1 m=1
M2 vo net2 VSS VSS nch l=0.15 w=1 nf=1 m=1
RL1 net2 VSS 1k
RL2 vo VSS 1k
RS net0 net1 1k
Vs net0 VSS DC 1
.ends dut
