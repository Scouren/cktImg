* official Analog Canvas netlist; PDK X cards rewritten by convert.py
.model nch nmos
.model pch pmos

.subckt dut VDD VSS Vin Vout
M1 X Vin VSS VSS nch l=0.15 w=1 nf=1 m=1
M2 X Vin VDD VDD pch l=0.15 w=1 nf=1 m=1
M3 Vout X VSS VSS nch l=0.15 w=1 nf=1 m=1
M4 Vout X VDD VDD pch l=0.15 w=1 nf=1 m=1
.ends dut
