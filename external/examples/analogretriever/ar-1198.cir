* official Analog Canvas netlist; PDK X cards rewritten by convert.py
.model nch nmos

.subckt dut VDD VSS Vin Vout
C1 Vin net1 1p
C2 net0 Vout 1p
I1 net0 VSS DC 1m
M1 VDD net1 net0 VSS nch l=0.15 w=1 nf=1 m=1
RG VDD net1 1k
.ends dut
