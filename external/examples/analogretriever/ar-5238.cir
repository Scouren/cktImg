* official Analog Canvas netlist; PDK X cards rewritten by convert.py
.model qnpn npn

.subckt opamp VDD VSS VIP VIN VOUT params: gain=1e6 vhigh=5 vlow=-5
Blin nlin 0 V={gain*(V(VIP)-V(VIN))}
Bcore VOUT 0 V={0.5*(vhigh+(0.5*(vlow+V(nlin)+sqrt((V(nlin)-vlow)*(V(nlin)-vlow)+(1e-4*(vhigh-vlow))*(1e-4*(vhigh-vlow))+1e-12)))-sqrt((vhigh-(0.5*(vlow+V(nlin)+sqrt((V(nlin)-vlow)*(V(nlin)-vlow)+(1e-4*(vhigh-vlow))*(1e-4*(vhigh-vlow))+1e-12))))*(vhigh-(0.5*(vlow+V(nlin)+sqrt((V(nlin)-vlow)*(V(nlin)-vlow)+(1e-4*(vhigh-vlow))*(1e-4*(vhigh-vlow))+1e-12))))+(1e-4*(vhigh-vlow))*(1e-4*(vhigh-vlow))+1e-12))}
.ends opamp

.subckt dut VSS Vin Vout
.model icm_zener_DZ D(BV=5.1)
DZ VSS net2 icm_zener_DZ
Q1 Vout net0 VSS VSS qnpn m=1
R1 net1 VSS 1k
R2 Vout net1 1k
R3 Vin net2 1k
RL Vout VSS 1k
RS Vin Vout 1k
X1 0 VSS net1 net2 net0 opamp gain=1e6
.ends dut
