* official Analog Canvas netlist; PDK X cards rewritten by convert.py
.model nch nmos
.model pch pmos

.subckt dut VDD VBIAS VBB1 VBB2 VSS Vi1 Vi2 Vcmc Vo1 Vo2
M1 net4 Vi1 net0 VSS nch l=0.15 w=1 nf=1 m=1
M1A Vo1 VBB2 net4 VSS nch l=0.15 w=1 nf=1 m=1
M2 net1 Vi2 net0 VSS nch l=0.15 w=1 nf=1 m=1
M2A Vo2 VBB2 net1 VSS nch l=0.15 w=1 nf=1 m=1
M3 net3 VBIAS VDD VDD pch l=0.15 w=1 nf=1 m=1
M3A Vo1 VBB1 net3 VDD pch l=0.15 w=1 nf=1 m=1
M4 net2 VBIAS VDD VDD pch l=0.15 w=1 nf=1 m=1
M4A Vo2 VBB1 net2 VDD pch l=0.15 w=1 nf=1 m=1
M5 net0 Vcmc VSS VSS nch l=0.15 w=1 nf=1 m=1
.ends dut
