* official Analog Canvas netlist; PDK X cards rewritten by convert.py
.model nch nmos

.subckt dut VDD VSS Vo
CL Vo VSS 100fF
M1 Vo net0 VSS VSS nch l=1 w=100 nf=1 m=1
M2 VDD VDD Vo VSS nch l=1 w=4 nf=1 m=1
RS net1 net0 1kΩ
Vi net1 VSS DC 1
.ends dut
