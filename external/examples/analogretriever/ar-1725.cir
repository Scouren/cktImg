* official Analog Canvas netlist; PDK X cards rewritten by convert.py
.model nch nmos

.subckt dut VDD VSS Vin Vout
Cin net1 VSS 1p
CL Vout VSS 1p
M1 Vout net1 net0 VSS nch l=0.15 w=1 nf=1 m=1
RD VDD Vout 1k
RP net0 VSS 1k
RS Vin net1 1k
.ends dut
