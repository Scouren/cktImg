* official Analog Canvas netlist; PDK X cards rewritten by convert.py
.model nch nmos

.subckt dut VDD VSS Vo- Vo+
C1 VDD Vo- 1p
C2 VDD Vo+ 1p
I net0 VSS DC 1m
L1 VDD Vo- 1n
L2 VDD Vo+ 1n
M1 Vo- Vo+ net0 VSS nch l=0.15 w=1 nf=1 m=1
M2 Vo+ Vo- net0 VSS nch l=0.15 w=1 nf=1 m=1
RP1 VDD Vo- 1k
RP2 VDD Vo+ 1k
.ends dut
