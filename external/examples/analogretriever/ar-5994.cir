* official Analog Canvas netlist; PDK X cards rewritten by convert.py
.model qnpn npn

.subckt dut VCC VEE VSS vo
C1 net1 VSS 1p
I1 net1 VEE DC 0.5mA
Q1 vo net0 net1 VEE qnpn m=1
R1 net2 net0 10kΩ
R2 VCC vo 10kΩ
vsig net2 VSS DC 1
.ends dut
