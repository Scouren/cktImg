* official Analog Canvas netlist; PDK X cards rewritten by convert.py

.subckt dut VSS Vo
CM net1 VSS 1p
Cpi net1 VSS 1p
G1 Vo VSS net1 VSS 1m
RB net1 VSS 1k
RL Vo VSS 1k
RS net0 net1 1k
rpi net1 VSS 1k
Vi net0 VSS DC 1
.ends dut
