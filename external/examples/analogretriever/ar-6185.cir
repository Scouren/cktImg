* official Analog Canvas netlist; PDK X cards rewritten by convert.py
.model qnpn npn

.subckt dut VCC VEE VSS Vin Vo
C1 net1 Vo 1p
I1 VCC net3 DC 0.1mA
I2 net1 VEE DC 1mA
Q1 net3 net2 Vin VEE qnpn m=1
Q2 VCC net3 net1 VEE qnpn m=1
R1 net2 VSS 1k
R2 net2 net1 1k
RL Vo VSS 1k
Rs net0 Vin 1k
Vs net0 VSS DC 1
.ends dut
