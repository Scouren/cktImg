* official Analog Canvas netlist; PDK X cards rewritten by convert.py
.model qpnp pnp

.subckt dut VCC VEE VSS
Q1 net2 net1 net0 qpnp m=1
RB net1 VSS 10kΩ
RC net2 VEE 1k
RE net0 VCC 1k
.ends dut
