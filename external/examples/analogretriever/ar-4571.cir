* official Analog Canvas netlist; PDK X cards rewritten by convert.py
.model nch nmos

.subckt dut VDD VSS vX vY vO1 vO2 vO3
.model NMOS nmos level=54
MD1 vO1 vX VSS VSS nch l=0.15 w=1 nf=1 m=1
MD2 vO2 vO1 VSS VSS nch l=0.15 w=1 nf=1 m=1
MD3 vO2 vO3 VSS VSS nch l=0.15 w=1 nf=1 m=1
MD4 vO3 vY VSS VSS nch l=0.15 w=1 nf=1 m=1
ML1 VDD vO1 vO1 VSS NMOS l=150n m=1 nf=1 w=1u
ML2 VDD vO2 vO2 VSS NMOS l=150n m=1 nf=1 w=1u
ML3 VDD VDD vO3 VSS nch l=0.15 w=1 nf=1 m=1
.ends dut
