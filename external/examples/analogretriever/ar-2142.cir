* official Analog Canvas netlist; PDK X cards rewritten by convert.py
.model nch nmos

.subckt dut VDD VSS
C1 net0 X 1p
C2 net2 net1 1p
M1 net2 X VSS VSS nch l=0.15 w=1 nf=1 m=1
R1 VDD X 1k
R2 X VSS 1k
R3 net1 VSS 8
RD VDD net2 1kΩ
V1 net0 VSS DC 1
.ends dut
