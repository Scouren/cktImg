* official Analog Canvas netlist; PDK X cards rewritten by convert.py
.model nch nmos
.model pch pmos
.model qnpn npn
.model qpnp pnp

.subckt dut VCC VEE VSS vI vO
.model DIODE D(IS=1e-14 N=1)
D1 net3 net1 DIODE
D2 net4 net6 DIODE
IBias VCC net3 DC 1m
MN VCC net5 vO VEE nch l=0.15 w=1 nf=1 m=1
MP VEE net0 vO VCC pch l=0.15 w=1 nf=1 m=1
Q1 VCC net3 net5 VEE qnpn m=1
Q2 VEE net6 net0 qpnp m=1
Q3 net1 net2 net4 VEE qnpn m=1
Q4 VEE vI net6 qpnp m=1
R2 net5 net0 1k
RA net1 net2 1k
RB net2 net4 1k
RL vO VSS 1k
.ends dut
