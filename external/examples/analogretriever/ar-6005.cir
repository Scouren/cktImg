* official Analog Canvas netlist; PDK X cards rewritten by convert.py
.model nch nmos

.subckt dut VSS Vin Vout
M1 Vout Vin net0 VSS nch l=0.15 w=1 nf=1 m=1
RD VSS Vout 1k
RL Vout VSS 1k
RS net0 VSS 1k
.ends dut
