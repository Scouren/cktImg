* official Analog Canvas netlist; PDK X cards rewritten by convert.py
.model nch nmos
.model pch pmos

.subckt dut VSS Vin1 Vin2
M1 net1 Vin1 net0 VSS nch l=0.15 w=1 nf=1 m=1
M2 VSS Vin2 net0 VSS nch l=0.15 w=1 nf=1 m=1
M3 net1 net1 VSS VSS pch l=0.15 w=1 nf=1 m=1
M4 VSS net1 VSS VSS pch l=0.15 w=1 nf=1 m=1
.ends dut
