* official Analog Canvas netlist; PDK X cards rewritten by convert.py
.model qnpn npn

.subckt dut VSS Vs
Q1 net1 Vs net0 VSS qnpn m=1
Q2 net2 net1 VSS VSS qnpn m=1
Q3 net3 net2 net4 VSS qnpn m=1
RC1 VSS net1 5kΩ
RC2 VSS net2 2kΩ
RC3 VSS net3 1kΩ
RE1 net0 VSS 0.1kΩ
RE2 net4 VSS 0.1kΩ
RF net0 net4 0.8kΩ
.ends dut
