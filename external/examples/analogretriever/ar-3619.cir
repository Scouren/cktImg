* official Analog Canvas netlist; PDK X cards rewritten by convert.py

.subckt dut VSS vO
.model DIODE D(IS=1e-14 N=1)
VB1 net1 VSS DC 2V
VB2 VSS net0 DC 4V
D1 net2 net1 DIODE
D2 net0 vO DIODE
R1 net3 vO 10kΩ
R2 vO net2 10kΩ
VI net3 VSS DC 1 SIN(0 1 1k 0 0 0)
.ends dut
