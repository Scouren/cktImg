* official Analog Canvas netlist; PDK X cards rewritten by convert.py
.model qnpn npn
.model qpnp pnp

.subckt dut VCC VSS Vin Vb Vout
Q1 Vout Vb Vin VSS qnpn m=1
Q3 net0 net0 VCC qpnp m=1
RC net0 Vout 1k
RE Vin VSS 1k
.ends dut
