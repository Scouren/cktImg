* official Analog Canvas netlist; PDK X cards rewritten by convert.py
.model nch nmos

.subckt dut VSS Iin Iout VBIAS
M1 net0 Iin VSS VSS nch l=0.15 w=1 nf=1 m=1
M2 net1 Iin VSS VSS nch l=0.15 w=1 nf=1 m=1
M3 Iin VBIAS net0 VSS nch l=0.15 w=1 nf=1 m=1
M4 Iout VBIAS net1 VSS nch l=0.15 w=1 nf=1 m=1
.ends dut
