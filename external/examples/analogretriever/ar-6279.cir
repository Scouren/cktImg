* official Analog Canvas netlist; PDK X cards rewritten by convert.py
.model nch nmos
.model pch pmos

.subckt dut VDD VSS A B C D Y
MNA Y A net1 VSS nch l=0.15 w=1 nf=1 m=1
MNB net1 B VSS VSS nch l=0.15 w=1 nf=1 m=1
MNC net1 C net2 VSS nch l=0.15 w=1 nf=1 m=1
MND net2 D VSS VSS nch l=0.15 w=1 nf=1 m=1
MPA Y A VDD VDD pch l=0.15 w=1 nf=1 m=1
MPB net0 B VDD VDD pch l=0.15 w=1 nf=1 m=1
MPC Y C net0 VDD pch l=0.15 w=1 nf=1 m=1
MPD Y D net0 VDD pch l=0.15 w=1 nf=1 m=1
.ends dut
