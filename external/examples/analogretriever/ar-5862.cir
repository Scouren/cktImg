* official Analog Canvas netlist; PDK X cards rewritten by convert.py
.model nch nmos

.subckt dut VDD VSS vi vo
C1 vi net0 1p
C2 net1 vo 1p
I VDD net1 DC 500uA
M1 net1 net0 VSS VSS nch l=0.15 w=1 nf=1 m=1
RG net0 net1 10MegΩ
RL vo VSS 10kΩ
.ends dut
