* official Analog Canvas netlist; PDK X cards rewritten by convert.py
.model qnpn npn

.subckt dut VEE VSS vin vR vO2 vO1
Q1 v1 vin net0 VEE qnpn m=1
Q2 v2 vR net0 VEE qnpn m=1
Q3 VSS v2 vO1 VEE qnpn m=1
Q4 VSS v1 vO2 VEE qnpn m=1
R2 vO1 VEE 3kΩ
R3 vO2 VEE 3kΩ
RC1 VSS v1 1k
RC2 VSS v2 1k
RE net0 VEE 2.5kΩ
.ends dut
