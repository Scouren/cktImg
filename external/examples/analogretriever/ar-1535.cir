* official Analog Canvas netlist; PDK X cards rewritten by convert.py
.model nch nmos

.subckt dut VDD VSS Vin1 Vin2 Vout1 Vout2
I1 VDD Vout1 DC 1m
I2 VDD Vout2 DC 1m
I3 net0 VSS DC 1m
I4 net1 VSS DC 1m
M1 Vout1 Vin1 net0 VSS nch l=0.15 w=1 nf=1 m=1
M2 Vout2 Vin2 net1 VSS nch l=0.15 w=1 nf=1 m=1
RDD Vout1 Vout2 1k
RSS net0 net1 1k
.ends dut
