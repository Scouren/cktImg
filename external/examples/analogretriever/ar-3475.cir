* official Analog Canvas netlist; PDK X cards rewritten by convert.py
.model qnpn npn

.subckt dut VCC VEE Iout1 Iout2
Q1 net0 net0 VEE VEE qnpn m=1
Q2 Iout1 net0 VEE VEE qnpn m=1
Q3 Iout2 net0 VEE VEE qnpn m=1
R1 VCC net0 1k
.ends dut
