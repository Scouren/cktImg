* official Analog Canvas netlist; PDK X cards rewritten by convert.py
.model qpnp pnp

.subckt dut VCC VSS vO
CC1 net0 net2 1p
CC2 net1 vO 1p
Q1 net1 net2 net3 qpnp m=1
R1 VCC net2 1k
R2 net2 VSS 1k
RC net1 VSS 1k
RE VCC net3 1k
RL vO VSS 1k
Vs net0 VSS DC 1
.ends dut
