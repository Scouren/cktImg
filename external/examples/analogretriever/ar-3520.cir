* official Analog Canvas netlist; PDK X cards rewritten by convert.py
.model qnpn npn
.model qpnp pnp

.subckt dut VCC VEE VSS Vin Vout
.model DIODE D(IS=1e-14 N=1)
D1 net3 net1 DIODE
D2 net1 net0 DIODE
ILS net0 VEE DC 1m
Q3 VCC Vin net2 VEE qnpn m=1
Q4 VCC net3 Vout VEE qnpn m=1
Q5 VEE net0 Vout qpnp m=1
RE3 net2 net3 1k
RL Vout VSS 1k
.ends dut
