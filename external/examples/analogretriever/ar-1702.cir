* official Analog Canvas netlist; PDK X cards rewritten by convert.py
.model nch nmos

.subckt dut VDD VSS Vin1
CDB1 net1 VSS 1p
CGD1 net0 net1 1p
CGS1 net0 VSS 1p
CSB1 VSS VSS 1p
M1 net1 net0 VSS VSS nch l=0.15 w=1 nf=1 m=1
RD VDD net1 1k
RS Vin1 net0 1k
.ends dut
