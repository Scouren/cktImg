* official Analog Canvas netlist; PDK X cards rewritten by convert.py

.subckt dut G D S B
Cdb D B 1p
Cgd G D 1p
Cgs G S 1p
Csb S B 1p
Gm D S G S 1m
Gmb D S B S 1m
ro D S 1k
.ends dut
