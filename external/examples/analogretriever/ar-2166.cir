* official Analog Canvas netlist; PDK X cards rewritten by convert.py
.model nch nmos

.subckt dut VDD VSS vout
VB1 net2 VSS DC 1
C1 net1 net0 1p
M1 vout net2 net0 VSS nch l=0.15 w=1 nf=1 m=1
R1 net0 VSS 1k
RD VDD vout 1k
vin net1 VSS DC 1
.ends dut
