* official Analog Canvas netlist; PDK X cards rewritten by convert.py

.subckt dut VDD VSS vo
CC1 net3 net1 1p
CC2 net0 vo 1p
M1 net0 net1 net2 VSS nmos_depletion l=150n m=1 nf=1 w=1u
RD VDD net0 1k
RG net1 VSS 1MegΩ
RL vo VSS 1k
RS net2 VSS 1k
Vi net3 VSS DC 1
.ends dut
