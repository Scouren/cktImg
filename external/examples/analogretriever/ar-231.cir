* official Analog Canvas netlist; PDK X cards rewritten by convert.py
.model nch nmos
.model pch pmos

.subckt dut VDD VSS GND BIAS vo1 vi2 vo
M1 net0 GND net1 VDD pch l=0.15 w=1 nf=1 m=1
M2 vo1 GND net1 VDD pch l=0.15 w=1 nf=1 m=1
M3 net0 net0 VSS VSS nch l=0.15 w=1 nf=1 m=1
M4 vo1 net0 VSS VSS nch l=0.15 w=1 nf=1 m=1
M5 net1 BIAS VDD VDD pch l=0.15 w=1 nf=1 m=1
M6 vo vi2 VSS VSS nch l=0.15 w=1 nf=1 m=1
M7 vo BIAS VDD VDD pch l=0.15 w=1 nf=1 m=1
.ends dut
