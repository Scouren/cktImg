* official Analog Canvas netlist; PDK X cards rewritten by convert.py
.model qnpn npn
.model qpnp pnp

.subckt dut VCC VSS Vb2 Vb1 vin vout
Q1 net0 vin VSS VSS qnpn m=1
Q2 vout Vb1 net0 VSS qnpn m=1
Q3 vout Vb2 net1 qpnp m=1
Q4 net1 net1 VCC qpnp m=1
.ends dut
