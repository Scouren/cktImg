* official Analog Canvas netlist; PDK X cards rewritten by convert.py
.model nch nmos
.model pch pmos

.subckt dut VDD VSS Vo1 Vi1 Vo2 Vi2 VBIAS
M1 Vo1 Vi1 VSS VSS nch l=0.15 w=1 nf=1 m=1
M2 Vo2 Vi2 VSS VSS nch l=0.15 w=1 nf=1 m=1
M3 Vo1 VBIAS VDD VDD pch l=0.15 w=1 nf=1 m=1
M4 Vo2 VBIAS VDD VDD pch l=0.15 w=1 nf=1 m=1
.ends dut
