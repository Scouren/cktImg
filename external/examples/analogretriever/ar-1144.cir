* official Analog Canvas netlist; PDK X cards rewritten by convert.py
.model nch nmos
.model pch pmos

.subckt dut VDD VSS Vin Vb Vout
M1 Vout Vb Vin VDD pch l=0.15 w=1 nf=1 m=1
M2 net0 Vout VSS VSS nch l=0.15 w=1 nf=1 m=1
R1 Vout net0 1k
RD Vout VSS 1k
.ends dut
