* official Analog Canvas netlist; PDK X cards rewritten by convert.py

.subckt dut VSS
Gm VSS vo v1 VSS 1m
R vo VSS 1k
Ri v1 VSS 1k
ro v1 vo 1k
RS VSS v1 1k
vt vo VSS DC 1
.ends dut
