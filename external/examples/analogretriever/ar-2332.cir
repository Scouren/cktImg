* official Analog Canvas netlist; PDK X cards rewritten by convert.py
.model nch nmos
.model pch pmos

.subckt dut VDD VSS VIN VBIAS VOUT
IBIAS1 VDD FP DC 1m
IBIAS2 VOUT VSS DC 1m
M1 FP VIN VSS VSS nch l=0.15 w=1 nf=1 m=1
M2 VOUT VBIAS FP VDD pch l=0.15 w=1 nf=1 m=1
RL1 VDD FP 1k
RL2 VOUT VSS 1k
.ends dut
