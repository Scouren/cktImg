* official Analog Canvas netlist; PDK X cards rewritten by convert.py
.model qnpn npn

.subckt dut VCC VSS Vin1 Vin2 Vout1 Vout2
Q1 Vout1 Vin1 net0 VSS qnpn m=1
Q2 Vout2 Vin2 net1 VSS qnpn m=1
R1 Vout1 net0 1k
R2 Vout2 net1 1k
RC1 VCC Vout1 1k
RC2 VCC Vout2 1k
RE1 net0 P 1k
RE2 net1 P 1k
RSS P VSS 1k
.ends dut
