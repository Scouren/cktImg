* official Analog Canvas netlist; PDK X cards rewritten by convert.py
.model nch nmos

.subckt dut VDD VSS vo Vin1 Vin2
I net0 VSS DC 1m
M1 VDD Vin1 net0 VSS nch l=0.15 w=1 nf=1 m=1
M2 vo Vin2 net0 VSS nch l=0.15 w=1 nf=1 m=1
RD VDD vo 1k
.ends dut
