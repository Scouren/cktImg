* official Analog Canvas netlist; PDK X cards rewritten by convert.py
.model qnpn npn
.model qpnp pnp

.subckt dut VCC VEE v1 v2
Q1 net2 v1 net1 VEE qnpn m=1
Q2 net0 v2 net1 VEE qnpn m=1
Q3 net3 net3 VEE VEE qnpn m=1
Q4 net1 net3 VEE VEE qnpn m=1
Q5 net2 net2 VCC qpnp m=1
Q6 net0 net2 VCC qpnp m=1
R VCC net3 15kΩ
.ends dut
