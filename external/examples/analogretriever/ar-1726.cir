* official Analog Canvas netlist; PDK X cards rewritten by convert.py
.model qnpn npn

.subckt dut VCC VSS Vin Vout
Q1 Vout X VSS VSS qnpn m=1
RB Vin X 1k
RC VCC Vout 1k
RF X Vout 1k
.ends dut
