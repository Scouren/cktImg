* official Analog Canvas netlist; PDK X cards rewritten by convert.py
.model qnpn npn
.model qpnp pnp

.subckt dut VCC VEE VSS Vout
VB1 net0 net1 DC 1
I1 VCC net0 DC 1m
I2 net1 VEE DC 1m
Q1 VCC net0 Vout VSS qnpn m=1
Q2 VEE net1 Vout qpnp m=1
RL Vout VSS 1k
.ends dut
