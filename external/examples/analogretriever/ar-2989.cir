* official Analog Canvas netlist; PDK X cards rewritten by convert.py
.model nch nmos

.subckt dut VDD VSS VF
It net1 VSS DC 1m
M1 VF VSS net0 VSS nch l=0.15 w=1 nf=1 m=1
R1 net0 net1 1k
R2 net0 VSS 1k
RD1 VDD VF 1k
RD2 VDD net1 1k
.ends dut
