* official Analog Canvas netlist; PDK X cards rewritten by convert.py
.model nch nmos
.model pch pmos

.subckt dut VDD VSS P N VBIAS1
M31 net0 P net1 VDD pch l=0.15 w=1 nf=1 m=1
M32 net2 N net1 VDD pch l=0.15 w=1 nf=1 m=1
M33 net0 net0 VSS VSS nch l=0.15 w=1 nf=1 m=1
M34 net2 net0 VSS VSS nch l=0.15 w=1 nf=1 m=1
M35 net1 VBIAS1 VDD VDD pch l=0.15 w=1 nf=1 m=1
.ends dut
