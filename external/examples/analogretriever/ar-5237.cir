* official Analog Canvas netlist; PDK X cards rewritten by convert.py
.model qnpn npn

.subckt dut VSS Vin Vout
.model icm_zener_DZ D(BV=5.1)
DZ VSS net0 icm_zener_DZ
Q1 Vout net1 net0 VSS qnpn m=1
R1 net1 VSS 1k
R2 Vout net1 1k
R3 Vin net0 1k
RL Vout VSS 1k
RS Vin Vout 1k
.ends dut
