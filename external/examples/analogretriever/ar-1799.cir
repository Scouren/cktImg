* official Analog Canvas netlist; PDK X cards rewritten by convert.py
.model nch nmos
.model pch pmos

.subckt dut VDD VSS Vb
.model DIODE D(IS=1e-14 N=1)
D1 net1 P DIODE
Iin VSS net0 DC 1m
M1 X Vb net0 VSS nch l=0.15 w=1 nf=1 m=1
M2 net1 X VDD VDD pch l=0.15 w=1 nf=1 m=1
RD VDD X 1k
RF net0 P 1k
RM P VSS 1k
.ends dut
