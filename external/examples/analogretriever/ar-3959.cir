* official Analog Canvas netlist; PDK X cards rewritten by convert.py

.subckt dut VSS vo B
G1 VSS vo VSS B 1m
RB B VSS 50kΩ
RC vo VSS 5kΩ
RL vo VSS 2kΩ
rpi B VSS 1k
RS net0 B 1kΩ
vs net0 VSS DC 1
.ends dut
