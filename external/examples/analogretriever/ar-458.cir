* official Analog Canvas netlist; PDK X cards rewritten by convert.py
.model qnpn npn

.subckt dut VSS Iout+ Iout- V1+ V1- V2+ V2-
IEE net0 VSS DC 1m
Q1 net1 V2+ net2 VSS qnpn m=1
Q2 net3 V2- net4 VSS qnpn m=1
Q3 Iout+ V1+ net1 VSS qnpn m=1
Q4 Iout- V1- net1 VSS qnpn m=1
Q5 Iout+ V1- net3 VSS qnpn m=1
Q6 Iout- V1+ net3 VSS qnpn m=1
R1 net2 net0 1k
R2 net4 net0 1k
.ends dut
