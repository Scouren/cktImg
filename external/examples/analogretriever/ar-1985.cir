* official Analog Canvas netlist; PDK X cards rewritten by convert.py
.model qnpn npn
.model qpnp pnp

.subckt dut VEE VCC VSS Vin Vout
I1 VCC net1 DC 1m
Q1 VCC net1 Vout VEE qnpn m=1
Q2 VEE Vin Vout qpnp m=1
Q3 net1 net1 net0 VEE qnpn m=1
Q4 Vin Vin net0 qpnp m=1
R1 Vout VSS 8Ω
.ends dut
