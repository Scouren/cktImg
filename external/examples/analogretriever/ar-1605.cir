* official Analog Canvas netlist; PDK X cards rewritten by convert.py
.model qnpn npn

.subckt dut VCC VSS Vb Vin1 Vin2 Vout1 Vout2
I1 VCC Vout1 DC 1m
I2 VCC Vout2 DC 1m
I3 net3 VSS DC 1m
I4 net0 VSS DC 1m
Q1 net2 Vin1 net3 VSS qnpn m=1
Q2 net1 Vin2 net0 VSS qnpn m=1
Q3 Vout1 Vb net2 VSS qnpn m=1
Q4 Vout2 Vb net1 VSS qnpn m=1
RS net3 net0 1k
.ends dut
