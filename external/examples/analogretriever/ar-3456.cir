* official Analog Canvas netlist; PDK X cards rewritten by convert.py
.model nch nmos
.model qpnp pnp

.subckt dut VCC VSS vOUT
VB1 VCC net0 DC 1
CI net1 net2 1p
M1 vOUT net2 VSS VSS nch l=0.15 w=1 nf=1 m=1
Q2 vOUT net0 VCC qpnp m=1
RG net2 vOUT 1k
vT net1 VSS DC 1
.ends dut
