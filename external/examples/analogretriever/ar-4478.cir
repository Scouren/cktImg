* official Analog Canvas netlist; PDK X cards rewritten by convert.py
.model nch nmos
.model qnpn npn
.model qpnp pnp

.subckt dut VCC VEE v1 v2 vo
IQ net0 VEE DC 500uA
M1 VCC vo2 vo VEE nch l=0.15 w=1 nf=1 m=1
Q1 net1 v1 net0 VEE qnpn m=1
Q2 vo1 v2 net0 VEE qnpn m=1
Q3 vo2 vo1 net2 qpnp m=1
RC1A VCC net1 1k
RC1B VCC vo1 1k
RC2 vo2 VEE 1k
RE VCC net2 0.5kΩ
RS vo VEE 1k
.ends dut
