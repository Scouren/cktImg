* official Analog Canvas netlist; PDK X cards rewritten by convert.py
.model nch nmos
.model pch pmos

.subckt dut VDD VSS CLK A vO
MN1 net0 CLK VSS VSS nch l=0.15 w=1 nf=1 m=1
MN2 vO vO1 VSS VSS nch l=0.15 w=1 nf=1 m=1
MNA vO1 A net0 VSS nch l=0.15 w=1 nf=1 m=1
MP1 vO1 CLK VDD VDD pch l=0.15 w=1 nf=1 m=1
MP2 vO vO1 VDD VDD pch l=0.15 w=1 nf=1 m=1
.ends dut
