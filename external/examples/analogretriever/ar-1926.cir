* official Analog Canvas netlist; PDK X cards rewritten by convert.py
.model qnpn npn

* Crystal: Butterworth-Van Dyke model, fs = 1/(2*pi*sqrt(lm*cm))
.subckt crystal n1 n2 params: rm=25 lm=12.7m cm=20f c0=5p
Rm n1 nr {rm}
Lm nr nl {lm}
Cm nl n2 {cm}
C0 n1 n2 {c0}
.ends crystal

.subckt dut VCC VSS
CA net1 VSS 1p
CB net0 VSS 1p
L1 VCC net0 1n
Q1 net0 net1 VSS VSS qnpn m=1
RF net1 net0 1k
X1 net1 net0 crystal c0=5p cm=20f lm=12.7m rm=25
.ends dut
