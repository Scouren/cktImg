* official Analog Canvas netlist; PDK X cards rewritten by convert.py
.model nch nmos
.model pch pmos

.subckt dut VSS voc
CLc voc VSS 1p
M1 voc net1 net0 VSS nch l=0.15 w=1 nf=1 m=1
M3 voc VSS VSS VSS pch l=0.15 w=1 nf=1 m=1
M5h net0 net2 VSS VSS nch l=0.15 w=1 nf=1 m=1
Vcmc net2 VSS DC 1
Vic net1 VSS DC 1
.ends dut
