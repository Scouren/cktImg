* official Analog Canvas netlist; PDK X cards rewritten by convert.py
.model qnpn npn

.subckt dut VCC VEE VSS vo
CC net2 vo 1p
IQ net2 VEE DC 2mA
Q1 VCC net1 net2 VEE qnpn m=1
RL vo VSS 1k
RS net0 net1 10kΩ
vs net0 VSS DC 1
.ends dut
