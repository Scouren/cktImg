* official Analog Canvas netlist; PDK X cards rewritten by convert.py

.subckt opamp VDD VSS VIP VIN VOUT params: gain=1e6 vhigh=5 vlow=-5
Blin nlin 0 V={gain*(V(VIP)-V(VIN))}
Bcore VOUT 0 V={0.5*(vhigh+(0.5*(vlow+V(nlin)+sqrt((V(nlin)-vlow)*(V(nlin)-vlow)+(1e-4*(vhigh-vlow))*(1e-4*(vhigh-vlow))+1e-12)))-sqrt((vhigh-(0.5*(vlow+V(nlin)+sqrt((V(nlin)-vlow)*(V(nlin)-vlow)+(1e-4*(vhigh-vlow))*(1e-4*(vhigh-vlow))+1e-12))))*(vhigh-(0.5*(vlow+V(nlin)+sqrt((V(nlin)-vlow)*(V(nlin)-vlow)+(1e-4*(vhigh-vlow))*(1e-4*(vhigh-vlow))+1e-12))))+(1e-4*(vhigh-vlow))*(1e-4*(vhigh-vlow))+1e-12))}
.ends opamp

.subckt dut VSS Vo phi1 phi2
.model ideal_switch SW(RON=1 ROFF=1e12 VT=0.5 VH=0)
C1 net0 net1 1p
C2 net1 net3 1p
S1 net2 net0 phi1 VSS ideal_switch
S2 VSS net0 phi2 VSS ideal_switch
S3 VSS net1 phi1 VSS ideal_switch
S4 VSS net3 phi1 VSS ideal_switch
S5 net3 Vo phi2 VSS ideal_switch
Vs net2 VSS DC 1
X1 0 VSS VSS net1 Vo opamp gain=1e6
.ends dut
