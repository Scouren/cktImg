* official Analog Canvas netlist; PDK X cards rewritten by convert.py
.model nch nmos
.model pch pmos

.subckt dut VDD VSS VB in- in+ Vo
C net2 Vo 1p
I1 VDD net1 DC 1m
I2 VDD net2 DC 1m
I3 VDD Vo DC 1m
I4 V1 VSS DC 1m
M1 net0 in- net1 VDD pch l=0.15 w=1 nf=1 m=1
M11 V1 VB net2 VDD pch l=0.15 w=1 nf=1 m=1
M2 V1 in+ net1 VDD pch l=0.15 w=1 nf=1 m=1
M3 net0 net0 VSS VSS nch l=0.15 w=1 nf=1 m=1
M4 V1 net0 VSS VSS nch l=0.15 w=1 nf=1 m=1
M6 Vo V1 VSS VSS nch l=0.15 w=1 nf=1 m=1
.ends dut
