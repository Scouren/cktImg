* official Analog Canvas netlist; PDK X cards rewritten by convert.py
.model nch nmos

.subckt dut VDD VSS Vo
I1 VDD net1 DC 1m
I2 Vo VSS DC 1m
Is VSS net0 DC 1m
M1 net1 net0 VSS VSS nch l=0.15 w=1 nf=1 m=1
M2 VDD net1 Vo VSS nch l=0.15 w=1 nf=1 m=1
RF net0 Vo 1k
.ends dut
