* official Analog Canvas netlist; PDK X cards rewritten by convert.py
.model qnpn npn

.subckt dut VCC VSS Vr Vo
CC1 net3 Vr 1p
CC2 Vr net1 1p
CC3 net4 net5 1p
CC4 net2 Vo 1p
CE net0 VSS 1p
L Vr net4 1n
Q1 Vo net4 net0 VSS qnpn m=1
R1 VCC Vr 51kΩ
R2 Vr VSS 5.5kΩ
RC VCC Vo 10kΩ
RE net0 VSS 0.5kΩ
RF Vr net2 82kΩ
Rp net1 VSS 1k
RS net3 VSS 10kΩ
Vt net5 VSS DC 1
.ends dut
