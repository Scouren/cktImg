* official Analog Canvas netlist; PDK X cards rewritten by convert.py
.model qnpn npn

.subckt dut VCC VSS
C1 net0 net3 1p
C2 net3 VSS 1p
C3 net1 VSS 1p
C4 net2 net0 1p
L net0 VSS 1n
LRFC VCC net2 1n
Q1 net2 net1 net3 VSS qnpn m=1
R1 VCC net1 1k
R2 net1 VSS 1k
RE net3 VSS 1k
.ends dut
