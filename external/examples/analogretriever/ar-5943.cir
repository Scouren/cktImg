* official Analog Canvas netlist; PDK X cards rewritten by convert.py
.model nch nmos
.model qnpn npn

.subckt dut VDD VSS Vin Vout
I1 net0 VSS DC 1m
I2 VDD Vout DC 1m
M1 VDD Vin net0 VSS nch l=0.15 w=1 nf=1 m=1
Q2 Vout net0 VSS VSS qnpn m=1
.ends dut
