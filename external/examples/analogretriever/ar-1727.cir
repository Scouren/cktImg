* official Analog Canvas netlist; PDK X cards rewritten by convert.py
.model nch nmos

.subckt dut VDD VSS Vin Vout
M1 VDD X Vout VSS nch l=0.15 w=1 nf=1 m=1
RF X Vout 1k
RL Vout VSS 1k
RS Vin X 1k
.ends dut
