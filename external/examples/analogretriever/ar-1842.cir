* official Analog Canvas netlist; PDK X cards rewritten by convert.py
.model nch nmos

.subckt dut VDD VSS Vout Vin
I1 VDD net0 DC 1m
ISS Vout VSS DC 1m
M1 net0 Vout Vin VSS nch l=0.15 w=1 nf=1 m=1
M2 VDD net0 Vout VSS nch l=0.15 w=1 nf=1 m=1
.ends dut
