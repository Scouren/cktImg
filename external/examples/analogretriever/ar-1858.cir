* official Analog Canvas netlist; PDK X cards rewritten by convert.py
.model nch nmos

.subckt dut VDD VSS Vb Vout
I1 Vout VSS DC 1m
Iin VSS net0 DC 1m
M1 net1 Vb net0 VSS nch l=0.15 w=1 nf=1 m=1
M2 VDD net1 Vout VSS nch l=0.15 w=1 nf=1 m=1
RD VDD net1 1k
RF net0 Vout 1k
.ends dut
