* official Analog Canvas netlist; PDK X cards rewritten by convert.py
.model qnpn npn

* Potentiometer: end 1 to wiper r*pos, wiper to end 2 r*(1-pos)
.subckt potentiometer n1 nw n2 params: r=10k pos=0.5
R1 n1 nw {max(r*pos,1m)}
R2 nw n2 {max(r*(1-pos),1m)}
.ends potentiometer

.subckt dut VSS Vin Vout
.model icm_zener_D1 D(BV=7.5)
D1 VSS net1 icm_zener_D1
Q1 net4 net2 net1 VSS qnpn m=1
Q2 Vin net4 Vout VSS qnpn m=1
R1 Vin net1 1kΩ
R2 Vin net4 1.5kΩ
R3 Vout net3 1kΩ
R5 net0 VSS 1kΩ
RL Vout VSS 1k
X1 net3 net2 net0 potentiometer pos=0.5 r=1kΩ
.ends dut
