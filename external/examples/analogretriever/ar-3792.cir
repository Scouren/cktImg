* official Analog Canvas netlist; PDK X cards rewritten by convert.py
.model nch nmos

.subckt dut VDD VSS GND vo
CC1 net1 net3 1p
CC2 net0 vo 1p
CS net2 GND 1p
IQ net2 VSS DC 1m
M1 net0 net3 net2 GND nch l=0.15 w=1 nf=1 m=1
RD VDD net0 1k
RG net3 GND 200kΩ
RL vo GND 1k
Vi net1 GND DC 1
.ends dut
