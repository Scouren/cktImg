* official Analog Canvas netlist; PDK X cards rewritten by convert.py
.model qnpn npn

.subckt dut VCC VSS Vin Vout Vb
IREF VCC net0 DC 1m
Q1 Vin net0 VSS VSS qnpn m=1
Q2 Vout Vb Vin VSS qnpn m=1
QREF net0 net0 VSS VSS qnpn m=1
RC VCC Vout 1k
.ends dut
