* official Analog Canvas netlist; PDK X cards rewritten by convert.py
.model qnpn npn

.subckt dut VCC VSS vin vout
C1 vin net1 1p
C2 net2 vout 1p
C3 net0 VSS 1p
Q1 net2 net0 net1 VSS qnpn m=1
R1 net0 VCC 1k
R2 net0 VSS 1k
RC net2 VCC 1k
RE net1 VSS 1k
.ends dut
