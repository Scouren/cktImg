* official Analog Canvas netlist; PDK X cards rewritten by convert.py
.model nch nmos

.subckt dut VDD VSS Vin1 Vin2 Vout1 Vout2
I1 net0 VSS DC 1m
I2 net1 VSS DC 1m
M1 Vout1 Vin1 net0 VSS nch l=0.15 w=1 nf=1 m=1
M2 Vout2 Vin2 net1 VSS nch l=0.15 w=1 nf=1 m=1
M3 VDD VDD Vout1 VSS nch l=0.15 w=1 nf=1 m=1
M4 VDD VDD Vout2 VSS nch l=0.15 w=1 nf=1 m=1
R1 Vout1 net0 1k
R2 Vout2 net1 1k
RSS net0 net1 1k
.ends dut
