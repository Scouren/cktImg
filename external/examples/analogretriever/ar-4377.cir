* official Analog Canvas netlist; PDK X cards rewritten by convert.py
.model nch nmos
.model pch pmos

.subckt dut VDD VSS v1 v2 vO
IQ VDD net1 DC 1m
M1 net0 v1 net1 VDD pch l=0.15 w=1 nf=1 m=1
M2 vO v2 net1 VDD pch l=0.15 w=1 nf=1 m=1
M3 net0 net0 VSS VSS nch l=0.15 w=1 nf=1 m=1
M4 vO net0 VSS VSS nch l=0.15 w=1 nf=1 m=1
.ends dut
