* official Analog Canvas netlist; PDK X cards rewritten by convert.py

.subckt dut VSS
VB1 net0 VSS DC 15V
R1 net0 A 1.0kΩ
R2 A B 560Ω
R3 B C 470Ω
R4 C VSS 3.3kΩ
R5 C VSS 2.2kΩ
.ends dut
