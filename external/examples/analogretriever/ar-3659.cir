* official Analog Canvas netlist; PDK X cards rewritten by convert.py

.subckt dut VSS VO
.model DIODE D(IS=1e-14 N=1)
D1 net1 VO DIODE
D2 VO net2 DIODE
R1 net0 net1 5kΩ
R2 net0 VO 5kΩ
R3 VO VSS 500Ω
R4 net2 VSS 500Ω
VI net0 VSS DC 1
.ends dut
