* official Analog Canvas netlist; PDK X cards rewritten by convert.py
.model nch nmos

.subckt dut VDD VSS vI vO
M1 VDD vI vO VSS nch l=0.15 w=1 nf=1 m=1
M2 vO net0 VSS VSS nch l=0.15 w=1 nf=1 m=1
M3 VDD VDD net1 VSS nch l=0.15 w=1 nf=1 m=1
M4 net1 net1 net0 VSS nch l=0.15 w=1 nf=1 m=1
M5 net0 net0 VSS VSS nch l=0.15 w=1 nf=1 m=1
.ends dut
