* official Analog Canvas netlist; PDK X cards rewritten by convert.py
.model nch nmos

.subckt Circuit_1 P N
.ends Circuit_1

.subckt Circuit_2 P N
.ends Circuit_2

.subckt dut VDD VSS
IREF VDD net2 DC 1m
M1 net1 net2 VSS VSS nch l=0.15 w=1 nf=1 m=1
M2 net0 net2 VSS VSS nch l=0.15 w=1 nf=1 m=1
MREF net2 net2 VSS VSS nch l=0.15 w=1 nf=1 m=1
X1 VDD net1 Circuit_1
X2 VDD net0 Circuit_2
.ends dut
