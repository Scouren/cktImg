* official Analog Canvas netlist; PDK X cards rewritten by convert.py
.model nch nmos

.subckt dut VDD VSS Vin1 Vin2
ISS P VSS DC 1m
M1 X Vin1 P VSS nch l=0.15 w=1 nf=1 m=1
M2 Y Vin2 P VSS nch l=0.15 w=1 nf=1 m=1
RD1 VDD X 1k
RD2 VDD Y 1k
RSS P VSS 1k
.ends dut
