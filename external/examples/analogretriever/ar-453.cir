* official Analog Canvas netlist; PDK X cards rewritten by convert.py

.subckt dut VSS Vo
Cin net0 VSS 1p
E1 Vo VSS VSS net0 1
R1 net1 net0 100kΩ
R2 net0 Vo 100kΩ
Vi net1 VSS DC 1
.ends dut
