* official Analog Canvas netlist; PDK X cards rewritten by convert.py

.subckt dut VSS vo
G1 net3 net0 net1 net0 1m
G2 vo net0 net2 net0 1m
G4 vo VSS net3 VSS 1m
R3 VSS net3 1k
Ro1 net3 net0 1k
Ro2 vo net0 1k
Ro4 VSS vo 1k
Rpi1 net1 net0 1k
Rpi2 net2 net0 1k
Rpi4 VSS net3 1k
Rtail net0 VSS 1k
V1 net1 VSS DC 1
V2 net2 VSS DC 1
.ends dut
