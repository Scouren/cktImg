* official Analog Canvas netlist; PDK X cards rewritten by convert.py
.model nch nmos
.model pch pmos

.subckt dut VDD VSS in- in+ Vo
I1 net11 VSS DC 1m
I2 net2 VSS DC 1m
M1 VDD in- net10 VSS nch l=0.15 w=1 nf=1 m=1
M10 net8 net8 net5 VDD pch l=0.15 w=1 nf=1 m=1
M11 net6 net6 net3 VSS nch l=0.15 w=1 nf=1 m=1
M12 net3 net3 VSS VSS nch l=0.15 w=1 nf=1 m=1
M13 net7 net5 VDD VDD pch l=0.15 w=1 nf=1 m=1
M14 Vo net8 net7 VDD pch l=0.15 w=1 nf=1 m=1
M15 Vo net6 net9 VSS nch l=0.15 w=1 nf=1 m=1
M16 net9 net3 VSS VSS nch l=0.15 w=1 nf=1 m=1
M2 VDD in- net0 VSS nch l=0.15 w=1 nf=1 m=1
M3 net8 in+ net1 VSS nch l=0.15 w=1 nf=1 m=1
M4 VDD in+ net4 VSS nch l=0.15 w=1 nf=1 m=1
M5 net11 net11 net10 VDD pch l=0.15 w=1 nf=1 m=1
M6 VSS net11 net1 VDD pch l=0.15 w=1 nf=1 m=1
M7 net6 net2 net0 VDD pch l=0.15 w=1 nf=1 m=1
M8 net2 net2 net4 VDD pch l=0.15 w=1 nf=1 m=1
M9 net5 net5 VDD VDD pch l=0.15 w=1 nf=1 m=1
.ends dut
