* official Analog Canvas netlist; PDK X cards rewritten by convert.py

.subckt dut VSS Vout
CGD net1 Vout 1p
G1 Vout net0 net1 net0 1m
RD Vout VSS 1k
RG VSS net1 1k
RS net2 net0 1k
Vin net2 VSS DC 1
.ends dut
