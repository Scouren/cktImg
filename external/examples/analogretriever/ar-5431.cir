* official Analog Canvas netlist; PDK X cards rewritten by convert.py

.subckt dut VSS Vin Vout
L Vin net0 50mH
R1 net0 VSS 3.3kΩ
R2 net0 net1 5.6kΩ
R3 net1 VSS 4.7kΩ
R4 net1 Vout 3.9kΩ
R5 Vout VSS 6.8kΩ
.ends dut
