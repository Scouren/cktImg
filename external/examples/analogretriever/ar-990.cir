* official Analog Canvas netlist; PDK X cards rewritten by convert.py
.model qnpn npn

.subckt dut VCC VSS
Q1 net0 net1 net2 VSS qnpn m=1
Q2 net2 net2 VSS VSS qnpn m=1
R1 VCC net1 100kΩ
R2 VCC net0 1kΩ
.ends dut
