* official Analog Canvas netlist; PDK X cards rewritten by convert.py

.subckt dut VSS vA vB vC vY
.model DIODE D(IS=1e-14 N=1)
D1 vA vY DIODE
D2 vB vY DIODE
D3 vC vY DIODE
R vY VSS 1k
.ends dut
