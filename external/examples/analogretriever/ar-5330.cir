* official Analog Canvas netlist; PDK X cards rewritten by convert.py

.subckt dut VSS
VB1 A VSS DC 8V
R1 A B 3.3kΩ
R2 A B 6.2kΩ
R3 B C 1.0kΩ
R4 C VSS 1.0kΩ
R5 C net0 680Ω
R6 net0 VSS 390Ω
.ends dut
