* official Analog Canvas netlist; PDK X cards rewritten by convert.py
.model nch nmos

.subckt dut VSS Vi Vo
CL Vo VSS 1p
M1 net0 Vi VSS VSS nch l=0.15 w=1 nf=1 m=1
M2 Vo VSS net0 VSS nch l=0.15 w=1 nf=1 m=1
R1 Vo VSS 1k
.ends dut
