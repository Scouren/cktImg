* official Analog Canvas netlist; PDK X cards rewritten by convert.py
.model nch nmos
.model pch pmos

.subckt dut VDD VSS GND Vi- Vi+ Vo
C net3 Vo 1p
CL Vo GND 1p
IBIAS net1 VSS DC 1m
M1 net0 Vi- net2 VDD pch l=0.15 w=1 nf=1 m=1
M2 X Vi+ net2 VDD pch l=0.15 w=1 nf=1 m=1
M3 net0 net0 VSS VSS nch l=0.15 w=1 nf=1 m=1
M4 X net0 VSS VSS nch l=0.15 w=1 nf=1 m=1
M5 net2 net1 VDD VDD pch l=0.15 w=1 nf=1 m=1
M6 Vo X VSS VSS nch l=0.15 w=1 nf=1 m=1
M7 Vo net1 VDD VDD pch l=0.15 w=1 nf=1 m=1
M8 net1 net1 VDD VDD pch l=0.15 w=1 nf=1 m=1
RZ X net3 1k
.ends dut
