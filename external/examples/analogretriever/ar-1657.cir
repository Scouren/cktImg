* official Analog Canvas netlist; PDK X cards rewritten by convert.py
.model nch nmos

.subckt dut VSS Vin Vout
CGS Vin VSS 1p
L1 net0 VSS 1n
M1 Vout Vin VSS VSS nch l=0.15 w=1 nf=1 m=1
RS Vin net0 1k
.ends dut
