* official Analog Canvas netlist; PDK X cards rewritten by convert.py
.model qnpn npn

.subckt dut VCC VSS vo
CC1 net1 net0 1p
CC2 net2 vo 1p
CE net3 VSS 1p
ii VSS net1 DC 1m
Q1 vo net0 net3 VSS qnpn m=1
R1 VCC net0 51kΩ
R2 net0 VSS 5.5kΩ
RC VCC vo 10kΩ
RE net3 VSS 0.5kΩ
RF net0 net2 82kΩ
RS net1 VSS 10kΩ
.ends dut
