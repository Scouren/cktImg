* official Analog Canvas netlist; PDK X cards rewritten by convert.py
.model qnpn npn

.subckt dut VCC VSS vo
CC1 net4 net2 1p
CC2 net3 net6 1p
CC3 net5 vo 1p
CE1 net7 VSS 1p
CF net0 net1 1p
Ii VSS net4 DC 1m
Q1 net3 net2 net7 VSS qnpn m=1
Q2 net5 net6 net1 VSS qnpn m=1
R1 VCC net2 80kΩ
R2 net2 VSS 20kΩ
R3 VCC net6 85kΩ
R4 net6 VSS 15kΩ
RC1 VCC net3 2kΩ
RC2 VCC net5 4kΩ
RE1 net7 VSS 1kΩ
RE2 net1 VSS 0.5kΩ
RF net2 net0 10kΩ
RL vo VSS 4kΩ
RS net4 VSS 1k
.ends dut
