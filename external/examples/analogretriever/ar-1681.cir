* official Analog Canvas netlist; PDK X cards rewritten by convert.py
.model qnpn npn

.subckt dut VCC VSS Vin Vout
CL Vout VSS 1p
Cmu VCC X 1p
Cpi X Vout 1p
I1 Vout VSS DC 1m
Q1 VCC X Vout VSS qnpn m=1
RS Vin X 1k
.ends dut
