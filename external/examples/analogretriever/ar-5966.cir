* official Analog Canvas netlist; PDK X cards rewritten by convert.py
.model nch nmos

.subckt dut VDD VSS vi vo
C1 vi net1 1p
C2 net0 vo 1p
I1 VDD net0 DC 200uA
M1 net0 net1 VSS VSS nch l=0.15 w=1 nf=1 m=1
R1 net1 net0 3MegΩ
R2 net1 VSS 2MegΩ
.ends dut
