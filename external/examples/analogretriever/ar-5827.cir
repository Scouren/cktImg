* official Analog Canvas netlist; PDK X cards rewritten by convert.py

.subckt dut VSS vo
F1 vo G V__icm_sense_f277ef12009160e3 1
RD vo VSS 1k
Rgm __icm_sense_node_f277ef12009160e3 S 1k
V__icm_sense_f277ef12009160e3 G __icm_sense_node_f277ef12009160e3 DC 0
Rs S VSS 1k
Rsig net0 G 1k
Vsig net0 VSS DC 1
.ends dut
