* official Analog Canvas netlist; PDK X cards rewritten by convert.py

.subckt dut VSS Vin
.model DIODE D(IS=1e-14 N=1)
D1 net0 VSS DIODE
D2 net1 net0 DIODE
D3 Vin net1 DIODE
R1 net1 net0 1k
.ends dut
