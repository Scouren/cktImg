* official Analog Canvas netlist; PDK X cards rewritten by convert.py

.subckt dut G D S
Cdb D S 1p
Cgd G D 1p
Cgs G S 1p
Gm D S G S 1m
ro D S 1k
.ends dut
