* official Analog Canvas netlist; PDK X cards rewritten by convert.py
.model qnpn npn

.subckt dut VCC VEE VSS Vo
C Vo VSS 1p
I net1 VEE DC 1m
L Vo VSS 1n
Q1 VCC Vo net1 VEE qnpn m=1
Q2 net0 VSS net1 VEE qnpn m=1
R net0 Vo 1k
RC VCC net0 1k
.ends dut
