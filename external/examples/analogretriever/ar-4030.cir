* official Analog Canvas netlist; PDK X cards rewritten by convert.py
.model qnpn npn

.subckt dut VCC VSS vo
CC net2 net0 1p
CE net3 VSS 1p
Q1 vo net2 net1 VSS qnpn m=1
Q2 vo net1 net3 VSS qnpn m=1
R1 VCC net2 335kΩ
R2 net2 VSS 125kΩ
RC VCC vo 2.2kΩ
RE2 net3 VSS 1kΩ
vs net0 VSS DC 1
.ends dut
