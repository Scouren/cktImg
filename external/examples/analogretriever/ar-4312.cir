* official Analog Canvas netlist; PDK X cards rewritten by convert.py
.model qnpn npn
.model qpnp pnp

.subckt voltage_amplifier VDD VSS VIN VOUT params: gain=1
ECORE VOUT 0 VIN 0 {gain}
.ends voltage_amplifier

.subckt dut VCC VEE Vout vB1 vB2
IQ net0 VEE DC 1m
Q1 net1 vB1 net0 VEE qnpn m=1
Q2 net2 vB2 net0 VEE qnpn m=1
Q3 net1 net3 VCC qpnp m=1
Q4 net2 net3 VCC qpnp m=1
Q5 VEE net1 net3 qpnp m=1
X1 0 0 net2 Vout voltage_amplifier gain=1
.ends dut
