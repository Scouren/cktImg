* official Analog Canvas netlist; PDK X cards rewritten by convert.py

.subckt dut VSS vI vO
.model DIODE D(IS=1e-14 N=1)
.model icm_zener_DZ D(BV=5)
D1 vO net0 DIODE
D2 net1 VSS DIODE
D3 VSS net0 DIODE
D4 net1 vO DIODE
DZ net1 net0 icm_zener_DZ
R1 vI vO 1kΩ
.ends dut
