* official Analog Canvas netlist; PDK X cards rewritten by convert.py
.model qnpn npn
.model qpnp pnp

.subckt dut VCC VSS Vin Vb1 Vb2 Vout
Q1 net0 net1 VSS VSS qnpn m=1
Q2 Vout Vb1 net0 VSS qnpn m=1
Q3 net0 Vb2 VCC qpnp m=1
RB Vin net1 1k
RC VCC Vout 1k
.ends dut
