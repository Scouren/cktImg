* official Analog Canvas netlist; PDK X cards rewritten by convert.py
.model qnpn npn

.subckt dut VSS Vin Vout
VB1 net2 VSS DC 2.5V
VB2 net0 VSS DC 1.5V
Q1 net2 Vin net1 VSS qnpn m=1
Q2 Vout net0 net1 VSS qnpn m=1
R1 net2 Vout 1kΩ
R2 net1 VSS 1kΩ
.ends dut
