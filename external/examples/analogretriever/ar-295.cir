* official Analog Canvas netlist; PDK X cards rewritten by convert.py
.model qnpn npn

.subckt dut VSS voc
CT net1 VSS 1p
Q1 voc net0 net1 VSS qnpn m=1
RL VSS voc 1k
RS net2 net0 1k
RT net1 VSS 1k
Vic net2 VSS DC 1
.ends dut
