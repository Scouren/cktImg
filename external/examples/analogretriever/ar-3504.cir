* official Analog Canvas netlist; PDK X cards rewritten by convert.py
.model qnpn npn

.subckt dut VCC VEE VSS vIN vOUT
ILS net4 VEE DC 1m
Q1 net2 vIN net6 VEE qnpn m=1
Q2 net1 net2 net3 VEE qnpn m=1
Q3 VCC net1 net0 VEE qnpn m=1
Q4 VCC net4 vOUT VEE qnpn m=1
RB1 VCC vIN 1k
RB2 vIN VEE 1k
RC1 VCC net2 1k
RC2 VCC net1 1k
RE1 net6 VEE 1k
RE2 net3 VEE 1k
RE3 net0 net4 1k
RE4 vOUT VEE 1k
RL vOUT VSS 1k
RT vIN net5 1k
VT net5 VSS DC 1
.ends dut
