* official Analog Canvas netlist; PDK X cards rewritten by convert.py
.model qnpn npn

.subckt dut VSS vo
Q1 VSS net0 net1 VSS qnpn m=1
Q2 vo net1 VSS VSS qnpn m=1
RL vo VSS 1k
RS net2 net0 1k
Vi net2 VSS DC 1
.ends dut
