* official Analog Canvas netlist; PDK X cards rewritten by convert.py
.model nch nmos
.model pch pmos

.subckt dut VSS Vin1 Vout1
M1 net1 Vin1 VSS VSS nch l=0.15 w=1 nf=1 m=1
M3 Vout1 VSS net1 VSS nch l=0.15 w=1 nf=1 m=1
M5 Vout1 VSS net0 VSS pch l=0.15 w=1 nf=1 m=1
M7 net0 VSS VSS VSS pch l=0.15 w=1 nf=1 m=1
R1 net0 Vout1 1k
.ends dut
