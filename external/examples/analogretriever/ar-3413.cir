* official Analog Canvas netlist; PDK X cards rewritten by convert.py
.model qnpn npn

.subckt dut VCC VSS vIN vOUT
C1 net3 vIN 1p
CB net1 VSS 1p
CO net2 vOUT 1p
Q net2 net1 net3 VSS qnpn m=1
RB1 VCC net1 1k
RB2 net1 VSS 1k
RC VCC net2 1k
RE net3 VSS 1k
RL vOUT VSS 1k
RT vIN net0 1k
vT net0 VSS DC 1
.ends dut
