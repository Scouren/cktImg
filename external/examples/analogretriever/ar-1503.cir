* official Analog Canvas netlist; PDK X cards rewritten by convert.py

.subckt dut VSS
G1 net3 VSS net0 VSS 1m
G2 net2 VSS net1 VSS 1m
RC1 VSS net3 1k
RC2 VSS net2 1k
Rpi1 net0 VSS 1k
Rpi2 net1 VSS 1k
Vin1 net0 VSS DC 1
Vin2 net1 VSS DC 1
.ends dut
