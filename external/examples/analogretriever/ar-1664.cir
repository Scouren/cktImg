* official Analog Canvas netlist; PDK X cards rewritten by convert.py
.model nch nmos

.subckt dut VDD VSS Vin Vout
CDB Vout VSS 1p
CGD Vin Vout 1p
CGS Vin VSS 1p
CSB VSS VSS 1p
M1 Vout Vin VSS VSS nch l=0.15 w=1 nf=1 m=1
RL VDD Vout 1k
.ends dut
