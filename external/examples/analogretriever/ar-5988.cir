* official Analog Canvas netlist; PDK X cards rewritten by convert.py
.model qnpn npn

.subckt dut VCC VEE IO1 IO2
IREF VCC net1 DC 1m
Q1 net1 net0 VEE VEE qnpn m=1
Q2 net0 net0 VEE VEE qnpn m=1
Q3 IO1 net1 net0 VEE qnpn m=1
Q4 IO2 net1 net0 VEE qnpn m=1
.ends dut
