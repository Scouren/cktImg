* official Analog Canvas netlist; PDK X cards rewritten by convert.py

.subckt dut VSS Vin Vout
G1 Vout VSS Vin VSS 1m
R1 Vout VSS 1k
R2 Vout VSS 1k
RT net0 Vin 1k
Vt net0 VSS DC 1
.ends dut
