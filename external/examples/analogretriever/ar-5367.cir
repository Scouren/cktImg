* official Analog Canvas netlist; PDK X cards rewritten by convert.py

.subckt dut
VB1 net0 net3 DC 2V
VB2 net2 net3 DC 3V
R1 net0 net1 1.0kΩ
R2 net1 net3 2.2kΩ
R3 net1 net4 1.0kΩ
R4 net4 net2 1.0kΩ
R5 net4 net3 2.2kΩ
.ends dut
