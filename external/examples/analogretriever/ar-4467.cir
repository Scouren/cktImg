* official Analog Canvas netlist; PDK X cards rewritten by convert.py
.model nch nmos
.model pch pmos

.subckt dut VDD VSS v2 v1 vo
M1 vo1 v1 net3 VDD pch l=0.15 w=1 nf=1 m=1
M2 net0 v2 net3 VDD pch l=0.15 w=1 nf=1 m=1
M3 vo1 net0 VSS VSS nch l=0.15 w=1 nf=1 m=1
M4 net0 net0 VSS VSS nch l=0.15 w=1 nf=1 m=1
M5 net1 net2 VDD VDD pch l=0.15 w=1 nf=1 m=1
M6 net4 vo1 VSS VSS nch l=0.15 w=1 nf=1 m=1
M7 net3 net2 VDD VDD pch l=0.15 w=1 nf=1 m=1
M8 net2 net2 VDD VDD pch l=0.15 w=1 nf=1 m=1
M9 VSS VSS net2 VDD pch l=0.15 w=1 nf=1 m=1
R1 net1 vo 1k
R2 vo net4 1k
.ends dut
