* official Analog Canvas netlist; PDK X cards rewritten by convert.py
.model qnpn npn

.subckt dut VCC VCC2 VEE VSS vo
I1 net0 VEE DC 1mA
Q1 VCC2 net1 net0 VEE qnpn m=1
Q2 vo VSS net0 VEE qnpn m=1
R1 net2 net1 10kΩ
R2 VCC vo 10kΩ
vsig net2 VSS DC 1
.ends dut
