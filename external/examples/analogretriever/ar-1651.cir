* official Analog Canvas netlist; PDK X cards rewritten by convert.py
.model nch nmos

.subckt dut VSS G D S
CDB D VSS 1p
CGD D G 1p
CGS G S 1p
CSB S VSS 1p
M1 D G S VSS nch l=0.15 w=1 nf=1 m=1
.ends dut
