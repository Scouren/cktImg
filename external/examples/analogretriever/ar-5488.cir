* official Analog Canvas netlist; PDK X cards rewritten by convert.py
.model nch nmos

.subckt dut VDD VSS Vout
C1 net1 net0 1p
C2 Vout net3 1p
C3 net2 VSS 1p
M1 net3 net1 net2 net2 nch l=0.15 w=1 nf=1 m=1
R1 VDD net1 1k
R2 net1 VSS 1k
RD VDD net3 1k
RS net2 VSS 1k
Vin net0 VSS DC 1 SIN(0 1 1k 0 0 0)
.ends dut
