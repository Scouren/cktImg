* official Analog Canvas netlist; PDK X cards rewritten by convert.py
.model qnpn npn

.subckt dut VCC VSS
Q1 net1 net2 VSS VSS qnpn m=1
R1 VCC net0 1kΩ
RB net2 net0 1k
Rp net0 net1 100Ω
.ends dut
