* official Analog Canvas netlist; PDK X cards rewritten by convert.py

.subckt dut VSS
G1 VSS net1 net0 VSS 1m
R1 net1 VSS 1k
Ri net0 VSS 1k
RL net1 VSS 1k
Ro net0 net1 1k
RS net2 net0 1k
Vs net2 VSS DC 1
.ends dut
