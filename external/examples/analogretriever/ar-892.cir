* official Analog Canvas netlist; PDK X cards rewritten by convert.py
.model qnpn npn

.subckt dut VCC VSS
C1 net2 net0 1p
Q1 net1 net0 VSS VSS qnpn m=1
R1 VCC net0 1k
R2 net0 VSS 1k
RC VCC net1 1k
vin net2 VSS DC 1
.ends dut
