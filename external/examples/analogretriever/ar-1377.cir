* official Analog Canvas netlist; PDK X cards rewritten by convert.py
.model nch nmos
.model pch pmos

.subckt dut VDD VSS Vb2 Vb1 vin vout
M1 X vin VSS VSS nch l=0.15 w=1 nf=1 m=1
M2 vout Vb1 X VSS nch l=0.15 w=1 nf=1 m=1
M3 vout Vb2 net0 VDD pch l=0.15 w=1 nf=1 m=1
M4 net0 Vb2 VDD VDD pch l=0.15 w=1 nf=1 m=1
.ends dut
