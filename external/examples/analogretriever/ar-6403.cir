* official Analog Canvas netlist; PDK X cards rewritten by convert.py

.subckt opamp VDD VSS VIP VIN VOUT params: gain=1e6 vhigh=5 vlow=-5
Blin nlin 0 V={gain*(V(VIP)-V(VIN))}
Bcore VOUT 0 V={0.5*(vhigh+(0.5*(vlow+V(nlin)+sqrt((V(nlin)-vlow)*(V(nlin)-vlow)+(1e-4*(vhigh-vlow))*(1e-4*(vhigh-vlow))+1e-12)))-sqrt((vhigh-(0.5*(vlow+V(nlin)+sqrt((V(nlin)-vlow)*(V(nlin)-vlow)+(1e-4*(vhigh-vlow))*(1e-4*(vhigh-vlow))+1e-12))))*(vhigh-(0.5*(vlow+V(nlin)+sqrt((V(nlin)-vlow)*(V(nlin)-vlow)+(1e-4*(vhigh-vlow))*(1e-4*(vhigh-vlow))+1e-12))))+(1e-4*(vhigh-vlow))*(1e-4*(vhigh-vlow))+1e-12))}
.ends opamp

.subckt dut VSS v1 v2 VM1 vO
.model DIODE D(IS=1e-14 N=1)
D1 net4 A DIODE
D2 net2 B DIODE
D3 C net0 DIODE
D4 D net3 DIODE
R1 v1 net4 1kΩ
R2 v2 net2 1kΩ
R3 VM1 net0 1kΩ
R4 A net1 1kΩ
R5 B net1 1kΩ
R6 C net1 1kΩ
R7 net1 D 1kΩ
R8 net3 vO 1kΩ
X1 0 VSS VSS net4 A opamp gain=1e6
X2 0 VSS VSS net2 B opamp gain=1e6
X3 0 VSS VSS net0 C opamp gain=1e6
X4 0 VSS VSS net1 D opamp gain=1e6
X5 0 VSS VSS net3 vO opamp gain=1e6
.ends dut
