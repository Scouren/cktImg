* official Analog Canvas netlist; PDK X cards rewritten by convert.py
.model qnpn npn

.subckt dut VCC VEE Vin Vout
I1 net0 VEE DC 1m
Q1 VCC Vin net0 VEE qnpn m=1
Q2 VCC net0 Vout VEE qnpn m=1
RE Vout VEE 1k
.ends dut
