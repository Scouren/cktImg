* official Analog Canvas netlist; PDK X cards rewritten by convert.py
.model qnpn npn

.subckt dut VCC VEE VSS Q5_C Q6_C Q16_C Q16_E
Q16 Q16_C Q6_C Q16_E VSS qnpn m=1
Q5 Q5_C net2 net0 VSS qnpn m=1
Q6 Q6_C net2 net1 VSS qnpn m=1
Q7 VCC Q5_C net2 VSS qnpn m=1
R1 net0 VEE 1k
R2 net1 VEE 1k
R3 net2 VEE 1k
.ends dut
