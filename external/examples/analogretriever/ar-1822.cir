* official Analog Canvas netlist; PDK X cards rewritten by convert.py
.model nch nmos

.subckt dut VDD VSS Vin Vout
C1 net1 VSS 1p
C2 net0 VSS 1p
C3 Vout VSS 1p
M1 net1 Vin VSS VSS nch l=0.15 w=1 nf=1 m=1
M2 net0 net1 VSS VSS nch l=0.15 w=1 nf=1 m=1
M3 Vout net0 VSS VSS nch l=0.15 w=1 nf=1 m=1
RD1 VDD net1 1k
RD2 VDD net0 1k
RD3 VDD Vout 1k
.ends dut
