* official Analog Canvas netlist; PDK X cards rewritten by convert.py
.model qnpn npn

.subckt dut VSS Vin
Ii net2 net1 DC 1m
Q1 net0 net1 net2 VSS qnpn m=1
RE2 net2 VSS 1k
RL VSS net0 1k
Vi net1 Vin DC 1
.ends dut
