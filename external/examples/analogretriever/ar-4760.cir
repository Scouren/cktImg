* official Analog Canvas netlist; PDK X cards rewritten by convert.py
.model qnpn npn

.subckt dut VCC VEE VSS vin vout
C1 vin net2 1p
C2 net1 net7 1p
C3 net0 net6 1p
C4 net5 vout 1p
Q1 net1 net2 net8 VEE qnpn m=1
Q2 net0 net7 net4 VEE qnpn m=1
Q3 net5 net6 net3 VEE qnpn m=1
RB1 net2 VSS 33kΩ
RB2 net7 VSS 33kΩ
RB3 net6 VSS 33kΩ
RC1 VCC net1 10kΩ
RC2 VCC net0 10kΩ
RC3 VCC net5 10kΩ
RE1 net8 VEE 20kΩ
RE2 net4 VEE 20kΩ
RE3 net3 VEE 20kΩ
.ends dut
