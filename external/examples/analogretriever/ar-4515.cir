* official Analog Canvas netlist; PDK X cards rewritten by convert.py

.subckt dut VSS Vgs Vo
C1 Vo VSS 1p
C2 Vgs VSS 1p
G1 Vo VSS Vgs VSS 1m
L Vgs Vo 1n
R Vo VSS 1k
.ends dut
