* official Analog Canvas netlist; PDK X cards rewritten by convert.py

.subckt dut VDD VSS VO
.model DIODE D(IS=1e-14 N=1)
D1 VO net1 DIODE
D2 net1 net0 DIODE
D3 net0 net2 DIODE
D4 net2 VSS DIODE
R VDD VO 1k
.ends dut
