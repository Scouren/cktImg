* official Analog Canvas netlist; PDK X cards rewritten by convert.py
.model qnpn npn

.subckt dut VCC VEE VSS vi vo
I1 net1 VEE DC 0.1mA
I2 net0 VEE DC 0.1mA
Q1 VCC vi net1 VEE qnpn m=1
Q2 vo VSS net0 VEE qnpn m=1
R1 net1 net0 500Ω
R2 VCC vo 25kΩ
.ends dut
