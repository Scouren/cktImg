* official Analog Canvas netlist; PDK X cards rewritten by convert.py
.model qnpn npn

.subckt dut VSS
Q1 net2 net0 net5 VSS qnpn m=1
Q2 net1 net2 VSS VSS qnpn m=1
Q3 net4 net1 net3 VSS qnpn m=1
R1 net5 VSS 88Ω
R2 net2 VSS 9kΩ
R3 net1 VSS 5kΩ
R4 net3 VSS 88Ω
RC net4 VSS 1k
Vs net0 VSS DC 1
.ends dut
