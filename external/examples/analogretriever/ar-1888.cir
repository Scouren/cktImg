* official Analog Canvas netlist; PDK X cards rewritten by convert.py
.model nch nmos
.model pch pmos

.subckt dut VDD VSS Vin Vout
C1 Vin net2 10pF
M1 net3 net1 VSS VSS nch l=0.15 w=1 nf=1 m=1
M2 net3 net1 VDD VDD pch l=0.15 w=1 nf=1 m=1
M3 net0 net3 VSS VSS nch l=0.15 w=1 nf=1 m=1
M4 net0 net3 VDD VDD pch l=0.15 w=1 nf=1 m=1
M5 Vout net0 VSS VSS nch l=0.15 w=1 nf=1 m=1
M6 Vout net0 VDD VDD pch l=0.15 w=1 nf=1 m=1
R1 net2 net1 1kΩ
R2 net1 Vout 10kΩ
.ends dut
