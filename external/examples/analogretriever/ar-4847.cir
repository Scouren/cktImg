* official Analog Canvas netlist; PDK X cards rewritten by convert.py

.subckt dut VSS
I1 VSS net0 DC 1m
R1 net2 VSS 5kΩ
re net0 VSS 3.03kΩ
RG net1 net2 600Ω
vg net1 VSS DC 1V
.ends dut
