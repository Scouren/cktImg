* official Analog Canvas netlist; PDK X cards rewritten by convert.py
.model nch nmos
.model pch pmos

.subckt dut VDD VSS IBIASN1 IBIASn IBIASP1 IBIASPn
IBIAS_EXT VBP2 VSS DC 1m
MN1 net5 VBN2 VSS VSS nch l=0.15 w=1 nf=1 m=1
MN2 VBN2 VBN2 net5 VSS nch l=0.15 w=1 nf=1 m=1
MN3 net6 VBN1 VSS VSS nch l=0.15 w=1 nf=1 m=1
MN4 VBN1 VBN2 net6 VSS nch l=0.15 w=1 nf=1 m=1
MN5 net4 VBN1 VSS VSS nch l=0.15 w=1 nf=1 m=1
MN6 IBIASP1 VBN2 net4 VSS nch l=0.15 w=1 nf=1 m=1
MN7 net8 VBN1 VSS VSS nch l=0.15 w=1 nf=1 m=1
MN8 IBIASPn VBN2 net8 VSS nch l=0.15 w=1 nf=1 m=1
MP1 net2 VBP1 VDD VDD pch l=0.15 w=1 nf=1 m=1
MP10 IBIASn VBP2 net1 VDD pch l=0.15 w=1 nf=1 m=1
MP2 VBP1 VBP2 net2 VDD pch l=0.15 w=1 nf=1 m=1
MP3 net0 VBP1 VDD VDD pch l=0.15 w=1 nf=1 m=1
MP4 VBN2 VBP2 net0 VDD pch l=0.15 w=1 nf=1 m=1
MP5 net7 VBP1 VDD VDD pch l=0.15 w=1 nf=1 m=1
MP6 VBN1 VBP2 net7 VDD pch l=0.15 w=1 nf=1 m=1
MP7 net3 VBP1 VDD VDD pch l=0.15 w=1 nf=1 m=1
MP8 IBIASN1 VBP2 net3 VDD pch l=0.15 w=1 nf=1 m=1
MP9 net1 VBP1 VDD VDD pch l=0.15 w=1 nf=1 m=1
RBIAS VBP1 VBP2 1k
.ends dut
