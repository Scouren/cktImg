* official Analog Canvas netlist; PDK X cards rewritten by convert.py

.subckt dut
VB1 net1 net0 DC 1
R1 net1 net0 1k
R2 net1 net0 1k
R3 net1 net0 1k
R4 net1 net0 1k
R5 net1 net0 1k
.ends dut
