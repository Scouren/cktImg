* official Analog Canvas netlist; PDK X cards rewritten by convert.py

.subckt dut VSS B1 C1
G1 C1 net0 B1 net0 1m
RE net0 VSS 1k
RL1 C1 VSS 1k
Rpi1 B1 net0 1k
Rs B1 VSS 1k
.ends dut
