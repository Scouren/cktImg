* official Analog Canvas netlist; PDK X cards rewritten by convert.py
.model qnpn npn

.subckt dut VSS VC VB
C VC VB 1p
L1 VC net0 1n
L2 net0 VB 1n
Q1 VC VB net0 VSS qnpn m=1
.ends dut
