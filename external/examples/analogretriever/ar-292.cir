* official Analog Canvas netlist; PDK X cards rewritten by convert.py
.model nch nmos

.subckt dut VSS VDD vi+ vi- vo+ vo-
ISS net1 VSS DC 1m
M1 vo+ net2 net1 VSS nch l=0.15 w=1 nf=1 m=1
M2 vo- net0 net1 VSS nch l=0.15 w=1 nf=1 m=1
RL1 VDD vo+ 1k
RL2 VDD vo- 1k
RS1 vi+ net2 1k
RS2 vi- net0 1k
.ends dut
