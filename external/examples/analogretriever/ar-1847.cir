* official Analog Canvas netlist; PDK X cards rewritten by convert.py
.model nch nmos

.subckt dut VDD VSS Vb Vout
I1 VDD net0 DC 1m
I2 net2 VSS DC 1m
Iin VSS net1 DC 1m
ISS Vout VSS DC 1m
M1 VDD net1 net2 VSS nch l=0.15 w=1 nf=1 m=1
M2 net0 Vb net2 VSS nch l=0.15 w=1 nf=1 m=1
M3 VDD net0 Vout VSS nch l=0.15 w=1 nf=1 m=1
RF net1 Vout 1k
.ends dut
