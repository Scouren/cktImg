* official Analog Canvas netlist; PDK X cards rewritten by convert.py

.subckt dut VDD VSS VO
.model DIODE D(IS=1e-14 N=1)
D1 VO net0 DIODE
D2 net0 VSS DIODE
R1 VDD VO 200Ω
R2 VO VSS 150Ω
.ends dut
