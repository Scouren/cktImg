* official Analog Canvas netlist; PDK X cards rewritten by convert.py
.model nch nmos

.subckt dut VDD VSS GND vo
CC1 net2 net0 1p
CC2 net4 vo 1p
CG net5 GND 1p
CS net3 GND 1p
M1 net4 net0 net3 GND nch l=0.15 w=1 nf=1 m=1
R1 VDD net5 179.5kΩ
R2 net5 net0 175kΩ
R3 net0 GND 145.5kΩ
RD VDD net4 3kΩ
Ri net1 net2 2kΩ
RL vo GND 10kΩ
RS net3 VSS 10kΩ
Vi net1 GND DC 1
.ends dut
