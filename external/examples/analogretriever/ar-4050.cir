* official Analog Canvas netlist; PDK X cards rewritten by convert.py

.subckt dut VSS Vo
CE net0 VSS 1p
G1 Vo net0 net2 net0 1m
RC Vo VSS 1k
RE net0 VSS 1k
Rpi net2 net0 1k
RS net1 net2 1k
Vi net1 VSS DC 1
.ends dut
