* official Analog Canvas netlist; PDK X cards rewritten by convert.py

.subckt dut VSS Vin Vout
G1 Vout net1 Vin net1 1m
I1 Vout net1 DC 1m
R net0 Vout 1k
Rtail net1 VSS 1k
V2 net0 VSS DC 1
vic Vin VSS DC 1
.ends dut
