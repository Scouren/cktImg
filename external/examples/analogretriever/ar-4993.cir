* official Analog Canvas netlist; PDK X cards rewritten by convert.py
.model nch nmos

.subckt dut VDD VSS vout
C1 net1 net0 1p
C2 net2 vout 1p
M1 net2 net0 VSS VSS nch l=0.15 w=1 nf=1 m=1
RD VDD net2 1k
RG net0 VSS 1k
RL vout VSS 1k
vin net1 VSS SIN(0 1 1k 0 0 0)
.ends dut
