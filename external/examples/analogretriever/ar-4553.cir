* official Analog Canvas netlist; PDK X cards rewritten by convert.py
.model nch nmos

.subckt dut VDD VSS A B C vO
MDA vO A net0 VSS nch l=0.15 w=1 nf=1 m=1
MDB vO B net0 VSS nch l=0.15 w=1 nf=1 m=1
MDC net0 C VSS VSS nch l=0.15 w=1 nf=1 m=1
ML VDD VDD vO VSS nch l=0.15 w=1 nf=1 m=1
.ends dut
