* official Analog Canvas netlist; PDK X cards rewritten by convert.py

.subckt dut VSS Vi Vo
G1 net0 VSS Vi VSS 1m
G2 Vo net0 VSS net0 1m
Ro1 net0 VSS 1k
Ro2 Vo net0 1k
Ro3 Vo VSS 1k
.ends dut
