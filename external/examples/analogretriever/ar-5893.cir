* official Analog Canvas netlist; PDK X cards rewritten by convert.py
.model qnpn npn

.subckt dut VCC VSS Vin vo
C1 Vin net2 1p
C2 net0 vo 1p
I1 VCC net0 DC 0.5mA
Q1 net0 net2 net1 VSS qnpn m=1
R1 net0 net2 200kΩ
R2 net1 VSS 200Ω
R3 vo VSS 20kΩ
Vi Vin VSS DC 1
.ends dut
