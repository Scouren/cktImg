* official Analog Canvas netlist; PDK X cards rewritten by convert.py

.subckt dut VSS Vout
C1 Vout VSS 1p
Iin VSS net0 DC 1m
L1 net0 Vout 1n
R1 net0 Vout 1k
.ends dut
