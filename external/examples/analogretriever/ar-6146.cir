* official Analog Canvas netlist; PDK X cards rewritten by convert.py
.model nch nmos

.subckt dut VDD VSS GND Vo Vin
I1 net1 VSS DC 1m
I2 VDD Vo DC 1m
M1 VDD Vin net1 GND nch l=0.15 w=1 nf=1 m=1
M2 Vo net1 GND GND nch l=0.15 w=1 nf=1 m=1
Rsig net0 Vin 1k
Vsig net0 GND DC 1
.ends dut
