* official Analog Canvas netlist; PDK X cards rewritten by convert.py

.subckt dut VSS vo
E1 net0 VSS v1 VSS 1
Ii VSS v1 DC 1m
RF v1 vo 1k
Ri v1 VSS 1k
RL vo VSS 1k
Ro net0 vo 1k
.ends dut
