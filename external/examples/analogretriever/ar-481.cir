* official Analog Canvas netlist; PDK X cards rewritten by convert.py

.subckt voltage_amplifier VDD VSS VIN VOUT params: gain=1
ECORE VOUT 0 VIN 0 {gain}
.ends voltage_amplifier

.subckt dut VSS Vin Vout
If Vout Vin DC 1m
Iia VSS net0 DC 1m
RF Vin Vout 1k
Via net0 Vin DC 1
X1 0 VSS net0 Vout voltage_amplifier gain={a}
.ends dut
