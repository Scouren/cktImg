* official Analog Canvas netlist; PDK X cards rewritten by convert.py
.model qnpn npn

.subckt dut VCC VEE V7
Q1 V7 net1 net0 VEE qnpn m=1
R1 VCC V7 9.1kΩ
R2 net1 V7 10kΩ
R3 net0 VEE 3kΩ
.ends dut
