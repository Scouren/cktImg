* official Analog Canvas netlist; PDK X cards rewritten by convert.py
.model qnpn npn

.subckt dut VCC VEE VSS vIN vOUT
I1 net1 VEE DC 1m
Q1 net0 vIN net1 VEE qnpn m=1
Q2 vOUT VSS net1 VEE qnpn m=1
R1 VCC net0 1k
R2 VCC vOUT 1k
RL vOUT VSS 1k
.ends dut
