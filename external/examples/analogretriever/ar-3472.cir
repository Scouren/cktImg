* official Analog Canvas netlist; PDK X cards rewritten by convert.py
.model nch nmos
.model qnpn npn

.subckt dut VDD VSS GND vO1 vO2 VREF
M1 vO1 net0 net1 VSS nch l=0.15 w=1 nf=1 m=1
M2 vO2 net2 net1 VSS nch l=0.15 w=1 nf=1 m=1
QB net1 VREF VSS VSS qnpn m=1
R1 VDD vO1 1k
R2 VDD vO2 1k
V1 net0 GND DC 1
V2 net2 GND DC 1
.ends dut
