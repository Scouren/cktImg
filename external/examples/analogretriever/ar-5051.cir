* official Analog Canvas netlist; PDK X cards rewritten by convert.py
.model qnpn npn

.subckt dut VCC VEE VSS vout- vout+
Q1 vout- net2 net0 VEE qnpn m=1
Q2 vout+ net3 net0 VEE qnpn m=1
RB1 net1 net2 10kΩ
RB2 net3 VSS 10kΩ
RC1 VCC vout- 1MegΩ
RC2 VCC vout+ 1MegΩ
RE net0 VEE 1MegΩ
V1 net1 VSS DC 1 SIN(0 10mV 1k 0 0 0)
.ends dut
