* official Analog Canvas netlist; PDK X cards rewritten by convert.py
.model qnpn npn

.subckt dut VCC VSS vout
C1 VSS net2 1p
Q1 vout net1 net3 VSS qnpn m=1
R1 net1 net2 1k
R2 net2 vout 1k
RC VCC vout 1k
RE net3 VSS 1k
RS net0 net1 1k
Vin net0 VSS DC 1
.ends dut
