* official Analog Canvas netlist; PDK X cards rewritten by convert.py
.model nch nmos

.subckt dut VSS vin vout
M1 X net0 VSS VSS nch l=0.15 w=1 nf=1 m=1
M2 vout X VSS VSS nch l=0.15 w=1 nf=1 m=1
RD1 VSS X 1kΩ
RD2 VSS vout 1kΩ
RF X vout 10kΩ
RS vin net0 200Ω
.ends dut
