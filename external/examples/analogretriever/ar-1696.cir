* official Analog Canvas netlist; PDK X cards rewritten by convert.py
.model qnpn npn

.subckt dut VCC VSS Vin Vb1 Vout
C1 X VSS 1p
C2 Y VSS 1p
C3 Vout VSS 1p
Q1 Y X VSS VSS qnpn m=1
Q2 Vout Vb1 Y VSS qnpn m=1
RL VCC Vout 1k
RS Vin X 1k
.ends dut
