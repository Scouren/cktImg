* official Analog Canvas netlist; PDK X cards rewritten by convert.py
.model qnpn npn

.subckt dut VCC VSS Vin Vout
C1 net0 VSS 1p
I1 net0 VSS DC 1m
Q1 Vout Vin net1 VSS qnpn m=1
RC VCC Vout 1k
RE net1 net0 1k
.ends dut
