* official Analog Canvas netlist; PDK X cards rewritten by convert.py
.model qnpn npn

.subckt dut VCC VSS Vb Vout Vin
Ci net1 net0 1p
I1 net0 VSS DC 1m
Q1 Vout Vb net0 VSS qnpn m=1
RC VCC Vout 1k
RS Vin net1 1k
.ends dut
