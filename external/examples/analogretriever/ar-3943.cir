* official Analog Canvas netlist; PDK X cards rewritten by convert.py
.model qnpn npn

.subckt dut VCC VSS vO
CC net1 net0 1p
Q1 vO net0 net3 VSS qnpn m=1
R1 VCC net0 56kΩ
R2 net0 VSS 12.2kΩ
RC VCC vO 2kΩ
RE net3 VSS 0.4kΩ
RS net2 net1 0.5kΩ
Vs net2 VSS DC 1
.ends dut
