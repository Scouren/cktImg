* official Analog Canvas netlist; PDK X cards rewritten by convert.py
.model qnpn npn
.model qpnp pnp

.subckt dut VCC VEE VSS vI vO
.model DIODE D(IS=1e-14 N=1)
D1 net0 net1 DIODE
D2 net1 net2 DIODE
IBIAS VCC net0 DC 1m
Q3 net2 vI VEE VSS qnpn m=1
QN VCC net0 vO VSS qnpn m=1
QP VEE net2 vO qpnp m=1
RL vO VSS 1k
.ends dut
