* official Analog Canvas netlist; PDK X cards rewritten by convert.py

.subckt dut VDD VSS
.model DIODE D(IS=1e-14 N=1)
D1 net1 net0 DIODE
R1 VDD net0 3kΩ
R2 VDD net1 2kΩ
R3 net0 VSS 2kΩ
R4 net1 VSS 2kΩ
.ends dut
