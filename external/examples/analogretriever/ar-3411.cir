* official Analog Canvas netlist; PDK X cards rewritten by convert.py
.model qnpn npn

.subckt dut VCC VSS vIN vOUT
CE net1 VSS 1p
CI vIN net4 1p
CO net2 vOUT 1p
Q net2 net4 net3 VSS qnpn m=1
RB1 VCC net4 1k
RB2 net4 VSS 1k
RC VCC net2 1k
RE1 net3 net1 1k
RE2 net1 VSS 1k
RL vOUT VSS 1k
RT net0 vIN 1k
VT net0 VSS DC 1
.ends dut
