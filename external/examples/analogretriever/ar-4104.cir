* official Analog Canvas netlist; PDK X cards rewritten by convert.py
.model nch nmos

.subckt dut VSS Vi Vo
VB1 net3 VSS DC 1
VB2 net2 VSS DC 1
CC net1 Vo 1p
Ci net0 VSS 1p
M1 net1 net3 net0 VSS nch l=0.15 w=1 nf=1 m=1
RD net1 net2 1k
RL Vo VSS 1k
RS Vi net0 1k
.ends dut
