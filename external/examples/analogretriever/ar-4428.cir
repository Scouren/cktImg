* official Analog Canvas netlist; PDK X cards rewritten by convert.py
.model nch nmos

.subckt dut VDD VSS GND vo
I1 net2 VSS DC 1mA
I2 vo VSS DC 2mA
M1 VDD net4 net2 GND nch l=0.15 w=1 nf=1 m=1
M2 net1 net3 net2 GND nch l=0.15 w=1 nf=1 m=1
M3 VDD net1 vo GND nch l=0.15 w=1 nf=1 m=1
R1 net3 GND 10kΩ
R2 net3 vo 40kΩ
RD VDD net1 1k
RL vo GND 4kΩ
RS net0 net4 1kΩ
vi net0 GND DC 1
.ends dut
