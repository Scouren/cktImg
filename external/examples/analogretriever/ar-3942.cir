* official Analog Canvas netlist; PDK X cards rewritten by convert.py
.model qnpn npn

.subckt dut VCC VSS Vin vO
CC Vin net0 1p
Q1 vO net0 VSS VSS qnpn m=1
R1 VCC net0 1k
R2 net0 VSS 1k
RC VCC vO 1k
RS net1 Vin 1k
Vs net1 VSS DC 1
.ends dut
