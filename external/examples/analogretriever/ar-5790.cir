* official Analog Canvas netlist; PDK X cards rewritten by convert.py
.model qpnp pnp

.subckt dut VCC VEE VSS
Q2 net1 net0 net2 qpnp m=1
R1 VCC net2 1kΩ
R2 net0 VEE 10kΩ
R3 net1 VSS 1kΩ
.ends dut
