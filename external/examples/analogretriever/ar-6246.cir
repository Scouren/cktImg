* official Analog Canvas netlist; PDK X cards rewritten by convert.py
.model qnpn npn
.model qpnp pnp

.subckt dut VCC VEE VSS Vin+ Vin- Y Q5_E Q6_E Out
CC VZ net15 30pF
Q1 net13 Vin+ net1 VSS qnpn m=1
Q10 Y net4 net7 VSS qnpn m=1
Q11 net4 net4 VEE VSS qnpn m=1
Q12 net5 net5 VCC qpnp m=1
Q13A net3 net5 VCC qpnp m=1
Q13B net15 net5 VCC qpnp m=1
Q14 VCC net3 net14 VSS qnpn m=1
Q15 net3 net14 Out VSS qnpn m=1
Q16 VCC VZ net10 VSS qnpn m=1
Q17 net15 net10 net8 VSS qnpn m=1
Q18 net3 net9 net0 VSS qnpn m=1
Q19 net3 net3 net9 VSS qnpn m=1
Q2 net13 Vin- net16 VSS qnpn m=1
Q20 VEE net0 net12 qpnp m=1
Q21 net2 net12 Out qpnp m=1
Q22 VZ net2 VEE VEE qnpn m=1
Q23 VEE net15 net0 qpnp m=1
Q24 net2 net2 VEE VSS qnpn m=1
Q3 net11 Y net1 qpnp m=1
Q4 VZ Y net16 qpnp m=1
Q5 net11 net6 Q5_E VSS qnpn m=1
Q6 VZ net6 Q6_E VSS qnpn m=1
Q7 VCC net11 net6 VSS qnpn m=1
Q8 net13 net13 VCC qpnp m=1
Q9 Y net13 VCC qpnp m=1
R1 Q5_E VEE 1kΩ
R10 net9 net0 40kΩ
R11 net2 VEE 50kΩ
R2 Q6_E VEE 1kΩ
R3 net6 VEE 50kΩ
R4 net7 VEE 5kΩ
R5 net5 net4 39kΩ
R6 net14 Out 27Ω
R7 Out net12 27Ω
R8 net8 VEE 100Ω
R9 net10 VEE 50kΩ
.ends dut
