* official Analog Canvas netlist; PDK X cards rewritten by convert.py
.model nch nmos
.model pch pmos

.subckt dut VDD VSS vo
M1 VDD net1 net3 VSS nch l=0.15 w=1 nf=1 m=1
M2 vo net3 VSS VSS nch l=2 w=100 nf=1 m=1
M3 vo net0 VDD VDD pch l=2 w=100 nf=1 m=1
M4 net0 net0 VDD VDD pch l=2 w=100 nf=1 m=1
M5 net2 net2 net0 net0 pch l=0.15 w=1 nf=1 m=1
M6 net2 net2 VSS VSS nch l=2 w=100 nf=1 m=1
M7 net3 net2 VSS VSS nch l=2 w=100 nf=1 m=1
Vi net1 VSS DC 1
.ends dut
