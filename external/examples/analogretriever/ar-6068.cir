* official Analog Canvas netlist; PDK X cards rewritten by convert.py
.model qnpn npn
.model qpnp pnp

.subckt dut VCC VEE VBIAS vd+ vd- vo
I1 net1 VEE DC 1m
Q1 net3 vd+ net1 VEE qnpn m=1
Q2 net2 vd- net1 VEE qnpn m=1
Q3 net4 VBIAS net3 VEE qnpn m=1
Q4 vo VBIAS net2 VEE qnpn m=1
Q5 net4 net0 VCC qpnp m=1
Q6 net0 net0 VCC qpnp m=1
Q7 vo net4 net0 qpnp m=1
.ends dut
