* official Analog Canvas netlist; PDK X cards rewritten by convert.py
.model qnpn npn

.subckt dut VCC VSS vIN vOUT
CB net3 VSS 1p
CC net0 net4 1p
CE net5 VSS 1p
CI net2 vIN 1p
CO vOUT net6 1p
Q1 net4 net2 net5 VSS qnpn m=1
Q2 net6 net3 net0 VSS qnpn m=1
RB11 VCC net2 1k
RB12 VCC net3 1k
RB21 net2 VSS 1k
RB22 net3 VSS 1k
RC1 VCC net4 1k
RC2 VCC net6 1k
RE1 net5 VSS 1k
RE2 net0 VSS 1k
RL vOUT VSS 1k
RT vIN net1 1k
VT net1 VSS DC 1
.ends dut
