* official Analog Canvas netlist; PDK X cards rewritten by convert.py
.model nch nmos
.model pch pmos

.subckt dut VDD VSS phi A Y2
CL1 Y1 VSS 1p
CL2 Y2 VSS 1p
M1 Y1 A net0 VSS nch l=0.15 w=1 nf=1 m=1
M2 Y2 Y1 net1 VSS nch l=0.15 w=1 nf=1 m=1
Me1 net0 phi VSS VSS nch l=0.15 w=1 nf=1 m=1
Me2 net1 phi VSS VSS nch l=0.15 w=1 nf=1 m=1
Mp1 Y1 phi VDD VDD pch l=0.15 w=1 nf=1 m=1
Mp2 Y2 phi VDD VDD pch l=0.15 w=1 nf=1 m=1
.ends dut
