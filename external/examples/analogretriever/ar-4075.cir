* official Analog Canvas netlist; PDK X cards rewritten by convert.py

.subckt dut VSS
Cpi Ve VSS 1p
R1 Ve VSS 1k
RE Ve VSS 1k
RS net0 Ve 1k
Vi net0 VSS DC 1
.ends dut
