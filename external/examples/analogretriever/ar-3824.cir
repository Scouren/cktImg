* official Analog Canvas netlist; PDK X cards rewritten by convert.py
.model nch nmos
.model pch pmos

.subckt dut VDD VSS GND Vo
CC net0 net1 1p
IQ net1 VSS DC 1mA
MD Vo GND net1 GND nch l=0.15 w=1 nf=1 m=1
ML Vo Vo VDD VDD pch l=0.15 w=1 nf=1 m=1
Vi net0 GND DC 1
.ends dut
