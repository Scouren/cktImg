* official Analog Canvas netlist; PDK X cards rewritten by convert.py

.subckt dut A B
R1 A net1 1k
R2 net1 net3 1k
R3 net3 net2 1k
R4 net0 net2 1k
R5 B net0 1k
.ends dut
