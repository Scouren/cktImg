* official Analog Canvas netlist; PDK X cards rewritten by convert.py
.model nch nmos

.subckt dut VDD VSS GND vIN vOUT
CO net1 vOUT 1p
M1 VDD vIN net1 GND nch l=0.15 w=1 nf=1 m=1
RL vOUT GND 1k
RS net1 VSS 1k
RT net0 vIN 1k
VT net0 GND DC 1
.ends dut
