* official Analog Canvas netlist; PDK X cards rewritten by convert.py
.model nch nmos
.model pch pmos

.subckt dut VDD VSS C A B Y
MNA net1 A VSS VSS nch l=0.15 w=1 nf=1 m=1
MNB net1 B VSS VSS nch l=0.15 w=1 nf=1 m=1
MNC Y C net1 VSS nch l=0.15 w=1 nf=1 m=1
MPA net0 A VDD VDD pch l=0.15 w=1 nf=1 m=1
MPB Y B net0 VDD pch l=0.15 w=1 nf=1 m=1
MPC Y C VDD VDD pch l=0.15 w=1 nf=1 m=1
.ends dut
