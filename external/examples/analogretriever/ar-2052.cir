* official Analog Canvas netlist; PDK X cards rewritten by convert.py
.model nch nmos
.model pch pmos

.subckt dut VDD VSS A B Vout
M1 Vout A VSS VSS nch l=0.15 w=1 nf=1 m=1
M2 Vout B VSS VSS nch l=0.15 w=1 nf=1 m=1
M3 Vout A VDD VDD pch l=0.15 w=1 nf=1 m=1
M4 Vout B VDD VDD pch l=0.15 w=1 nf=1 m=1
.ends dut
