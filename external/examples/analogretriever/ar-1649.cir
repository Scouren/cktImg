* official Analog Canvas netlist; PDK X cards rewritten by convert.py
.model qnpn npn

.subckt dut VCC VSS Vb Vin Vout
CCS1 net0 VSS 1p
CCS2 Vout VSS 1p
Cmu1 net0 Vin 1p
Cmu2 Vout Vb 1p
Cpi1 Vin VSS 1p
Cpi2 Vb net0 1p
Q1 net0 Vin VSS VSS qnpn m=1
Q2 Vout Vb net0 VSS qnpn m=1
RC VCC Vout 1k
.ends dut
