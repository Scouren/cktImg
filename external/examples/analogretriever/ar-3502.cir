* official Analog Canvas netlist; PDK X cards rewritten by convert.py
.model qnpn npn

.subckt dut VCC VEE VSS vIN vOUT
CE1 net1 VEE 1p
CE2 net2 VEE 1p
Q1 net3 vIN net1 VEE qnpn m=1
Q2 vOUT net3 net2 VEE qnpn m=1
RB1 VCC vIN 1k
RB2 vIN VEE 1k
RC1 VCC net3 1k
RC2 VCC vOUT 1k
RE1 net1 VEE 1k
RE2 net2 VEE 1k
RL vOUT VSS 1k
RT vIN net0 1k
VT net0 VSS DC 1
.ends dut
