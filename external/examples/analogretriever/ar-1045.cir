* official Analog Canvas netlist; PDK X cards rewritten by convert.py
.model qnpn npn

.subckt dut VCC VSS Vin Vout
C1 net1 net0 1p
C2 net2 VSS 1p
Q1 Vout net0 net3 VSS qnpn m=1
R1 Vin net1 1kΩ
R2 VCC net0 14kΩ
R3 net0 VSS 11kΩ
R4 net3 net2 500Ω
R5 net2 VSS 2kΩ
RC VCC Vout 10kΩ
.ends dut
