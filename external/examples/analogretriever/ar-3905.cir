* official Analog Canvas netlist; PDK X cards rewritten by convert.py
.model qpnp pnp

.subckt dut VCC VSS
Q1 VSS VB net0 qpnp m=1
R1 VCC VB 20kΩ
R2 VB VSS 15kΩ
RE VCC net0 1kΩ
.ends dut
