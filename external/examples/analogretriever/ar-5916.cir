* official Analog Canvas netlist; PDK X cards rewritten by convert.py

.subckt dut VSS
G1 D VSS VSS S 1m
R1 VSS S 1k
RL D VSS 1k
ro D S 1k
Vx S VSS DC 1
.ends dut
