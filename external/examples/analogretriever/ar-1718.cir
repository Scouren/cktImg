* official Analog Canvas netlist; PDK X cards rewritten by convert.py
.model qnpn npn

.subckt dut VCC VSS Vin Vout
CL Vout VSS 1p
Q1 Vout Vin VSS VSS qnpn m=1
Q2 VCC net0 Vout VSS qnpn m=1
RB VCC net0 1k
.ends dut
