* official Analog Canvas netlist; PDK X cards rewritten by convert.py
.model nch nmos

.subckt dut VSS Vin Vout
Cin net0 VSS 1p
Cout Vout VSS 1p
CXY net0 Vout 1p
M1 Vout net0 VSS VSS nch l=0.15 w=1 nf=1 m=1
R1 Vout VSS 1k
RS Vin net0 1k
.ends dut
