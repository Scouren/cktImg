* official Analog Canvas netlist; PDK X cards rewritten by convert.py
.model nch nmos
.model pch pmos

.subckt dut VDD VSS A B C Vout
M1 Vout A VSS VSS nch l=0.15 w=1 nf=1 m=1
M2 Vout B VSS VSS nch l=0.15 w=1 nf=1 m=1
M3 Vout C VSS VSS nch l=0.15 w=1 nf=1 m=1
M4 Vout C net1 VDD pch l=0.15 w=1 nf=1 m=1
M5 net1 B net0 VDD pch l=0.15 w=1 nf=1 m=1
M6 net0 A VDD VDD pch l=0.15 w=1 nf=1 m=1
.ends dut
