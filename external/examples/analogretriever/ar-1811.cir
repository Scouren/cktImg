* official Analog Canvas netlist; PDK X cards rewritten by convert.py
.model nch nmos
.model pch pmos

.subckt dut VDD VSS Vin VF1 VF2
ISS net0 VSS DC 1m
M1 net2 X VDD VDD pch l=0.15 w=1 nf=1 m=1
M3 X Vin net0 VSS nch l=0.15 w=1 nf=1 m=1
M4 net1 VF1 net0 VSS nch l=0.15 w=1 nf=1 m=1
M5 X net1 VDD VDD pch l=0.15 w=1 nf=1 m=1
M6 net1 net1 VDD VDD pch l=0.15 w=1 nf=1 m=1
RL net2 VF2 1k
RM1 VF1 VSS 1k
RM2 VF2 VSS 1k
RO1 net2 VSS 1k
.ends dut
