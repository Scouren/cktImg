* official Analog Canvas netlist; PDK X cards rewritten by convert.py
.model qnpn npn
.model qpnp pnp

.subckt dut VSS Vout
Q1 VSS net1 Vout VSS qnpn m=1
Q2 VSS net0 Vout qpnp m=1
R1 VSS net1 1k
R2 net1 net0 1k
R3 net0 VSS 1k
.ends dut
