* official Analog Canvas netlist; PDK X cards rewritten by convert.py
.model qnpn npn

.subckt dut VCC VEE
IBias VCC net1 DC 1m
IBias2 net0 VEE DC 1m
Q net1 net2 net0 VEE qnpn m=1
R1 net1 net2 1k
R2 net2 net0 1k
.ends dut
