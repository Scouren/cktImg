* official Analog Canvas netlist; PDK X cards rewritten by convert.py
.model nch nmos

.subckt dut VDD VSS I0 In
IBIAS1 VDD VB1 DC 1m
IBIAS2 VDD VB2 DC 1m
M1 VB1 VB1 VSS VSS nch l=0.15 w=1 nf=1 m=1
M2 VB2 VB1 net0 VSS nch l=0.15 w=1 nf=1 m=1
M3 net0 VB2 VSS VSS nch l=0.15 w=1 nf=1 m=1
M4 I0 VB1 net2 VSS nch l=0.15 w=1 nf=1 m=1
M5 net2 VB2 VSS VSS nch l=0.15 w=1 nf=1 m=1
M6 In VB1 net1 VSS nch l=0.15 w=1 nf=1 m=1
M7 net1 VB2 VSS VSS nch l=0.15 w=1 nf=1 m=1
.ends dut
