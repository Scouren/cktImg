* official Analog Canvas netlist; PDK X cards rewritten by convert.py
.model nch nmos
.model pch pmos

.subckt dut VDD VSS v1 v2 vo
IQ net2 VSS DC 1m
M1 net0 v1 net2 VSS nch l=0.15 w=1 nf=1 m=1
M2 vo v2 net2 VSS nch l=0.15 w=1 nf=1 m=1
M3 net0 net0 net1 VDD pch l=0.15 w=1 nf=1 m=1
M4 vo net0 net3 VDD pch l=0.15 w=1 nf=1 m=1
M5 net1 net1 VDD VDD pch l=0.15 w=1 nf=1 m=1
M6 net3 net1 VDD VDD pch l=0.15 w=1 nf=1 m=1
.ends dut
