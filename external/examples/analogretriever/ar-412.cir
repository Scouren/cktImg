* official Analog Canvas netlist; PDK X cards rewritten by convert.py

.subckt dut VSS vo
E1 net0 VSS VSS net2 1
R1 net1 net2 10kΩ
R2 net2 vo 100kΩ
Ri net2 VSS 1k
Ro net0 vo 1k
vi net1 VSS DC 1
.ends dut
