* official Analog Canvas netlist; PDK X cards rewritten by convert.py
.model nch nmos
.model pch pmos

.subckt dut VDD VSS vi+ vi- vo
CC Vo1 vo 1p
IBIAS net1 VSS DC 1m
IC net7 VSS DC 1m
M1 net2 vi+ net8 VDD pch l=0.15 w=1 nf=1 m=1
M10 VDD Vo1 net0 VSS nch l=0.15 w=1 nf=1 m=1
M11 net0 net4 VSS VSS nch l=0.15 w=1 nf=1 m=1
M1A net5 net7 net2 VDD pch l=0.15 w=1 nf=1 m=1
M2 net6 vi- net8 VDD pch l=0.15 w=1 nf=1 m=1
M2A Vo1 net7 net6 VDD pch l=0.15 w=1 nf=1 m=1
M3 net4 net4 VSS VSS nch l=0.15 w=1 nf=1 m=1
M3A net5 net5 net4 VSS nch l=0.15 w=1 nf=1 m=1
M4 net3 net4 VSS VSS nch l=0.15 w=1 nf=1 m=1
M4A Vo1 net5 net3 VSS nch l=0.15 w=1 nf=1 m=1
M5 net8 net1 VDD VDD pch l=0.15 w=1 nf=1 m=1
M6 vo net0 VSS VSS nch l=0.15 w=1 nf=1 m=1
M7 vo net1 VDD VDD pch l=0.15 w=1 nf=1 m=1
M8 net1 net1 VDD VDD pch l=0.15 w=1 nf=1 m=1
M9 net7 net7 net8 VDD pch l=0.15 w=1 nf=1 m=1
.ends dut
