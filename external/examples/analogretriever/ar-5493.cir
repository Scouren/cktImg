* official Analog Canvas netlist; PDK X cards rewritten by convert.py
.model qnpn npn

.subckt dut VCC VSS Vout
C1 net1 net2 1p
C2 net3 net0 1p
C3 net4 VSS 1p
C4 Vout net3 1p
C5 net3 net2 1p
L1 net2 VSS 1n
L2 VSS net3 1n
Q1 net0 net1 net4 VSS qnpn m=1
R1 VCC net1 1k
R2 net1 VSS 1k
R3 VCC net0 1k
R4 net4 VSS 1k
.ends dut
