* official Analog Canvas netlist; PDK X cards rewritten by convert.py
.model qnpn npn

.subckt dut VCC VSS vO
CC1 net2 net1 0.1uF
CE net0 VSS 1p
Q1 vO net1 net0 VSS qnpn m=1
R1 VCC net1 60kΩ
R2 net1 VSS 5.5kΩ
RC VCC vO 4kΩ
RE net0 VSS 0.2kΩ
RS net3 net2 2kΩ
vi net3 VSS DC 1
.ends dut
