* official Analog Canvas netlist; PDK X cards rewritten by convert.py
.model qnpn npn

.subckt dut VCC VEE VSS vO
CE net1 VSS 1p
Q1 vO net0 net1 VEE qnpn m=1
RC VCC vO 1k
RE net1 VEE 1k
RS net2 net0 1k
vi net2 VSS DC 1
.ends dut
