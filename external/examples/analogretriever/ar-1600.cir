* official Analog Canvas netlist; PDK X cards rewritten by convert.py
.model nch nmos
.model pch pmos

.subckt dut VDD VSS Vin1 Vin2 Vout1 Vout2 Vb
I1 net0 VSS DC 1m
I2 net1 VSS DC 1m
M1 Vout1 Vin1 net0 VSS nch l=0.15 w=1 nf=1 m=1
M2 Vout2 Vin2 net1 VSS nch l=0.15 w=1 nf=1 m=1
M3 Vout1 Vb VDD VDD pch l=0.15 w=1 nf=1 m=1
M4 Vout2 Vb VDD VDD pch l=0.15 w=1 nf=1 m=1
RSS net0 net1 1k
.ends dut
