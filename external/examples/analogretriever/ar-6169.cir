* official Analog Canvas netlist; PDK X cards rewritten by convert.py
.model qnpn npn

.subckt dut VCC VSS Vs Vo Y
Q1 net0 Vs net2 VSS qnpn m=1
Q2 net1 net0 VSS VSS qnpn m=1
Q3 Vo net1 Y VSS qnpn m=1
RC1 VCC net0 9kΩ
RC2 VCC net1 5kΩ
RC3 VCC Vo 600Ω
RE1 net2 VSS 100Ω
RE2 Y VSS 100Ω
RF net2 Y 640Ω
.ends dut
