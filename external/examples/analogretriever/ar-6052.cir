* official Analog Canvas netlist; PDK X cards rewritten by convert.py
.model nch nmos

.subckt dut VDD VSS vG1 vG2 Vout1 Vout2 VC
I1 net1 VSS DC 1m
I2 net0 VSS DC 1m
M1 Vout1 vG1 net1 VSS nch l=0.15 w=1 nf=1 m=1
M2 Vout2 vG2 net0 VSS nch l=0.15 w=1 nf=1 m=1
M3 net1 VC net0 VSS nch l=0.15 w=1 nf=1 m=1
RD1 VDD Vout1 1k
RD2 VDD Vout2 1k
.ends dut
