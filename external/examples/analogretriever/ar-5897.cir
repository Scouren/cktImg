* official Analog Canvas netlist; PDK X cards rewritten by convert.py
.model qnpn npn

.subckt dut VCC VEE VSS Vin vo
C1 Vin net2 1p
C2 net0 vo 1p
I1 net1 VEE DC 50uA
I2 net0 VEE DC 5mA
Q1 VCC net2 net1 VEE qnpn m=1
Q2 VCC net1 net0 VEE qnpn m=1
R1 VCC net2 1MegΩ
R2 net2 VSS 1MegΩ
.ends dut
