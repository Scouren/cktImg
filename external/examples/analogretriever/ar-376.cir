* official Analog Canvas netlist; PDK X cards rewritten by convert.py

.subckt dut VSS
G1 net1 net2 net0 net2 1m
Rb net3 net0 1k
RE net2 VSS 1k
RL net1 VSS 1k
Rpi net0 net2 1k
Vs net3 VSS DC 1
.ends dut
