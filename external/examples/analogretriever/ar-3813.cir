* official Analog Canvas netlist; PDK X cards rewritten by convert.py
.model nch nmos

.subckt dut VDD VSS GND vo
CC1 net1 net0 1p
CC2 net2 vo 1p
M1 net2 GND net0 GND nch l=0.15 w=1 nf=1 m=1
RD net2 VDD 5kΩ
RL vo GND 4kΩ
RS net0 VSS 10kΩ
Vi net1 GND DC 1
.ends dut
