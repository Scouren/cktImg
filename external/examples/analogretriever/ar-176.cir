* official Analog Canvas netlist; PDK X cards rewritten by convert.py
.model qnpn npn
.model qpnp pnp

.subckt dut VEE VCC VSS Vi Vo
I1 net1 VEE DC 100uA
Q1 net0 Vi net1 VEE qnpn m=1
Q2 Vo VSS net1 VEE qnpn m=1
Q3 net0 net0 VCC qpnp m=1
Q4 Vo net0 VCC qpnp m=1
.ends dut
