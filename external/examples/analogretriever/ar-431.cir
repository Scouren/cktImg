* official Analog Canvas netlist; PDK X cards rewritten by convert.py
.model nch nmos
.model pch pmos

.subckt dut VDD VSS vid vod
CL vod VSS 1p
Cp net0 VSS 1p
M1 net0 vid VSS VSS nch l=0.15 w=1 nf=1 m=1
M1A vod VSS net0 VDD pch l=0.15 w=1 nf=1 m=1
.ends dut
