* official Analog Canvas netlist; PDK X cards rewritten by convert.py

.subckt dut VSS
.model DIODE D(IS=1e-14 N=1)
D1 net1 net0 DIODE
D2 net0 VSS DIODE
IX VSS net1 DC 1mA
R1 net1 VSS 1k
.ends dut
