* official Analog Canvas netlist; PDK X cards rewritten by convert.py
.model qnpn npn
.model qpnp pnp

.subckt dut VCC VEE VSS Vin Vout
I1 net0 VEE DC 1m
Q1 VCC net0 Vout VEE qnpn m=1
Q2 VEE Vin Vout qpnp m=1
Q3 VCC Vin net0 VEE qnpn m=1
RL Vout VSS 1k
.ends dut
