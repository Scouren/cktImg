* official Analog Canvas netlist; PDK X cards rewritten by convert.py
.model qnpn npn

.subckt dut VCC VSS Icopy
IREF VCC net0 DC 1m
Q1 Icopy net0 VSS VSS qnpn m=1
Q2 Icopy net0 VSS VSS qnpn m=1
Q3 Icopy net0 VSS VSS qnpn m=1
QREF net0 net0 VSS VSS qnpn m=1
.ends dut
