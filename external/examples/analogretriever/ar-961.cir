* official Analog Canvas netlist; PDK X cards rewritten by convert.py
.model qnpn npn

.subckt dut VCC VSS vout
C1 net2 net3 1p
C2 net1 VSS 1p
I1 net4 VSS DC 1m
Q1 vout net3 net4 VSS qnpn m=1
R1 net3 net1 1k
R2 net1 net4 1k
RC VCC vout 1k
RS net0 net2 1k
Vin net0 VSS DC 1
.ends dut
