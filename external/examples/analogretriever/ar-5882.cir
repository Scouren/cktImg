* official Analog Canvas netlist; PDK X cards rewritten by convert.py
.model nch nmos

.subckt dut VDD VSS GND X Y Z
C1 X net2 1p
C2 net0 Y 1p
C3 net1 Z 1p
M1 net0 net2 net1 GND nch l=0.15 w=1 nf=1 m=1
RD VDD net0 1k
RG net2 GND 1k
RS net1 VSS 1k
.ends dut
