* official Analog Canvas netlist; PDK X cards rewritten by convert.py
.model nch nmos
.model pch pmos

.subckt dut VDD VSS v1 v2 vo
IQ VDD net0 DC 1m
M1 net1 v1 net0 VDD pch l=0.15 w=1 nf=1 m=1
M2 vo1 v2 net0 VDD pch l=0.15 w=1 nf=1 m=1
M3 vo2 vo1 VSS VSS nch l=0.15 w=1 nf=1 m=1
M4 VSS vo2 vo VDD pch l=0.15 w=1 nf=1 m=1
RD1 net1 VSS 1k
RD1B vo1 VSS 1k
RD3 VDD vo2 1k
RS VDD vo 1k
.ends dut
