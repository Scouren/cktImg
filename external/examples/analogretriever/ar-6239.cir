* official Analog Canvas netlist; PDK X cards rewritten by convert.py
.model nch nmos
.model pch pmos

.subckt dut VDD VSS Vb1
M10 Vb1 net1 net0 VSS nch l=0.15 w=1 nf=1 m=1
M11 net1 net1 net2 VSS nch l=0.15 w=1 nf=1 m=1
M12 net0 net2 net3 VSS nch l=0.15 w=1 nf=1 m=1
M13 net2 net2 VSS VSS nch l=0.15 w=1 nf=1 m=1
M8 Vb1 Vb1 VDD VDD pch l=0.15 w=1 nf=1 m=1
M9 net1 Vb1 VDD VDD pch l=0.15 w=1 nf=1 m=1
RB net3 VSS 1k
.ends dut
