* official Analog Canvas netlist; PDK X cards rewritten by convert.py
.model qnpn npn

.subckt dut VSS vo
Isig VSS net0 DC 1m
Q1 vo VSS net0 VSS qnpn m=1
RC vo VSS 1k
Rsig net0 VSS 1k
.ends dut
