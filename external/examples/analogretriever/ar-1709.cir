* official Analog Canvas netlist; PDK X cards rewritten by convert.py

.subckt dut VSS VY
C2 net0 VY 1p
I1 net0 VSS DC 1m
RC net0 VSS 1k
Rin2 VY VSS 1k
.ends dut
