* official Analog Canvas netlist; PDK X cards rewritten by convert.py

.subckt dut VSS vo
G1 VSS vo net1 vo 1m
RL vo VSS 1k
Rpi net1 vo 1k
RS net1 net0 1k
vi net0 VSS DC 1
.ends dut
