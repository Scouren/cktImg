* official Analog Canvas netlist; PDK X cards rewritten by convert.py
.model nch nmos
.model pch pmos

.subckt dut VDD VSS
ISS net0 VSS DC 1m
M1 X VSS net0 VSS nch l=0.15 w=1 nf=1 m=1
M2 VSS VSS net0 VSS nch l=0.15 w=1 nf=1 m=1
M3 X X VDD VDD pch l=0.15 w=1 nf=1 m=1
M4 VSS X VDD VDD pch l=0.15 w=1 nf=1 m=1
.ends dut
