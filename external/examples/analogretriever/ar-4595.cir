* official Analog Canvas netlist; PDK X cards rewritten by convert.py
.model qnpn npn

.subckt dut VCC VSS vI VR vO1 vO2
Q1 net2 vI net0 VSS qnpn m=1
Q2 VCC net2 vO1 VSS qnpn m=1
Q3 VCC net1 vO2 VSS qnpn m=1
QR net1 VR net0 VSS qnpn m=1
R2 vO1 VSS 1k
R3 vO2 VSS 1k
RC1 VCC net2 1k
RC2 VCC net1 1k
RE net0 VSS 1k
.ends dut
