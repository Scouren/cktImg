* official Analog Canvas netlist; PDK X cards rewritten by convert.py

.subckt dut VDD VSS V1 Vout
I1 Vout VSS DC 1m
RD VDD Vout 1k
RF V1 Vout 1k
RS net0 V1 1k
Vin net0 VSS DC 1
.ends dut
