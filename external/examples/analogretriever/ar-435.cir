* official Analog Canvas netlist; PDK X cards rewritten by convert.py

.subckt dut VSS vo v1
C1 v2 VSS 1p
C2 vo VSS 1p
Cm v2 vo 1p
G1 VSS v2 v1 VSS 1m
G2 vo VSS v2 VSS 1m
Gf vo VSS v1 VSS 1m
R1 v2 VSS 1k
R2 vo VSS 1k
.ends dut
