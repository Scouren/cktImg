* official Analog Canvas netlist; PDK X cards rewritten by convert.py
.model qnpn npn

.subckt dut VCC VSS vout
C1 net3 net4 1p
C2 net0 vout 1p
Q1 VCC net4 net1 VSS qnpn m=1
Q2 VCC net1 net0 VSS qnpn m=1
R1 VCC net4 1k
R2 net4 VSS 1k
RE net0 VSS 1k
RG net2 net3 1k
Vg net2 VSS DC 1 SIN(0 1 1k 0 0 0)
.ends dut
