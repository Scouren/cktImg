* official Analog Canvas netlist; PDK X cards rewritten by convert.py
.model nch nmos
.model pch pmos

.subckt dut VSS vo
IQ net0 VSS DC 100uA
M1 vo VSS net2 VSS nch l=0.15 w=1 nf=1 m=1
M2 vo net0 VSS VSS pch l=0.15 w=1 nf=1 m=1
M3 net0 net0 VSS VSS pch l=0.15 w=1 nf=1 m=1
R1 net1 net2 50Ω
vi net1 VSS DC 1
.ends dut
