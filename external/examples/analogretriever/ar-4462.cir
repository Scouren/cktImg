* official Analog Canvas netlist; PDK X cards rewritten by convert.py
.model nch nmos
.model pch pmos

.subckt dut VDD VSS GND vo VB2
IREF net6 VBN DC 1m
M1 net0 v1 net3 VDD pch l=0.15 w=1 nf=1 m=1
M10 net2 net2 VDD VDD pch l=0.15 w=1 nf=1 m=1
M11 net3 net6 VDD VDD pch l=0.15 w=1 nf=1 m=1
M12 net6 net6 VDD VDD pch l=0.15 w=1 nf=1 m=1
M13 VBN VBN VSS VSS nch l=0.15 w=1 nf=1 m=1
M2 net4 v2 net3 VDD pch l=0.15 w=1 nf=1 m=1
M3 net4 VBN VSS VSS nch l=0.15 w=1 nf=1 m=1
M4 net0 VBN VSS VSS nch l=0.15 w=1 nf=1 m=1
M5 net1 VB2 net4 VSS nch l=0.15 w=1 nf=1 m=1
M6 vo VB2 net0 VSS nch l=0.15 w=1 nf=1 m=1
M7 net1 net1 net5 VDD pch l=0.15 w=1 nf=1 m=1
M8 vo net1 net2 VDD pch l=0.15 w=1 nf=1 m=1
M9 net5 net2 VDD VDD pch l=0.15 w=1 nf=1 m=1
V1 GND v1 DC 1
V2 v2 GND DC 1
.ends dut
