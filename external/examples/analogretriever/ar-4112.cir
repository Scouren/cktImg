* official Analog Canvas netlist; PDK X cards rewritten by convert.py
.model nch nmos

.subckt dut VSS Vi Vo
CL1 Vo1 VSS 1p
CL2 Vo VSS 1p
M1 Vo1 Vi VSS VSS nch l=0.15 w=1 nf=1 m=1
M2 Vo Vo1 VSS VSS nch l=0.15 w=1 nf=1 m=1
RD1 VSS Vo1 1k
RD2 VSS Vo 1k
.ends dut
