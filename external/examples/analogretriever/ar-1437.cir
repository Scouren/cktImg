* official Analog Canvas netlist; PDK X cards rewritten by convert.py
.model nch nmos
.model pch pmos

.subckt dut VDD VSS Vin Vb1 Vout
M1 Vout Vb1 net1 VSS nch l=0.15 w=1 nf=1 m=1
M2 Vout Vin net0 VDD pch l=0.15 w=1 nf=1 m=1
RE VDD net0 1k
RS VSS net1 1k
.ends dut
