* official Analog Canvas netlist; PDK X cards rewritten by convert.py
.model qnpn npn

.subckt dut VCC VEE Iout
IREF VCC net0 DC 1m
Q1 net1 net1 VEE VEE qnpn m=1
Q2 net2 net1 VEE VEE qnpn m=1
Q3 net0 net0 net1 VEE qnpn m=1
Q4 Iout net0 net2 VEE qnpn m=1
.ends dut
