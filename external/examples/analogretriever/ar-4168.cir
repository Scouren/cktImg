* official Analog Canvas netlist; PDK X cards rewritten by convert.py
.model qnpn npn
.model qpnp pnp

.subckt dut VCC VEE VSS vO
IQ VCC vO DC 4mA
Q1 net0 net2 vO qpnp m=1
Q2 vO net0 net1 VEE qnpn m=1
Q3 vO net1 VEE VEE qnpn m=1
R1 VSS net2 25kΩ
RL vO VSS 1k
.ends dut
