* official Analog Canvas netlist; PDK X cards rewritten by convert.py
.model qnpn npn

.subckt dut VCC VSS Icopy1 Icopy2
IREF VCC X DC 0.2mA
Q1 Icopy1 X VSS VSS qnpn m=1
Q2 Icopy2 X VSS VSS qnpn m=10
Q3 X X VSS VSS qnpn m=1
Q4 X X VSS VSS qnpn m=1
Q5 X X VSS VSS qnpn m=1
Q6 X X VSS VSS qnpn m=1
.ends dut
