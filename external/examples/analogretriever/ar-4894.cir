* official Analog Canvas netlist; PDK X cards rewritten by convert.py
.model qnpn npn

.subckt dut VSS
Q1 net0 net1 VSS VSS qnpn m=1
R1 net1 VSS 1k
R2 net1 VSS 1k
rc net0 VSS 1k
vin net1 VSS DC 1 SIN(0 1 1k 0 0 0)
.ends dut
