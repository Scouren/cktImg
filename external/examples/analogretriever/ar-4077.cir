* official Analog Canvas netlist; PDK X cards rewritten by convert.py
.model qnpn npn

.subckt dut VCC VEE VSS vO
CB net2 VSS 1p
CC1 net4 net1 1p
CC2 net6 vO 1p
CE net3 VSS 1p
CL vO VSS 1p
Q1 net5 net1 net3 VEE qnpn m=1
Q2 net6 net2 net5 VEE qnpn m=1
R1 VCC net2 1k
R2 net2 net1 1k
R3 net1 VEE 1k
RC VCC net6 1k
RE net3 VEE 1k
RL vO VSS 1k
RS net0 net4 1k
vi net0 VSS DC 1
.ends dut
