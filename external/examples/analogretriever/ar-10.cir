* official Analog Canvas netlist; PDK X cards rewritten by convert.py

.subckt dut VSS B C E
Ccs net0 VSS 1p
Cmu Bp net0 1p
Cpi Bp net1 1p
G1 net0 net1 Bp net1 1m
Rb B Bp 1k
Rc net0 C 1k
Rex net1 E 1k
Rmu Bp net0 1k
Ro net0 net1 1k
Rpi Bp net1 1k
.ends dut
