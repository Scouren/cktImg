* official Analog Canvas netlist; PDK X cards rewritten by convert.py
.model qnpn npn

.subckt dut VCC VSS
C1 net1 net0 1p
I1 net1 VSS DC 1m
Q1 net2 net3 VSS VSS qnpn m=1
Q2 VCC net2 net1 VSS qnpn m=1
RC VCC net2 1kΩ
Rsp net0 VSS 8
vin net3 VSS DC 1
.ends dut
