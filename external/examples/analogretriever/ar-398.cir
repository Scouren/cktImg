* official Analog Canvas netlist; PDK X cards rewritten by convert.py

.subckt dut Vout Vref
G2 Vout net0 net1 net0 1m
G3 net1 Vref net0 Vref 1m
R1 net0 Vref 1k
Ro2 Vout net0 1k
Rpi2 net1 net0 1k
.ends dut
