* official Analog Canvas netlist; PDK X cards rewritten by convert.py
.model qpnp pnp

.subckt dut VCC VEE VSS
CC net1 net2 1p
Q1 net0 net2 net3 qpnp m=1
R1 VCC net2 1k
R2 net2 VEE 1k
RC net0 VEE 1k
RE VCC net3 1k
Vs net1 VSS DC 1
.ends dut
