* official Analog Canvas netlist; PDK X cards rewritten by convert.py
.model nch nmos

.subckt dut VDD VSS v1 v2 vo3
IQ1 net0 VSS DC 1m
IQ2 net2 VSS DC 1m
M1 vo1 v1 net0 VSS nch l=0.15 w=1 nf=1 m=1
M2 vo2 v2 net0 VSS nch l=0.15 w=1 nf=1 m=1
M3 vo3 vo1 net2 VSS nch l=0.15 w=1 nf=1 m=1
M4 net1 vo2 net2 VSS nch l=0.15 w=1 nf=1 m=1
R1A VDD vo1 1k
R1B VDD vo2 1k
R2A VDD vo3 1k
R2B VDD net1 1k
.ends dut
