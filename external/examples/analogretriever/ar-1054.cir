* official Analog Canvas netlist; PDK X cards rewritten by convert.py
.model qnpn npn

.subckt dut VCC VSS Vin
Q1 net0 net1 Vin VSS qnpn m=1
Q2 VCC net1 VSS VSS qnpn m=1
R1 VCC net0 1k
R2 VCC net1 1k
.ends dut
