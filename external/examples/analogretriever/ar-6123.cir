* official Analog Canvas netlist; PDK X cards rewritten by convert.py
.model nch nmos

.subckt dut VSS G D
M1 D G net0 VSS nch l=0.15 w=1 nf=1 m=1
RL D VSS 1k
Rs net0 VSS 1k
Rsig G VSS 1k
.ends dut
