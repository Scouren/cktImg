* official Analog Canvas netlist; PDK X cards rewritten by convert.py
.model nch nmos
.model pch pmos

.subckt dut VSS vi vo
M1 vo vi VSS VSS pch l=0.15 w=1 nf=1 m=1
M2 vo net0 VSS VSS nch l=0.15 w=1 nf=1 m=1
M3 net0 net0 VSS VSS nch l=0.15 w=1 nf=1 m=1
R VSS net0 1k
.ends dut
