* official Analog Canvas netlist; PDK X cards rewritten by convert.py

.subckt dut VSS vo
Gm VSS vo vi vo 1m
RL vo VSS 1k
ro VSS vo 1k
RS net0 vi 1k
rpi vi vo 1k
vs net0 VSS DC 1
.ends dut
