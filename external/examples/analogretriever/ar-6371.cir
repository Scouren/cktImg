* official Analog Canvas netlist; PDK X cards rewritten by convert.py
.model nch nmos

.subckt dut VSS Vo
CL Vo VSS 1p
L Vo VSS 1n
M1 Vo net0 VSS VSS nch l=0.15 w=1 nf=1 m=1
RL Vo VSS 1k
Vi net0 VSS DC 1
.ends dut
