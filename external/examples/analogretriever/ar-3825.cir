* official Analog Canvas netlist; PDK X cards rewritten by convert.py
.model nch nmos
.model pch pmos

.subckt dut VSS vi vo
I1 VSS net0 DC 200uA
IQ vo VSS DC 100uA
M1 net0 vi VSS VSS nch l=0.15 w=1 nf=1 m=1
M2 vo VSS net0 net0 pch l=0.15 w=1 nf=1 m=1
.ends dut
