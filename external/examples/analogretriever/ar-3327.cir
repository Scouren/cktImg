* official Analog Canvas netlist; PDK X cards rewritten by convert.py
.model nch nmos
.model pch pmos

.subckt dut VDD VSS Vb Iout1 Iout2 Ioutn
M0 VG Vb VDD VDD pch l=0.15 w=1 nf=1 m=1
M1 Iout1 VG net0 VSS nch l=0.15 w=1 nf=1 m=1
M2 Iout2 VG net2 VSS nch l=0.15 w=1 nf=1 m=1
Mn Ioutn VG net1 VSS nch l=0.15 w=1 nf=1 m=1
MREF VG VG VSS VSS nch l=0.15 w=1 nf=1 m=1
R1 VSS net0 1k
R2 net0 net2 1k
R3 net2 net1 1k
.ends dut
