* official Analog Canvas netlist; PDK X cards rewritten by convert.py

.subckt dut VSS
G2 net1 VSS VSS VSS 1m
G4 net2 net1 VSS net1 1m
G6 net0 net2 VSS net2 1m
R1 net0 net2 1k
R2 net2 net1 1k
R3 VSS net1 1k
R4 net1 VSS 1k
R5 VSS VSS 1k
Vx net0 VSS DC 1
.ends dut
