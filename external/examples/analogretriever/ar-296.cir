* official Analog Canvas netlist; PDK X cards rewritten by convert.py
.model nch nmos

.subckt dut VSS voc
CT net0 VSS 1p
M1 voc net2 net0 VSS nch l=0.15 w=1 nf=1 m=1
RL VSS voc 1k
RS net1 net2 1k
RT net0 VSS 1k
Vic net1 VSS DC 1
.ends dut
