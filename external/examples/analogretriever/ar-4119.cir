* official Analog Canvas netlist; PDK X cards rewritten by convert.py

.subckt dut VSS Vo
C1 net1 VSS 1p
G1 Vo VSS net1 VSS 1m
Rb net0 net1 1k
RL Vo VSS 1k
Rpi net1 VSS 1k
Vi net0 VSS DC 1
.ends dut
