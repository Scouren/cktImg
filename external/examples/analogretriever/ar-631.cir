* official Analog Canvas netlist; PDK X cards rewritten by convert.py

.subckt dut VSS vout
R1 net2 vout 1k
R2 vout net0 1k
R3 net0 net1 1k
R4 net1 VSS 1k
vad net2 VSS DC 1
.ends dut
