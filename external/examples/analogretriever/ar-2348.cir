* official Analog Canvas netlist; PDK X cards rewritten by convert.py
.model nch nmos
.model pch pmos

.subckt dut VDD VSS I0 In
M1 net2 VBN VSS VSS nch l=0.15 w=1 nf=1 m=1
M2 VBN VBN VSS VSS nch l=0.15 w=1 nf=1 m=1
M3 net2 net2 net1 VDD pch l=0.15 w=1 nf=1 m=1
M4 VBN net2 net0 VDD pch l=0.15 w=1 nf=1 m=1
M5 net1 net1 VDD VDD pch l=0.15 w=1 nf=1 m=1
M6 net0 net1 net3 VDD pch l=0.15 w=1 nf=1 m=1
M7 I0 VBN VSS VSS nch l=0.15 w=1 nf=1 m=1
M8 In VBN VSS VSS nch l=0.15 w=1 nf=1 m=1
R1 VDD net3 1k
.ends dut
