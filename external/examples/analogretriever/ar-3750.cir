* official Analog Canvas netlist; PDK X cards rewritten by convert.py
.model nch nmos

.subckt dut VDD VSS GND vO
CC net2 net0 1p
M1 vO net0 net1 GND nch l=0.15 w=1 nf=1 m=1
R1 VDD net0 165kΩ
R2 net0 VSS 35kΩ
RD VDD vO 7kΩ
RS net1 VSS 0.5kΩ
vi net2 GND DC 1
.ends dut
