* official Analog Canvas netlist; PDK X cards rewritten by convert.py
.model qnpn npn

.subckt dut VCC VSS Vin1 Vin2 X Y
IEE1 net1 VSS DC 1m
IEE2 net0 VSS DC 1m
Q1 X Vin1 net1 VSS qnpn m=1
Q2 Y Vin2 net0 VSS qnpn m=1
RC1 VCC X 1k
RC2 VCC Y 1k
RE net1 net0 1k
.ends dut
