* official Analog Canvas netlist; PDK X cards rewritten by convert.py
.model qnpn npn

.subckt dut VEE VSS A B D C
I1 D VEE DC 1m
I2 net2 VEE DC 1m
I3 net0 VEE DC 1m
I4 net4 VEE DC 1m
I5 C VEE DC 1m
Q1 VSS net4 net0 VSS qnpn m=1
Q2 VSS net1 C VSS qnpn m=1
Q3 VSS net3 D VSS qnpn m=1
QA net3 A net2 VSS qnpn m=1
QB net3 B net2 VSS qnpn m=1
QR net1 net0 net2 VSS qnpn m=1
R1 VSS net3 1k
R2 VSS net1 1k
R3 VSS net4 1k
.ends dut
