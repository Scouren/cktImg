* official Analog Canvas netlist; PDK X cards rewritten by convert.py

.subckt dut VDD VSS vO+ vO- Vin1 Vin2
G1 vO+ net0 Vin1 net0 1m
G2 vO- net0 Vin2 net0 1m
IBIAS net0 VSS DC 1m
RD1 VDD vO+ 1k
RD2 VDD vO- 1k
.ends dut
