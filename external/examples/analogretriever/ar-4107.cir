* official Analog Canvas netlist; PDK X cards rewritten by convert.py
.model nch nmos

.subckt dut VDD VSS vo
CC net1 net0 1p
CL vo VSS 1p
M1 vo net0 VSS VSS nch l=0.15 w=1 nf=1 m=1
R1 VDD net0 1k
R2 net0 VSS 1k
RD VDD vo 1k
RSi net2 net1 200Ω
vi net2 VSS DC 1
.ends dut
