* official Analog Canvas netlist; PDK X cards rewritten by convert.py
.model qnpn npn
.model qpnp pnp

.subckt dut VCC VSS VB
.model DIODE D(IS=1e-14 N=1)
D1 net2 net1 DIODE
Ii VSS net3 DC 1m
IQ net1 VSS DC 16mA
Q1 net0 VB net3 VSS qnpn m=1
Q2 net2 net0 VCC qpnp m=1
RC net0 VCC 200Ω
RF net3 net1 500Ω
.ends dut
