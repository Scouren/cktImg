* official Analog Canvas netlist; PDK X cards rewritten by convert.py
.model qnpn npn

.subckt dut VSS Vo
C1 net0 VSS 1p
C2 Vo VSS 1p
Ii VSS net0 DC 1m
L1 net0 VSS 1n
L2 Vo VSS 1n
Q1 net1 net0 VSS VSS qnpn m=1
Q2 Vo VSS net1 VSS qnpn m=1
R1 net0 VSS 1k
R2 Vo VSS 1k
.ends dut
