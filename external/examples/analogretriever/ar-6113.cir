* official Analog Canvas netlist; PDK X cards rewritten by convert.py

.subckt dut VSS Vo
Cgd G VSS 1p
Cgs G Vo 1p
CL Vo VSS 1p
Gm VSS Vo G Vo 1m
RLp Vo VSS 1k
Rsig net0 G 1k
Vsig net0 VSS DC 1
.ends dut
