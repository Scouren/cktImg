* official Analog Canvas netlist; PDK X cards rewritten by convert.py
.model qnpn npn

.subckt dut VCC VSS
CC1 net0 net2 1p
CC2 net3 net1 1p
ii VSS net0 DC 1m
Q1 net3 net2 VSS VSS qnpn m=1
R1 VCC net2 1k
R2 net2 VSS 1k
RC VCC net3 1k
RL net1 VSS 1k
.ends dut
