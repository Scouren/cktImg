* official Analog Canvas netlist; PDK X cards rewritten by convert.py
.model qnpn npn

.subckt dut VCC VEE VSS vo
CC1 net3 net2 1p
CC2 net1 vo 1p
Q1 net1 net2 net4 VEE qnpn m=1
RB net2 VSS 10kΩ
RC VCC net1 6.8kΩ
RE net4 VEE 3kΩ
RL vo VSS 6.8kΩ
RS net0 net3 0.5kΩ
vs net0 VSS DC 1
.ends dut
