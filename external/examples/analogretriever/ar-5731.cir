* official Analog Canvas netlist; PDK X cards rewritten by convert.py
.model nch nmos

.subckt dut VDD VSS V3 V4 V5
M1 V3 V3 V4 VSS nch l=0.15 w=1 nf=1 m=1
M2 V4 V4 V5 VSS nch l=0.15 w=1 nf=1 m=1
R1 VDD V3 1kΩ
R2 V5 VSS 1kΩ
.ends dut
