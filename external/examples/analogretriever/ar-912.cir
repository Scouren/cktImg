* official Analog Canvas netlist; PDK X cards rewritten by convert.py
.model qnpn npn

.subckt dut VCC VSS vout VB
Q1 vout net0 net2 VSS qnpn m=1
RB net0 VB 1k
RC VCC vout 1k
RE net1 net2 1k
rO vout net2 1k
vin net1 VSS DC 1
.ends dut
