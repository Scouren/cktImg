* official Analog Canvas netlist; PDK X cards rewritten by convert.py

.subckt dut VSS
Cpi net1 net0 1p
G1 VSS net0 net1 net0 1m
RS VSS net1 1k
rpi net1 net0 1k
VX net0 VSS DC 1
.ends dut
