* official Analog Canvas netlist; PDK X cards rewritten by convert.py

.subckt dut VSS VO
.model DIODE D(IS=1e-14 N=1)
VB1 net1 VSS DC 1
D1 VO VSS DIODE
D2 net0 net2 DIODE
D3 net2 VO DIODE
R1 net1 net0 1k
R2 VO VSS 1kΩ
.ends dut
