* official Analog Canvas netlist; PDK X cards rewritten by convert.py
.model pch pmos

.subckt dut VDD VSS GND
IREF2 net0 VSS DC 1m
MA net1 GND net2 VDD pch l=0.15 w=1 nf=1 m=1
MB net2 net0 VDD VDD pch l=0.15 w=1 nf=1 m=1
MC net0 net0 VDD VDD pch l=0.15 w=1 nf=1 m=1
RD net1 VSS 8kΩ
.ends dut
