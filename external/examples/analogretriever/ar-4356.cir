* official Analog Canvas netlist; PDK X cards rewritten by convert.py
.model qnpn npn

.subckt dut VCC VEE v1 v2 vo3
IQ1 net2 VEE DC 1m
IQ2 net0 VEE DC 1m
Q1 vo1 v1 net2 VEE qnpn m=1
Q2 vo2 v2 net2 VEE qnpn m=1
Q3 vo3 vo1 net0 VEE qnpn m=1
Q4 net1 vo2 net0 VEE qnpn m=1
R1A VCC vo1 1k
R1B VCC vo2 1k
R2A VCC vo3 1k
R2B VCC net1 1k
.ends dut
