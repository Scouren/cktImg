* official Analog Canvas netlist; PDK X cards rewritten by convert.py
.model nch nmos
.model pch pmos

.subckt dut VDD VSS A B vo
IREF VDD VB DC 200uA
M1 net0 A net2 VSS nch l=0.15 w=1 nf=1 m=1
M2 net1 B net2 VSS nch l=0.15 w=1 nf=1 m=1
M3 net0 net0 VDD VDD pch l=0.15 w=1 nf=1 m=1
M4 net1 net0 VDD VDD pch l=0.15 w=1 nf=1 m=1
M5 net2 VB VSS VSS nch l=0.15 w=1 nf=1 m=1
M6 vo net1 VDD VDD pch l=0.15 w=1 nf=1 m=1
M7 vo VB VSS VSS nch l=0.15 w=1 nf=1 m=1
M8 VB VB VSS VSS nch l=0.15 w=1 nf=1 m=1
.ends dut
