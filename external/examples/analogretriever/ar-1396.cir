* official Analog Canvas netlist; PDK X cards rewritten by convert.py
.model qnpn npn
.model qpnp pnp

.subckt dut VCC VSS vin vout
IREF VCC X1 DC 1m
Q1 vout vin VSS VSS qnpn m=1
Q2 vout X2 VCC qpnp m=1
QM X2 X1 VSS VSS qnpn m=1
QREF1 X1 X1 VSS VSS qnpn m=1
QREF2 X2 X2 VCC qpnp m=1
.ends dut
