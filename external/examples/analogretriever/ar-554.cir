* official Analog Canvas netlist; PDK X cards rewritten by convert.py
.model nch nmos
.model pch pmos

.subckt dut VDD VSS BiasB BiasC BiasD BiasA Vid Vod
CL Vod VSS 1p
M1 net1 Vid VSS VSS nch l=0.15 w=1 nf=1 m=1
M11 net1 BiasB VDD VDD pch l=0.15 w=1 nf=1 m=1
M1A Vod BiasC net1 VDD pch l=0.15 w=1 nf=1 m=1
M3 net0 BiasA VSS VSS nch l=0.15 w=1 nf=1 m=1
M3A Vod BiasD net0 VSS nch l=0.15 w=1 nf=1 m=1
.ends dut
