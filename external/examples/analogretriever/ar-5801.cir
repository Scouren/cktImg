* official Analog Canvas netlist; PDK X cards rewritten by convert.py

.subckt dut VSS vo
G1 vo VSS G VSS 1m
RD vo VSS 1k
RG G vo 1k
RL vo VSS 1k
Ro vo VSS 1k
Vi G VSS DC 1
.ends dut
