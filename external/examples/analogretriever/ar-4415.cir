* official Analog Canvas netlist; PDK X cards rewritten by convert.py

.subckt dut VSS Vo
G1 Vo VSS net0 VSS 1m
Ii VSS net0 DC 1m
RC Vo VSS 1k
RF net0 Vo 1k
Rpi net0 VSS 1k
.ends dut
