* official Analog Canvas netlist; PDK X cards rewritten by convert.py
.model qnpn npn
.model qpnp pnp

.subckt dut VCC VEE VSS v- v+ vo
Q1 net7 v- net0 VEE qnpn m=1
Q2 net7 v+ net6 VEE qnpn m=1
Q3 net3 net4 net0 qpnp m=1
Q4 net5 net4 net6 qpnp m=1
Q5 vo net5 net1 VEE qnpn m=1
QA net2 net2 VEE VEE qnpn m=1
QB net4 net2 net8 VEE qnpn m=1
QC net4 net7 VCC qpnp m=1
QD net7 net7 VCC qpnp m=1
R1 net8 VEE 1k
R2 net3 VEE 1k
R3 net5 VEE 1k
R4 VCC vo 1k
R5 net1 VEE 1k
RREF VSS net2 1k
.ends dut
