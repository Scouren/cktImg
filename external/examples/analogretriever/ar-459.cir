* official Analog Canvas netlist; PDK X cards rewritten by convert.py
.model qnpn npn

.subckt Tanh_1 in+ in- out+ out-
.ends Tanh_1

.subckt dut VSS Iout+ Iout- V1+ V1- V2+ V2-
IEE net4 VSS DC 1m
Q1 net0 net1 net4 VSS qnpn m=1
Q2 net2 V2o- net4 VSS qnpn m=1
Q3 Iout+ V1o+ net0 VSS qnpn m=1
Q4 Iout- net3 net0 VSS qnpn m=1
Q5 Iout+ net3 net2 VSS qnpn m=1
Q6 Iout- V1o+ net2 VSS qnpn m=1
X1 V1+ V1- V1o+ net3 Tanh_1
X2 V2+ V2- net1 V2o- Tanh_1
.ends dut
