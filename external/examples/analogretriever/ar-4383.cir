* official Analog Canvas netlist; PDK X cards rewritten by convert.py
.model pch pmos
.model qnpn npn

.subckt dut VDD VSS vO
VB1 net3 VSS DC 2.5V
CC net1 vO 1p
IQ VDD net1 DC 1m
M1 net2 net0 net1 VDD pch l=0.15 w=1 nf=1 m=1
Q2 net1 net2 VSS VSS qnpn m=1
R1 net2 VSS 8kΩ
RL vO VSS 1k
vi net0 net3 DC 1
.ends dut
