* official Analog Canvas netlist; PDK X cards rewritten by convert.py
.model nch nmos
.model pch pmos

.subckt dut VDD VSS Y A B C D
M1 Y A VDD VDD pch l=0.15 w=1 nf=1 m=1
M2 Y B VDD VDD pch l=0.15 w=1 nf=1 m=1
M3 Y C VDD VDD pch l=0.15 w=1 nf=1 m=1
M4 Y D VDD VDD pch l=0.15 w=1 nf=1 m=1
M5 Y A net2 VSS nch l=0.15 w=1 nf=1 m=1
M6 net2 B net1 VSS nch l=0.15 w=1 nf=1 m=1
M7 net1 C net0 VSS nch l=0.15 w=1 nf=1 m=1
M8 net0 D VSS VSS nch l=0.15 w=1 nf=1 m=1
.ends dut
