* official Analog Canvas netlist; PDK X cards rewritten by convert.py
.model nch nmos
.model pch pmos

.subckt dut VDD VSS vI vO
M1 net0 net0 VDD VDD pch l=0.15 w=1 nf=1 m=1
M2 vO net0 VDD VDD pch l=0.15 w=1 nf=1 m=1
M3 VSS VSS net0 VDD pch l=0.15 w=1 nf=1 m=1
Mo vO vI VSS VSS nch l=0.15 w=1 nf=1 m=1
.ends dut
