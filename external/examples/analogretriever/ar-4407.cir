* official Analog Canvas netlist; PDK X cards rewritten by convert.py
.model qnpn npn

.subckt dut VSS
Ii VSS net0 DC 1m
Q1 net2 net0 VSS VSS qnpn m=1
Q2 net1 net2 net3 VSS qnpn m=1
RB1 net0 VSS 1k
RB2 net2 VSS 1k
RC1 net2 VSS 1k
RC2 net1 VSS 1k
RE2 net3 VSS 1k
RF net0 net3 1k
RL net1 VSS 1k
RS net0 VSS 1k
.ends dut
