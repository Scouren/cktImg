* official Analog Canvas netlist; PDK X cards rewritten by convert.py
.model qnpn npn

.subckt dut VSS vi vo
Q12 v1 vi net0 VSS qnpn m=1
Q14 VSS v1 net1 VSS qnpn m=1
Q15 VSS net1 vo VSS qnpn m=1
R1 net0 VSS 1k
R12 net1 vo 1k
RL vo VSS 1k
RL12 v1 VSS 1k
.ends dut
