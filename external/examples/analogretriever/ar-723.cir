* official Analog Canvas netlist; PDK X cards rewritten by convert.py

.subckt dut VCC VEE Vin Vout
.model DIODE D(IS=1e-14 N=1)
D1 Vout net1 DIODE
D2 net0 Vin DIODE
D3 net0 Vout DIODE
D4 Vin net1 DIODE
R1 VCC net0 1kΩ
R2 net1 VEE 1kΩ
.ends dut
