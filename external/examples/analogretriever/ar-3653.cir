* official Analog Canvas netlist; PDK X cards rewritten by convert.py

.subckt dut VSS V1 V2 VO
.model DIODE D(IS=1e-14 N=1)
D1 net1 VO DIODE
D2 net0 VO DIODE
R1 V1 net1 0.5kΩ
R2 V2 net0 0.5kΩ
R3 VO VSS 9.5kΩ
.ends dut
