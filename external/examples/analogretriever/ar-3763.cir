* official Analog Canvas netlist; PDK X cards rewritten by convert.py

.subckt dut VSS Vo
G1 Vo S VSS S 1m
RD Vo VSS 1k
RL Vo VSS 1k
RSi net0 S 1k
Vi net0 VSS DC 1
.ends dut
