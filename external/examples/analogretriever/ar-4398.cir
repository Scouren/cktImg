* official Analog Canvas netlist; PDK X cards rewritten by convert.py

.subckt dut Vout VoutN
G1 Vout VoutN net2 net1 1m
Rif net2 net1 1k
RL Vout VoutN 1k
Rof Vout VoutN 1k
RS net0 net2 1k
Vi net0 net1 DC 1
.ends dut
