* official Analog Canvas netlist; PDK X cards rewritten by convert.py

.subckt dut VSS vin vout
.model DIODE D(IS=1e-14 N=1)
D1 vout net1 DIODE
D2 net1 net0 DIODE
D3 net0 VSS DIODE
R1 vin vout 1kΩ
.ends dut
