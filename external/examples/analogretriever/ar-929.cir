* official Analog Canvas netlist; PDK X cards rewritten by convert.py
.model qnpn npn

.subckt dut VCC VSS vout
VB1 net1 VSS DC 1
C1 net2 net0 1p
Q1 vout net1 net0 VSS qnpn m=1
RC VCC vout 1k
RE net0 VSS 1k
vin net2 VSS DC 1
.ends dut
