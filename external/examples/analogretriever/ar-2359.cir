* official Analog Canvas netlist; PDK X cards rewritten by convert.py
.model nch nmos
.model pch pmos

.subckt dut VDD VSS VIN+ VIN- VOUT+ VOUT- VBIAS4 VBIAS3 VBIAS2 VBIAS1 VCMFB
CC1 net4 VOUT+ 1p
CC2 net6 VOUT+ 1p
CC3 net0 VOUT- 1p
CC4 net5 VOUT- 1p
M1 net6 VIN+ net1 net1 pch l=0.15 w=1 nf=1 m=1
M10 net0 VBIAS3 VDD VDD pch l=0.15 w=1 nf=1 m=1
M11 VOUT+ VBIAS3 VDD VDD pch l=0.15 w=1 nf=1 m=1
M12 VOUT- VBIAS3 VDD VDD pch l=0.15 w=1 nf=1 m=1
M13 VOUT+ net3 VSS VSS nch l=0.15 w=1 nf=1 m=1
M14 VOUT- net2 VSS VSS nch l=0.15 w=1 nf=1 m=1
M2 net5 VIN- net1 net1 pch l=0.15 w=1 nf=1 m=1
M3 net6 VCMFB VSS VSS nch l=0.15 w=1 nf=1 m=1
M4 net5 VCMFB VSS VSS nch l=0.15 w=1 nf=1 m=1
M5 net3 VBIAS1 net6 VSS nch l=0.15 w=1 nf=1 m=1
M6 net2 VBIAS1 net5 VSS nch l=0.15 w=1 nf=1 m=1
M7 net3 VBIAS2 net4 VDD pch l=0.15 w=1 nf=1 m=1
M8 net2 VBIAS2 net0 VDD pch l=0.15 w=1 nf=1 m=1
M9 net4 VBIAS3 VDD VDD pch l=0.15 w=1 nf=1 m=1
MB1 net1 VBIAS4 VDD VDD pch l=0.15 w=1 nf=1 m=1
.ends dut
