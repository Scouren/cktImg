* official Analog Canvas netlist; PDK X cards rewritten by convert.py

.subckt dut VSS
CF VSS net0 1p
i2 VSS net0 DC 1m
RE net0 VSS 1k
RF VSS net0 1k
.ends dut
