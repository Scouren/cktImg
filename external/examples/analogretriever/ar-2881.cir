* official Analog Canvas netlist; PDK X cards rewritten by convert.py
.model nch nmos
.model pch pmos

.subckt dut VDD VSS
M1 X net0 net1 VSS nch l=0.15 w=1 nf=1 m=1
M2 Y net0 net1 VSS nch l=0.15 w=1 nf=1 m=1
M3 X net2 VDD VDD pch l=0.15 w=1 nf=1 m=1
M4 Y VSS VDD VDD pch l=0.15 w=1 nf=1 m=1
Vn3 net2 VSS DC 1
.ends dut
