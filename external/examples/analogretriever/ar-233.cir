* official Analog Canvas netlist; PDK X cards rewritten by convert.py
.model nch nmos
.model pch pmos

.subckt dut vdd VSS vob
M1 net0 VSS net1 vdd pch l=0.15 w=1 nf=1 m=1
M2 net2 VSS net1 vdd pch l=0.15 w=1 nf=1 m=1
M3 net0 net0 VSS VSS nch l=0.15 w=1 nf=1 m=1
M4 net2 net0 VSS VSS nch l=0.15 w=1 nf=1 m=1
M6 vob net2 VSS VSS nch l=0.15 w=1 nf=1 m=1
Ro7 VSS vob 1k
Rtail vdd net1 1k
.ends dut
