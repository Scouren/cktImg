* official Analog Canvas netlist; PDK X cards rewritten by convert.py

.subckt dut VSS Vc1
G1 Vc1 net3 net1 net3 1m
R11f net3 net2 1k
Rpi1 net1 net3 1k
RS net0 net1 1k
V1 net2 VSS DC 1
Vs net0 VSS DC 1
.ends dut
