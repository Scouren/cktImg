* official Analog Canvas netlist; PDK X cards rewritten by convert.py
.model nch nmos

.subckt dut VDD VSS Vin Vb Vout
C1 net0 Vout 50uF
M1 VDD Vin net0 VSS nch l=0.15 w=1 nf=1 m=1
M2 net0 Vb VSS VSS nch l=0.15 w=1 nf=1 m=1
R1 Vout VSS 8Ω
.ends dut
