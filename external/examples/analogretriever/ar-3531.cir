* official Analog Canvas netlist; PDK X cards rewritten by convert.py
.model nch nmos
.model pch pmos
.model qpnp pnp

.subckt dut VDD VCC VEE VSS vIN1 vIN2 Vout
IBIAS1 net2 VEE DC 1m
IBIAS2 Vout VEE DC 1m
M1 net0 vIN1 net2 VSS nch l=0.15 w=1 nf=1 m=1
M2 net1 vIN2 net2 VSS nch l=0.15 w=1 nf=1 m=1
M7 Vout net1 VCC VCC pch l=0.15 w=1 nf=1 m=1
Q5 net0 net0 VCC qpnp m=1
Q6 net1 net0 VCC qpnp m=1
.ends dut
