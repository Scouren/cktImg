* official Analog Canvas netlist; PDK X cards rewritten by convert.py
.model qnpn npn

.subckt dut VCC VSS
C1 VSS net2 1p
C2 net3 VSS 1p
CB net0 net2 1p
CE net1 VSS 1p
L net3 net2 1n
Q1 net3 net0 net1 VSS qnpn m=1
R1 VCC net0 1k
R2 net0 VSS 1k
RC VCC net3 1k
RE net1 VSS 1k
.ends dut
