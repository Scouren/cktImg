* official Analog Canvas netlist; PDK X cards rewritten by convert.py
.model qnpn npn

.subckt dut VCC VSS X Y VB1 VB2
C1 net0 VB1 1p
C2 net0 VB2 1p
Q1 X VB1 VSS VSS qnpn m=1
Q2 Y VB2 VSS VSS qnpn m=1
RC1 VCC X 1k
RC2 VCC Y 1k
Vin net0 VSS DC 1
.ends dut
