* official Analog Canvas netlist; PDK X cards rewritten by convert.py
.model qnpn npn

.subckt dut VSS
H1 net7 net9 V__icm_sense_486cf6439764b14e 1k
Q1 net4 net9 net3 VSS qnpn m=1
Q2 net6 net4 VSS VSS qnpn m=1
Q3 __icm_sense_node_486cf6439764b14e net6 net5 VSS qnpn m=1
V__icm_sense_486cf6439764b14e net2 __icm_sense_node_486cf6439764b14e DC 0
RE1 net3 VSS 1k
RE1b net0 VSS 1k
RE2 net5 VSS 1k
RE2a net8 VSS 1k
RFa net3 net8 1k
RFb net5 net0 1k
RL net2 VSS 1k
RL1 net4 VSS 1k
RL2 net6 VSS 1k
RS net1 net7 1k
Vs net1 VSS DC 1
.ends dut
