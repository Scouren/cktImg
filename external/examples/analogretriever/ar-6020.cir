* official Analog Canvas netlist; PDK X cards rewritten by convert.py
.model qnpn npn

.subckt dut VCC VEE VSS Vo1 Vo2 B1 B2
I net2 VEE DC 1mA
Q1 Vo1 B1 net1 VEE qnpn m=1
Q2 Vo2 B2 net0 VEE qnpn m=1
R1 net3 B1 5kΩ
R2 net4 B2 5kΩ
RC1 VCC Vo1 10kΩ
RC2 VCC Vo2 10kΩ
RE1 net1 net2 150Ω
RE2 net0 net2 150Ω
Vsig1 net3 VSS DC 1
Vsig2 VSS net4 DC 1
.ends dut
