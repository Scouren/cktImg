* official Analog Canvas netlist; PDK X cards rewritten by convert.py
.model nch nmos

.subckt dut VSS Vr Vin
M1 Vr VSS net1 VSS nch l=0.15 w=1 nf=1 m=1
M2 net0 Vin VSS VSS nch l=0.15 w=1 nf=1 m=1
R1 net1 VSS 1k
R2 net1 net0 1k
RD1 VSS Vr 1k
RD2 VSS net0 1k
Vt Vin VSS DC 1
.ends dut
