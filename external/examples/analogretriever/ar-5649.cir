* official Analog Canvas netlist; PDK X cards rewritten by convert.py

.subckt dut VDD VSS vO vI
.model DIODE D(IS=1e-14 N=1)
D1 net0 vI DIODE
D2 net0 VSS DIODE
I1 VDD vO DC 1mA
R1 vO net0 1kΩ
.ends dut
