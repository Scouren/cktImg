* official Analog Canvas netlist; PDK X cards rewritten by convert.py
.model nch nmos
.model pch pmos

.subckt dut VDD VSS Vb Vin Vout2 Vout1
M1 Vout2 Vin Vout1 VSS nch l=0.15 w=1 nf=1 m=1
M2 VSS VSS Vout1 VDD pch l=0.15 w=1 nf=1 m=1
M3 VDD VDD Vout2 VSS nch l=0.15 w=1 nf=1 m=1
M4 Vout2 Vb VDD VDD pch l=0.15 w=1 nf=1 m=1
.ends dut
