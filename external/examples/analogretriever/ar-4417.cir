* official Analog Canvas netlist; PDK X cards rewritten by convert.py

.subckt dut VSS Vo
G1 Vo VSS net0 VSS 18.9m
Ii VSS net0 DC 1m
RB net0 VSS 4.96kΩ
RC Vo VSS 10kΩ
RF net0 Vo 82kΩ
Rpi net0 VSS 5.28kΩ
RS net0 VSS 10kΩ
.ends dut
