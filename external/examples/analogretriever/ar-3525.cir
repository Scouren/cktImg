* official Analog Canvas netlist; PDK X cards rewritten by convert.py

.subckt dut VSS Vin Vout
G1 net1 VSS Vin VSS 1m
G2 net3 VSS net1 VSS 1m
G3 VSS net0 net3 net0 1m
G4 VSS Vout net2 Vout 1m
RC1 net1 VSS 1k
RC2 net3 VSS 1k
RE3 net0 net2 1k
RE4 Vout VSS 1k
RL Vout VSS 1k
Rpi1 Vin VSS 1k
Rpi2 net1 VSS 1k
Rpi3 net3 net0 1k
Rpi4 net2 Vout 1k
.ends dut
