* official Analog Canvas netlist; PDK X cards rewritten by convert.py

.subckt dut VSS
VB1 net1 VSS DC 100V
R1 net1 VSS 100Ω
R2 net1 A 220Ω
R3 A VSS 560Ω
R4 A net0 1.0kΩ
R5 net0 VSS 100Ω
.ends dut
