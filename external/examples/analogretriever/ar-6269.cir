* official Analog Canvas netlist; PDK X cards rewritten by convert.py
.model nch nmos
.model pch pmos

.subckt dut VDD VSS GND
I1 VDD net0 DC 1m
M1 net1 net1 net0 VDD pch l=0.15 w=1 nf=1 m=1
M2 net1 net1 GND VSS nch l=0.15 w=1 nf=1 m=1
M3 VDD net0 net2 VSS nch l=0.15 w=1 nf=1 m=1
M4 VSS GND net2 VDD pch l=0.15 w=1 nf=1 m=1
.ends dut
