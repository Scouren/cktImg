* official Analog Canvas netlist; PDK X cards rewritten by convert.py
.model nch nmos

.subckt dut VSS
C1 VSS net1 1p
C2 net0 VSS 1p
L net0 net1 1n
M1 net1 net0 VSS VSS nch l=0.15 w=1 nf=1 m=1
R net1 VSS 1k
.ends dut
