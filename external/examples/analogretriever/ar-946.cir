* official Analog Canvas netlist; PDK X cards rewritten by convert.py
.model qnpn npn

.subckt dut VCC VSS
C1 net1 net0 1p
Q1 net1 net2 VSS VSS qnpn m=1
RC VCC net1 1kΩ
Rsp net0 VSS 8
vin net2 VSS DC 1
.ends dut
