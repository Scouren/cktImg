* official Analog Canvas netlist; PDK X cards rewritten by convert.py
.model nch nmos
.model pch pmos

.subckt dut VDD VSS Vin Vo
VB1 net0 VSS DC 0.9V
I1 VDD G2 DC 0.1mA
I2 G3 VSS DC 0.1mA
I3 Vo VSS DC 0.1mA
M1 G2 Vin S1 VSS nch l=0.15 w=1 nf=1 m=1
M2 G3 G2 VDD VDD pch l=0.15 w=1 nf=1 m=1
M3 VDD G3 Vo VSS nch l=0.15 w=1 nf=1 m=1
R1 S1 VSS 2kΩ
R2 S1 Vo 18kΩ
Vs Vin net0 DC 1
.ends dut
