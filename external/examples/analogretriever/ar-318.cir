* official Analog Canvas netlist; PDK X cards rewritten by convert.py

.subckt dut VSS vo
Ccs1 net2 VSS 1p
Ccs3 net0 VSS 1p
Cmu1 net3 net2 1p
Cmu3 net0 net1 1p
Cpi1 net3 net6 1p
Cpi3 net4 net1 1p
G1 net2 net6 net3 net6 1m
G3 net0 net4 net1 net4 1m
Rb3 net1 VSS 1k
Rc1 net2 net4 1k
Rc3 net0 vo 1k
RE net6 VSS 1k
RL vo VSS 1k
Rpi1 net3 net6 1k
Rpi3 net4 net1 1k
Rs net5 net3 1k
Vs net5 VSS DC 1
.ends dut
