* official Analog Canvas netlist; PDK X cards rewritten by convert.py
.model nch nmos

.subckt dut VDD VSS Iout
IREF VDD net1 DC 1m
M1 net1 net0 VSS VSS nch l=0.15 w=1 nf=1 m=1
M2 net0 net0 VSS VSS nch l=0.15 w=1 nf=1 m=1
M3 Iout net1 net0 VSS nch l=0.15 w=1 nf=1 m=1
.ends dut
