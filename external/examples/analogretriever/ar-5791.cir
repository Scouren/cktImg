* official Analog Canvas netlist; PDK X cards rewritten by convert.py
.model qnpn npn
.model qpnp pnp

.subckt dut VCC VSS
Q3 net4 net1 net0 qpnp m=1
Q4 net2 net4 net3 VSS qnpn m=1
R1 VCC net0 10kΩ
R2 net1 VSS 10kΩ
R3 net4 VSS 20kΩ
R4 VCC net2 30kΩ
R5 net3 VSS 10kΩ
.ends dut
