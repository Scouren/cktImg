* official Analog Canvas netlist; PDK X cards rewritten by convert.py
.model qnpn npn

.subckt dut VCC VSS I1
IREF VCC net1 DC 1m
Q1 I1 net0 VSS VSS qnpn m=1
QREF net1 net1 VSS VSS qnpn m=1
RP net1 net0 1k
.ends dut
