* official Analog Canvas netlist; PDK X cards rewritten by convert.py

.subckt dut VDD VSS V
.model DIODE D(IS=1e-14 N=1)
D1 net0 V DIODE
D2 net0 VSS DIODE
I1 VDD net0 DC 10mA
R1 V VSS 1k
.ends dut
