* official Analog Canvas netlist; PDK X cards rewritten by convert.py
.model nch nmos
.model pch pmos

.subckt dut VDD VSS GND
VB1 net0 VSS DC 1
I1 VDD net3 DC 1m
M1 net1 net2 net3 VDD pch l=0.15 w=1 nf=1 m=1
M2 net0 GND net3 VDD pch l=0.15 w=1 nf=1 m=1
M3 net1 net1 VSS VSS nch l=0.15 w=1 nf=1 m=1
M4 net0 net1 VSS VSS nch l=0.15 w=1 nf=1 m=1
VeqT net2 GND DC 1
.ends dut
