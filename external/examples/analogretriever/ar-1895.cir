* official Analog Canvas netlist; PDK X cards rewritten by convert.py
.model nch nmos
.model pch pmos

.subckt dut VDD VSS Vout
M1 X Vout VSS VSS nch l=0.15 w=1 nf=1 m=1
M2 Y X VSS VSS nch l=0.15 w=1 nf=1 m=1
M3 Z Y VSS VSS nch l=0.15 w=1 nf=1 m=1
M4 Vout Z VSS VSS nch l=0.15 w=1 nf=1 m=1
M5 X Vout VDD VDD pch l=0.15 w=1 nf=1 m=1
M6 Y X VDD VDD pch l=0.15 w=1 nf=1 m=1
M7 Z Y VDD VDD pch l=0.15 w=1 nf=1 m=1
M8 Vout Z VDD VDD pch l=0.15 w=1 nf=1 m=1
.ends dut
