* official Analog Canvas netlist; PDK X cards rewritten by convert.py
.model qnpn npn

.subckt dut VSS vin vout
Q1 vout net1 net0 VSS qnpn m=1
R1 vout VSS 1k
R2 net0 VSS 1k
RB vin net1 1k
RC VSS vout 1k
.ends dut
