* official Analog Canvas netlist; PDK X cards rewritten by convert.py

.subckt dut VSS Vo
G1 Vo VSS net0 VSS 1m
RB net0 VSS 1k
rc Vo VSS 1k
ro Vo VSS 1k
rpi net0 VSS 1k
Vs net0 VSS DC 1
.ends dut
