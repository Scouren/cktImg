* official Analog Canvas netlist; PDK X cards rewritten by convert.py
.model nch nmos
.model pch pmos

.subckt dut VDD VSS GND v1 v2 vo VB1 VB2
CL vo GND 1p
IQ net1 VSS DC 1m
M1 net0 v1 net1 VSS nch l=0.15 w=1 nf=1 m=1
M10 vo VB1 net4 VDD pch l=0.15 w=1 nf=1 m=1
M11 net7 VB2 net6 VSS nch l=0.15 w=1 nf=1 m=1
M12 vo VB2 net5 VSS nch l=0.15 w=1 nf=1 m=1
M2 net2 v2 net1 VSS nch l=0.15 w=1 nf=1 m=1
M3 net0 net0 VDD VDD pch l=0.15 w=1 nf=1 m=1
M4 net2 net2 VDD VDD pch l=0.15 w=1 nf=1 m=1
M5 net3 net0 VDD VDD pch l=0.15 w=1 nf=1 m=1
M6 net4 net2 VDD VDD pch l=0.15 w=1 nf=1 m=1
M7 net6 net6 VSS VSS nch l=0.15 w=1 nf=1 m=1
M8 net5 net6 VSS VSS nch l=0.15 w=1 nf=1 m=1
M9 net7 VB1 net3 VDD pch l=0.15 w=1 nf=1 m=1
.ends dut
