* official Analog Canvas netlist; PDK X cards rewritten by convert.py

.subckt dut VSS vo
E1 net0 VSS vi VSS 1
RF vi vo 1k
ri vi VSS 1k
RL vo VSS 1k
ro net0 vo 1k
RS net1 vi 1k
vs net1 VSS DC 1
.ends dut
