* official Analog Canvas netlist; PDK X cards rewritten by convert.py
.model pch pmos

.subckt dut VDD VSS vO
CC1 net2 net1 1p
M1 VSS net1 vO VDD pch l=0.15 w=1 nf=1 m=1
R1 VDD net1 1k
R2 net1 VSS 1k
RS VDD vO 1k
RSi net0 net2 1k
Vi net0 VSS DC 1
.ends dut
