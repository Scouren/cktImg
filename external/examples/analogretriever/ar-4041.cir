* official Analog Canvas netlist; PDK X cards rewritten by convert.py
.model nch nmos

.subckt dut VDD VSS GND vo
CC vo net1 1p
M1 net1 net0 net2 GND nch l=0.15 w=1 nf=1 m=1
RD VDD net1 6.7kΩ
RG net0 GND 50kΩ
RL vo GND 10kΩ
RS net2 VSS 5kΩ
vi net0 GND DC 1
.ends dut
