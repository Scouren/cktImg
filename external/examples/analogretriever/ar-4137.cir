* official Analog Canvas netlist; PDK X cards rewritten by convert.py
.model nch nmos

.subckt dut VDD VSS GND vo
CC1 net2 net6 1p
CC2 net1 vo 1p
CG net3 GND 1p
CS net5 GND 1p
M1 net4 net6 net5 GND nch l=0.15 w=1 nf=1 m=1
M2 net1 net3 net4 GND nch l=0.15 w=1 nf=1 m=1
R1 VDD net3 179.5kΩ
R2 net3 net6 175kΩ
R3 net6 GND 145.5kΩ
RD VDD net1 3kΩ
Ri net0 net2 2kΩ
RL vo GND 10kΩ
RS net5 VSS 10kΩ
Vi net0 GND DC 1
.ends dut
