* official Analog Canvas netlist; PDK X cards rewritten by convert.py
.model nch nmos
.model pch pmos

.subckt dut VDD VSS Vb
M1 net1 Vb net2 VSS nch l=0.15 w=1 nf=1 m=1
M2 net0 net1 VDD VDD pch l=0.15 w=1 nf=1 m=1
RD VDD net1 1k
RF net2 VSS 1k
RF2 VSS net0 1k
RM net0 VSS 1k
VX net0 VSS DC 1
.ends dut
