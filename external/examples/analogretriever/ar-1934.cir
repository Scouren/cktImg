* official Analog Canvas netlist; PDK X cards rewritten by convert.py

.subckt voltage_amplifier VDD VSS VIN VOUT params: gain=1
ECORE VOUT 0 VIN 0 {gain}
.ends voltage_amplifier

.subckt dut VSS Vout
C1 Vout net1 1p
C2 net1 net2 1p
C3 net0 VSS 1p
R1 net1 VSS 1k
R2 net2 VSS 1k
R3 net2 net0 1k
X1 0 VSS net0 Vout voltage_amplifier gain={-A0}
.ends dut
