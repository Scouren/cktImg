* official Analog Canvas netlist; PDK X cards rewritten by convert.py
.model qnpn npn

.subckt dut VSS
C net1 net0 1p
L1 VSS net0 1n
L2 net1 VSS 1n
Q1 net0 net1 VSS VSS qnpn m=1
R net0 VSS 1k
.ends dut
