* official Analog Canvas netlist; PDK X cards rewritten by convert.py
.model qnpn npn
.model qpnp pnp

.subckt dut VCC VSS vI vO
IREF net0 VSS DC 1m
Q0 vO vI VSS VSS qnpn m=1
Q1 net0 net1 VCC qpnp m=1
Q2 net1 net1 VCC qpnp m=1
Q3 vO net0 net1 qpnp m=1
.ends dut
