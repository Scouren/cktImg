* official Analog Canvas netlist; PDK X cards rewritten by convert.py
.model nch nmos
.model pch pmos

.subckt dut VDD VSS VREF
.model DIODE D(IS=1e-14 N=1)
D1 net3 VSS DIODE
D2 net1 VSS DIODE
D3 net5 VSS DIODE
D4 net14 VSS DIODE
M1 net2 net2 net3 VSS nch l=0.15 w=1 nf=1 m=1
M10 net7 ICTAT VDD VDD pch l=0.15 w=1 nf=1 m=1
M11 net4 net9 VSS VSS nch l=0.15 w=1 nf=1 m=1
M12 net9 net8 VDD VDD pch l=0.15 w=1 nf=1 m=1
M13 net9 ICTAT VDD VDD pch l=0.15 w=1 nf=1 m=1
M14 net4 net4 VDD VDD pch l=0.15 w=1 nf=1 m=1
M15 net11 net13 VSS VSS nch l=0.15 w=1 nf=1 m=1
M16 net13 net0 net14 VSS nch l=0.15 w=1 nf=1 m=1
M17 net0 net0 net15 VSS nch l=0.15 w=1 nf=1 m=1
M18 net11 net11 VDD VDD pch l=0.15 w=1 nf=1 m=1
M19 net13 net4 VDD VDD pch l=0.15 w=1 nf=1 m=1
M2 net8 net2 net6 VSS nch l=0.15 w=1 nf=1 m=1
M20 net0 net11 VDD VDD pch l=0.15 w=1 nf=1 m=1
M21 net10 net10 VSS VSS nch l=0.15 w=1 nf=1 m=1
M22 VREF net10 VSS VSS nch l=0.15 w=1 nf=1 m=1
M23 net10 net11 VDD VDD pch l=0.15 w=1 nf=1 m=1
M24 VREF net8 VDD VDD pch l=0.15 w=1 nf=1 m=1
M25 VREF ICTAT VDD VDD pch l=0.15 w=1 nf=1 m=1
M3 net2 net8 VDD VDD pch l=0.15 w=1 nf=1 m=1
M4 net8 net8 VDD VDD pch l=0.15 w=1 nf=1 m=1
M5 ICTAT net12 VSS VSS nch l=0.15 w=1 nf=1 m=1
M6 net12 net7 net5 VSS nch l=0.15 w=1 nf=1 m=1
M7 net7 net7 net16 VSS nch l=0.15 w=1 nf=1 m=1
M8 ICTAT ICTAT VDD VDD pch l=0.15 w=1 nf=1 m=1
M9 net12 net8 VDD VDD pch l=0.15 w=1 nf=1 m=1
R1 net6 net1 1k
R2 net16 VSS 1k
R3 net9 VSS 1k
R4 net15 VSS 1k
R5 VREF VSS 1k
.ends dut
