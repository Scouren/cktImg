* official Analog Canvas netlist; PDK X cards rewritten by convert.py
.model nch nmos
.model pch pmos

.subckt dut VDD VSS VIN VREF VB4 VB3 VB5 VOUT
CF1 VOUT VFB 1p
Cm1 net5 VOUT 1p
Cm2 net5 net3 1p
M11 net8 VB6 VSS VSS nch l=0.15 w=1 nf=1 m=1
M12 VX VFB net8 VSS nch l=0.15 w=1 nf=1 m=1
M13 VY VREF net8 VSS nch l=0.15 w=1 nf=1 m=1
M14 VX VX VIN VDD pch l=0.15 w=1 nf=1 m=1
M15 VY VY VIN VDD pch l=0.15 w=1 nf=1 m=1
M16 VY VB4 VIN VDD pch l=0.15 w=1 nf=1 m=1
M17 VY net5 VSS VSS nch l=0.15 w=1 nf=1 m=1
M18 VY VY VSS VSS nch l=0.15 w=1 nf=1 m=1
M21 net6 net5 VSS VSS nch l=0.15 w=1 nf=1 m=1
M22 net2 VY VSS VSS nch l=0.15 w=1 nf=1 m=1
M23 net6 net6 VIN VDD pch l=0.15 w=1 nf=1 m=1
M24 net2 net6 VIN VDD pch l=0.15 w=1 nf=1 m=1
M25 net5 VX VIN VDD pch l=0.15 w=1 nf=1 m=1
M26 net4 VY VIN VDD pch l=0.15 w=1 nf=1 m=1
M27 net4 net4 VSS VSS nch l=0.15 w=1 nf=1 m=1
M28 net5 net4 VSS VSS nch l=0.15 w=1 nf=1 m=1
M29 VB6 net0 VIN VDD pch l=0.15 w=1 nf=1 m=1
M30 net0 net0 VIN VDD pch l=0.15 w=1 nf=1 m=1
M31 net1 net0 VIN VDD pch l=0.15 w=1 nf=1 m=1
M32 VB2 net0 VIN VDD pch l=0.15 w=1 nf=1 m=1
M33 VB6 VB6 VSS VSS nch l=0.15 w=1 nf=1 m=1
M34 net0 VB2 VB1 VSS nch l=0.15 w=1 nf=1 m=1
M35 VB1 net1 VSS VSS nch l=0.15 w=1 nf=1 m=1
M36 net1 net1 VSS VSS nch l=0.15 w=1 nf=1 m=1
M37 VB2 VB1 VSS VSS nch l=0.15 w=1 nf=1 m=1
MD1 net3 net5 VSS VSS nch l=0.15 w=1 nf=1 m=1
MD2 net7 VB5 VSS VSS nch l=0.15 w=1 nf=1 m=1
MD3 net9 net3 net7 VSS nch l=0.15 w=1 nf=1 m=1
MD4 VX VB3 net7 VSS nch l=0.15 w=1 nf=1 m=1
MD5 net3 VX VIN VDD pch l=0.15 w=1 nf=1 m=1
MD6 net9 net9 VIN VDD pch l=0.15 w=1 nf=1 m=1
MD7 VX VX VIN VDD pch l=0.15 w=1 nf=1 m=1
MPT VOUT net2 VIN VDD pch l=0.15 w=1 nf=1 m=1
RF1 VOUT VFB 1k
RF2 VFB VSS 1k
.ends dut
