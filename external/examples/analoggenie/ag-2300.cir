* official Analog Canvas netlist; PDK X cards rewritten by convert.py
.model nch nmos
.model pch pmos

.subckt dut VDD VSS VREF VB2 VB1 VB3 VB4 IBUF VIN VOUT
CL VOUT net7 1p
M1 net5 net5 VDD VDD pch l=0.15 w=1 nf=1 m=1
M10 EAO VB3 net10 VDD pch l=0.15 w=1 nf=1 m=1
M11 net4 VB1 VDD VDD pch l=0.15 w=1 nf=1 m=1
M12 net10 VB1 VDD VDD pch l=0.15 w=1 nf=1 m=1
M13 net0 VB4 VDD VDD pch l=0.15 w=1 nf=1 m=1
M14 net9 EAO net0 VDD pch l=0.15 w=1 nf=1 m=1
M15 net9 net9 VSS VSS nch l=0.15 w=1 nf=1 m=1
M16 GATE net9 VSS VSS nch l=0.15 w=1 nf=1 m=1
M17 VDD net0 GATE VSS nch l=0.15 w=1 nf=1 m=1
M18 net6 EAO IBUF VSS nch l=0.15 w=1 nf=1 m=1
M19 net6 net6 VDD VDD pch l=0.15 w=1 nf=1 m=1
M2 net8 VB2 VSS VSS nch l=0.15 w=1 nf=1 m=1
M20 GATE net6 VDD VDD pch l=0.15 w=1 nf=1 m=1
M21 VSS IBUF GATE VDD pch l=0.15 w=1 nf=1 m=1
M22 VB5 net5 VDD VDD pch l=0.15 w=1 nf=1 m=1
M23 VB5 VB5 net2 VSS nch l=0.15 w=1 nf=1 m=1
M24 net2 VB5 VSS VSS nch l=0.15 w=1 nf=1 m=1
M25 VIN GATE VOUT VSS nch l=0.15 w=1 nf=1 m=1
M3 net10 VREF net8 VSS nch l=0.15 w=1 nf=1 m=1
M4 net4 FB net8 VSS nch l=0.15 w=1 nf=1 m=1
M5 net1 net3 VSS VSS nch l=0.15 w=1 nf=1 m=1
M6 net11 net3 VSS VSS nch l=0.15 w=1 nf=1 m=1
M7 net3 VB5 net1 VSS nch l=0.15 w=1 nf=1 m=1
M8 EAO VB5 net11 VSS nch l=0.15 w=1 nf=1 m=1
M9 net3 VB3 net4 VDD pch l=0.15 w=1 nf=1 m=1
R1 FB VSS 1k
R2 VOUT FB 1k
R3 net7 VSS 1k
RB net5 VSS 1k
RL VOUT VSS 1k
.ends dut
