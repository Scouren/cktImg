* official Analog Canvas netlist; PDK X cards rewritten by convert.py
.model nch nmos
.model pch pmos

.subckt bias VDD VSS VIN VB1 VBN
M27 net0 net0 VIN VDD pch l=0.15 w=1 nf=1 m=1
M28 VBN net0 VIN VDD pch l=0.15 w=1 nf=1 m=1
M29 VB1 VB1 VIN VDD pch l=0.15 w=1 nf=1 m=1
M30 VBN VBN VSS VSS nch l=0.15 w=1 nf=1 m=1
M31 VB1 VBN VSS VSS nch l=0.15 w=1 nf=1 m=1
R1 net0 VSS 1k
.ends bias

.subckt dut VDD VSS VB4 VB2 VB3 VOUT VIN VB1
CF1 VOUT VFB 1p
Cm1 VOUT V1 1p
Cm2 net3 V1 1p
M11 net6 VBN VSS VSS nch l=0.15 w=1 nf=1 m=1
M12 VY VFB net6 VSS nch l=0.15 w=1 nf=1 m=1
M13 VX VREF net6 VSS nch l=0.15 w=1 nf=1 m=1
M14 net0 net0 VSS VSS nch l=0.15 w=1 nf=1 m=1
M15 V1 net0 VSS VSS nch l=0.15 w=1 nf=1 m=1
M16 VX VB4 VIN VDD pch l=0.15 w=1 nf=1 m=1
M17 VX VX VSS VSS nch l=0.15 w=1 nf=1 m=1
M18 VX V1 VSS VSS nch l=0.15 w=1 nf=1 m=1
M19 VX VX VIN VDD pch l=0.15 w=1 nf=1 m=1
M20 VY VY VIN VDD pch l=0.15 w=1 nf=1 m=1
M21 net2 V1 VSS VSS nch l=0.15 w=1 nf=1 m=1
M22 net4 VX VSS VSS nch l=0.15 w=1 nf=1 m=1
M23 net2 net2 VIN VDD pch l=0.15 w=1 nf=1 m=1
M24 net4 net2 VIN VDD pch l=0.15 w=1 nf=1 m=1
M25 net0 VX VIN VDD pch l=0.15 w=1 nf=1 m=1
M26 V1 VY VIN VDD pch l=0.15 w=1 nf=1 m=1
MD1 net3 V1 VSS VSS nch l=0.15 w=1 nf=1 m=1
MD2 net1 VB2 VSS VSS nch l=0.15 w=1 nf=1 m=1
MD3 net5 net3 net1 VSS nch l=0.15 w=1 nf=1 m=1
MD4 VY VB3 net1 VSS nch l=0.15 w=1 nf=1 m=1
MD5 net3 VY VIN VDD pch l=0.15 w=1 nf=1 m=1
MD6 net5 net5 VIN VDD pch l=0.15 w=1 nf=1 m=1
MD7 VY VY VIN VDD pch l=0.15 w=1 nf=1 m=1
MPT VOUT net4 VIN VDD pch l=0.15 w=1 nf=1 m=1
RF1 VOUT VFB 1k
RF2 VFB VSS 1k
X1 VDD VSS VIN VB1 VBN bias
.ends dut
