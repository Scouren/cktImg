* official Analog Canvas netlist; PDK X cards rewritten by convert.py
.model nch nmos
.model pch pmos

.subckt dut VDD VSS vci phi1 phi2 vco
C1 net9 net5 1p
C2 net2 vco 1p
M1 vci phi1 net9 VSS nch l=0.15 w=1 nf=1 m=1
M10 vco net6 VDD VDD pch l=0.15 w=1 nf=1 m=1
M11 net3 net3 VSS VSS nch l=0.15 w=1 nf=1 m=1
M12 vco net3 VSS VSS nch l=0.15 w=1 nf=1 m=1
M13 net8 VB3 VSS VSS nch l=0.15 w=1 nf=1 m=1
M14 VB3 VB1 VDD VDD pch l=0.15 w=1 nf=1 m=1
M15 VB1 VB1 VDD VDD pch l=0.15 w=1 nf=1 m=1
M16 net4 net0 VDD VDD pch l=0.15 w=1 nf=1 m=1
M17 net0 net0 VDD VDD pch l=0.15 w=1 nf=1 m=1
M18 VB2 net0 VDD VDD pch l=0.15 w=1 nf=1 m=1
M19 VB3 VB3 VSS VSS nch l=0.15 w=1 nf=1 m=1
M2 net9 phi2 VSS VSS nch l=0.15 w=1 nf=1 m=1
M20 VB1 net4 VSS VSS nch l=0.15 w=1 nf=1 m=1
M21 net4 net4 VSS VSS nch l=0.15 w=1 nf=1 m=1
M22 net0 VB2 net7 VSS nch l=0.15 w=1 nf=1 m=1
M23 VB2 VB2 VSS VSS nch l=0.15 w=1 nf=1 m=1
M3 net5 phi1 VSS VSS nch l=0.15 w=1 nf=1 m=1
M4 net5 phi2 net2 VSS nch l=0.15 w=1 nf=1 m=1
M5 net1 net2 net8 VSS nch l=0.15 w=1 nf=1 m=1
M6 net6 VSS net8 VSS nch l=0.15 w=1 nf=1 m=1
M7 net1 net1 VDD VDD pch l=0.15 w=1 nf=1 m=1
M8 net6 net6 VDD VDD pch l=0.15 w=1 nf=1 m=1
M9 net3 net1 VDD VDD pch l=0.15 w=1 nf=1 m=1
R1 net7 VSS 1k
.ends dut
