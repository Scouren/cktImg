* official Analog Canvas netlist; PDK X cards rewritten by convert.py
.model nch nmos
.model pch pmos

.subckt dut VDD VSS VB1 VREF VB3 VB2 VB4 VB6 VB5 VOUT VIN
CF1 VOUT VFB 1p
Cm1 net6 VOUT 1p
Cm2 net6 net9 1p
M11 net7 VB2 VSS VSS nch l=0.15 w=1 nf=1 m=1
M12 net8 VFB net7 VSS nch l=0.15 w=1 nf=1 m=1
M13 VX VREF net7 VSS nch l=0.15 w=1 nf=1 m=1
M14 net12 net13 VSS VSS nch l=0.15 w=1 nf=1 m=1
M15 net2 net13 VSS VSS nch l=0.15 w=1 nf=1 m=1
M16 net11 VB4 VIN VDD pch l=0.15 w=1 nf=1 m=1
M17 net11 net6 VSS VSS nch l=0.15 w=1 nf=1 m=1
M18 net11 net11 VSS VSS nch l=0.15 w=1 nf=1 m=1
M21 net0 net6 VSS VSS nch l=0.15 w=1 nf=1 m=1
M22 net10 net11 VSS VSS nch l=0.15 w=1 nf=1 m=1
M23 net0 net0 VIN VDD pch l=0.15 w=1 nf=1 m=1
M24 net10 net0 VIN VDD pch l=0.15 w=1 nf=1 m=1
M31 VX VB1 VIN VDD pch l=0.15 w=1 nf=1 m=1
M32 net8 VB1 VIN VDD pch l=0.15 w=1 nf=1 m=1
M33 net13 VB3 VX VDD pch l=0.15 w=1 nf=1 m=1
M34 net6 VB3 net8 VDD pch l=0.15 w=1 nf=1 m=1
M35 net13 VB7 net12 VSS nch l=0.15 w=1 nf=1 m=1
M36 net6 VB7 net2 VSS nch l=0.15 w=1 nf=1 m=1
M41 VB7 net4 VIN VDD pch l=0.15 w=1 nf=1 m=1
M42 net4 net4 VIN VDD pch l=0.15 w=1 nf=1 m=1
M43 VB7 VB7 net1 VSS nch l=0.15 w=1 nf=1 m=1
M44 net1 VB7 VSS VSS nch l=0.15 w=1 nf=1 m=1
MD1 net9 net6 VSS VSS nch l=0.15 w=1 nf=1 m=1
MD2 net3 VB5 VSS VSS nch l=0.15 w=1 nf=1 m=1
MD3 VX net9 net3 VSS nch l=0.15 w=1 nf=1 m=1
MD4 net5 VB6 net3 VSS nch l=0.15 w=1 nf=1 m=1
MD5 net9 net5 VIN VDD pch l=0.15 w=1 nf=1 m=1
MD6 net5 net5 VIN VDD pch l=0.15 w=1 nf=1 m=1
MD7 VX VX VIN VDD pch l=0.15 w=1 nf=1 m=1
MPT VOUT net10 VIN VDD pch l=0.15 w=1 nf=1 m=1
R1 net4 VSS 1k
RF1 VOUT VFB 1k
RF2 VFB VSS 1k
.ends dut
