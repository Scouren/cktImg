* official Analog Canvas netlist; PDK X cards rewritten by convert.py
.model nch nmos

.subckt dut VDD VSS VB
I1 VDD VB DC 1m
M1 VB VB VSS VSS nch l=1 w=10 nf=1 m=1
M2 VDD VB VSS VSS nch l=1 w=10 nf=1 m=1
M3 VDD VB VSS VSS nch l=1 w=10 nf=1 m=1
M4 VDD VB VSS VSS nch l=1 w=10 nf=1 m=1
.ends dut
