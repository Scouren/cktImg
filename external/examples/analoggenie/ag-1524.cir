* official Analog Canvas netlist; PDK X cards rewritten by convert.py
.model nch nmos
.model pch pmos
.model qnpn npn

.subckt A1 VDD VSS INP INN OUT VC
M1 net2 INP net3 VSS nch l=0.15 w=1 nf=1 m=1
M10 VC VC VDD VDD pch l=0.15 w=1 nf=1 m=1
M11 VC net1 VSS VSS nch l=0.15 w=1 nf=1 m=1
M12 net1 VC VDD VDD pch l=0.15 w=1 nf=1 m=1
M13 net1 net1 VSS VSS nch l=0.15 w=1 nf=1 m=1
M14 VB1 VB1 VDD VDD pch l=0.15 w=1 nf=1 m=1
M15 VB1 net1 VSS VSS nch l=0.15 w=1 nf=1 m=1
M16 VB2 VB1 VDD VDD pch l=0.15 w=1 nf=1 m=1
M17 VB2 VB2 VSS VSS nch l=0.15 w=1 nf=1 m=1
M2 net0 INN net3 VSS nch l=0.15 w=1 nf=1 m=1
M3 net2 net2 VDD VDD pch l=0.15 w=1 nf=1 m=1
M4 net0 net0 VDD VDD pch l=0.15 w=1 nf=1 m=1
M5 net3 VB2 VSS VSS nch l=0.15 w=1 nf=1 m=1
M6 OUT net2 VDD VDD pch l=0.15 w=1 nf=1 m=1
M7 VC net0 VDD VDD pch l=0.15 w=1 nf=1 m=1
M8 OUT VC VSS VSS nch l=0.15 w=1 nf=1 m=1
M9 VC VC VSS VSS nch l=0.15 w=1 nf=1 m=1
RF VDD net1 1k
.ends A1

.subckt dut VDD VSS Vout
Q1 X X VSS VSS qnpn m=1
Q2 net0 net0 VSS VSS qnpn m=1
R1 Vout X 1k
R2 Vout Y 1k
R3 Y net0 1k
X1 VDD VSS X Y Vout net0 A1
.ends dut
