* official Analog Canvas netlist; PDK X cards rewritten by convert.py
.model nch nmos
.model pch pmos

.subckt comparator VDD VSS INN OUT
M10 OUT OUT net2 VSS nch l=0.15 w=1 nf=1 m=1
M11 OUT net3 VSS VSS nch l=0.15 w=1 nf=1 m=1
M12 net3 net3 VSS VSS nch l=0.15 w=1 nf=1 m=1
M13 net2 VB2 VSS VSS nch l=0.15 w=1 nf=1 m=1
M14 net0 net0 net4 VSS nch l=0.15 w=1 nf=1 m=1
M15 net1 net0 VSS VSS nch l=0.15 w=1 nf=1 m=1
M16 net1 net1 VDD VDD pch l=0.15 w=1 nf=1 m=1
M17 VB2 net1 VDD VDD pch l=0.15 w=1 nf=1 m=1
M18 VB2 VB2 VSS VSS nch l=0.15 w=1 nf=1 m=1
M19 VB1 VB2 VSS VSS nch l=0.15 w=1 nf=1 m=1
M20 VB1 VB1 VDD VDD pch l=0.15 w=1 nf=1 m=1
M5 VX VX VDD VDD pch l=0.15 w=1 nf=1 m=1
M6 OUT OUT VDD VDD pch l=0.15 w=1 nf=1 m=1
M7 OUT OUT VDD VDD pch l=0.15 w=1 nf=1 m=1
M8 net3 VX VDD VDD pch l=0.15 w=1 nf=1 m=1
M9 VX INN net2 VSS nch l=0.15 w=1 nf=1 m=1
R1 VDD net0 1k
R2 net4 VSS 1k
.ends comparator

.subckt dut VDD VSS VSTO VCONT2 VCONT3 VCONT1 VOUT
CL VOUT VSS 1p
CSTO VSTO VSS 1p
LRX net0 net2 1n
MN1 net0 VCONT2 VSS VSS nch l=0.15 w=1 nf=1 m=1
MN2 net2 VCONT3 VSS VSS nch l=0.15 w=1 nf=1 m=1
MP2 net2 net1 VOUT VDD pch l=0.15 w=1 nf=1 m=1
MP3 net0 VCONT1 VSTO VDD pch l=0.15 w=1 nf=1 m=1
X1 VDD VSS net2 net1 comparator
.ends dut
