* official Analog Canvas netlist; PDK X cards rewritten by convert.py
.model nch nmos
.model pch pmos

.subckt dut VDD VSS vci phi1 phi2 vco
C1 net1 net5 1p
C2 net0 vco 1p
M1 vci phi1 net1 VSS nch l=0.15 w=1 nf=1 m=1
M10 net3 net0 net6 VSS nch l=0.15 w=1 nf=1 m=1
M11 net4 VSS net6 VSS nch l=0.15 w=1 nf=1 m=1
M12 net6 VB1 VSS VSS nch l=0.15 w=1 nf=1 m=1
M13 vco VX VSS VSS nch l=0.15 w=1 nf=1 m=1
M14 net2 net2 VDD VDD pch l=0.15 w=1 nf=1 m=1
M15 VB1 net2 VDD VDD pch l=0.15 w=1 nf=1 m=1
M16 VB1 VB1 VSS VSS nch l=0.15 w=1 nf=1 m=1
M2 net1 phi2 VSS VSS nch l=0.15 w=1 nf=1 m=1
M3 net5 phi1 VSS VSS nch l=0.15 w=1 nf=1 m=1
M4 net5 phi2 net0 VSS nch l=0.15 w=1 nf=1 m=1
M5 VX net3 VDD VDD pch l=0.15 w=1 nf=1 m=1
M6 net3 net3 VDD VDD pch l=0.15 w=1 nf=1 m=1
M7 net4 net4 VDD VDD pch l=0.15 w=1 nf=1 m=1
M8 vco net4 VDD VDD pch l=0.15 w=1 nf=1 m=1
M9 VX VX VSS VSS nch l=0.15 w=1 nf=1 m=1
R1 net2 VSS 1k
.ends dut
