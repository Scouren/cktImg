* official Analog Canvas netlist; PDK X cards rewritten by convert.py
.model nch nmos
.model pch pmos

.subckt comparator VDD VSS INN OUT
M10 net1 VA VDD VDD pch l=0.15 w=1 nf=1 m=1
M11 net1 net1 VSS VSS nch l=0.15 w=1 nf=1 m=1
M12 net3 VBN VSS VSS nch l=0.15 w=1 nf=1 m=1
M13 VBN VB1 VDD VDD pch l=0.15 w=1 nf=1 m=1
M14 VBN VBN VSS VSS nch l=0.15 w=1 nf=1 m=1
M15 VB1 VB1 VDD VDD pch l=0.15 w=1 nf=1 m=1
M16 VB1 net4 VSS VSS nch l=0.15 w=1 nf=1 m=1
M17 net4 net0 VDD VDD pch l=0.15 w=1 nf=1 m=1
M18 net4 net4 VSS VSS nch l=0.15 w=1 nf=1 m=1
M19 net0 net0 VDD VDD pch l=0.15 w=1 nf=1 m=1
M20 net0 VB2 net2 VSS nch l=0.15 w=1 nf=1 m=1
M21 VB2 net0 VDD VDD pch l=0.15 w=1 nf=1 m=1
M22 VB2 VB2 VSS VSS nch l=0.15 w=1 nf=1 m=1
M4 VA VA VDD VDD pch l=0.15 w=1 nf=1 m=1
M5 VA INN net3 VSS nch l=0.15 w=1 nf=1 m=1
M6 OUT OUT VDD VDD pch l=0.15 w=1 nf=1 m=1
M7 OUT OUT net3 VSS nch l=0.15 w=1 nf=1 m=1
M8 OUT OUT VDD VDD pch l=0.15 w=1 nf=1 m=1
M9 OUT net1 VSS VSS nch l=0.15 w=1 nf=1 m=1
R1 net2 VSS 1k
.ends comparator

.subckt dut VDD VSS VSTO VCONT1 VCONT3 VOUT VCONT2
C1 VSTO VSS 1p
C2 VOUT VSS 1p
L1 net2 net0 1n
M1 net2 VCONT1 VSTO VDD pch l=0.15 w=1 nf=1 m=1
M2 net0 net1 VOUT VDD pch l=0.15 w=1 nf=1 m=1
M3 net2 VCONT2 VSS VSS nch l=0.15 w=1 nf=1 m=1
M4 net0 VCONT3 VSS VSS nch l=0.15 w=1 nf=1 m=1
X1 VDD VSS net0 net1 comparator
.ends dut
