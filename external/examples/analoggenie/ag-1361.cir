* official Analog Canvas netlist; PDK X cards rewritten by convert.py
.model nch nmos
.model pch pmos

.subckt comparator VDD VSS VB1 VX INM VB2 OUT VB3
M1 net2 net3 VDD VDD pch l=0.15 w=1 nf=1 m=1
M10 net3 INM net11 VSS nch l=0.15 w=1 nf=1 m=1
M11 net6 OUT net11 VSS nch l=0.15 w=1 nf=1 m=1
M12 OUT VBN net4 VSS nch l=0.15 w=1 nf=1 m=1
M13 net9 VX VSS VSS nch l=0.15 w=1 nf=1 m=1
M14 net11 VB2 VSS VSS nch l=0.15 w=1 nf=1 m=1
M15 net4 VX VSS VSS nch l=0.15 w=1 nf=1 m=1
M16 VBP VBP VDD VDD pch l=0.15 w=1 nf=1 m=1
M17 net7 VBP VDD VDD pch l=0.15 w=1 nf=1 m=1
M18 VB3 VBP VDD VDD pch l=0.15 w=1 nf=1 m=1
M19 VBN VBP VDD VDD pch l=0.15 w=1 nf=1 m=1
M2 net5 net3 VDD VDD pch l=0.15 w=1 nf=1 m=1
M20 VBP VB3 net8 VSS nch l=0.15 w=1 nf=1 m=1
M21 net8 net7 VSS VSS nch l=0.15 w=1 nf=1 m=1
M22 net7 net7 VSS VSS nch l=0.15 w=1 nf=1 m=1
M23 VB3 VB3 VSS VSS nch l=0.15 w=1 nf=1 m=1
M24 VBN VBN net10 VSS nch l=0.15 w=1 nf=1 m=1
M25 net10 VBN VSS VSS nch l=0.15 w=1 nf=1 m=1
M3 net1 net6 VDD VDD pch l=0.15 w=1 nf=1 m=1
M4 net0 net6 VDD VDD pch l=0.15 w=1 nf=1 m=1
M5 VX VB1 net2 VDD pch l=0.15 w=1 nf=1 m=1
M6 net3 VB1 net5 VDD pch l=0.15 w=1 nf=1 m=1
M7 net6 VB1 net1 VDD pch l=0.15 w=1 nf=1 m=1
M8 OUT VB1 net0 VDD pch l=0.15 w=1 nf=1 m=1
M9 VX VBN net9 VSS nch l=0.15 w=1 nf=1 m=1
.ends comparator

.subckt dut VDD VSS VSTO VCONT1 VCONT2 VCONT3 VOUT VB1 VB2 VB3
CL VOUT VSS 1p
CSTO VSTO VSS 1p
LRX VX net1 1n
MN1 VX VCONT2 VSS VSS nch l=0.15 w=1 nf=1 m=1
MN2 net1 VCONT3 VSS VSS nch l=0.15 w=1 nf=1 m=1
MP2 net1 net0 VOUT VDD pch l=0.15 w=1 nf=1 m=1
MP3 VX VCONT1 VSTO VDD pch l=0.15 w=1 nf=1 m=1
X1 VDD VSS VB1 VX net1 VB2 net0 VB3 comparator
.ends dut
