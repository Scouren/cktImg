* official Analog Canvas netlist; PDK X cards rewritten by convert.py
.model nch nmos
.model pch pmos

.subckt dut VDD VSS VIN VC5 VC1 VC2 VC3 VC4 VP VREF VB2 VB1
.model DIODE D(IS=1e-14 N=1)
CFLY VX1 VX2 1p
CO VP VN 1p
COP VP VSS 1p
D1 VN VX2 DIODE
L1 VX1 VX3 1n
M1 VS VC5 VIN VDD pch l=0.15 w=1 nf=1 m=1
M2 VX1 VC1 VIN VDD pch l=0.15 w=1 nf=1 m=1
M3 VX2 VC2 VIN VDD pch l=0.15 w=1 nf=1 m=1
M4 VP VC3 VX3 VDD pch l=0.15 w=1 nf=1 m=1
M5 VX3 VC4 VSS VSS nch l=0.15 w=1 nf=1 m=1
MN1 net3 VFP1 net4 VSS nch l=0.15 w=1 nf=1 m=1
MN10 net0 net2 VSS VSS nch l=0.15 w=1 nf=1 m=1
MN11 net2 VB2 VSS VSS nch l=0.15 w=1 nf=1 m=1
MN2 VX3 VREF net4 VSS nch l=0.15 w=1 nf=1 m=1
MN3 VB3 VB3 VSS VSS nch l=0.15 w=1 nf=1 m=1
MN4 net4 VB3 VSS VSS nch l=0.15 w=1 nf=1 m=1
MN5 net5 net5 VSS VSS nch l=0.15 w=1 nf=1 m=1
MN6 VCTRL net5 VSS VSS nch l=0.15 w=1 nf=1 m=1
MN7 VB1 VB1 VSS VSS nch l=0.15 w=1 nf=1 m=1
MN8 net1 VB1 VX2 VSS nch l=0.15 w=1 nf=1 m=1
MN9 net2 net2 VSS VSS nch l=0.15 w=1 nf=1 m=1
MP1 net5 net3 VDD VDD pch l=0.15 w=1 nf=1 m=1
MP10 VX1 net0 VS VDD pch l=0.15 w=1 nf=1 m=1
MP2 net3 net3 VDD VDD pch l=0.15 w=1 nf=1 m=1
MP3 VX3 VX3 VDD VDD pch l=0.15 w=1 nf=1 m=1
MP4 VCTRL VX3 VDD VDD pch l=0.15 w=1 nf=1 m=1
MP5 VB3 net1 VDD VDD pch l=0.15 w=1 nf=1 m=1
MP6 net1 net1 VDD VDD pch l=0.15 w=1 nf=1 m=1
MP7 VB1 net1 VDD VDD pch l=0.15 w=1 nf=1 m=1
MP8 net2 VCTRL VS VDD pch l=0.15 w=1 nf=1 m=1
MP9 net0 net0 VS VDD pch l=0.15 w=1 nf=1 m=1
R1 VP VFP1 1k
R2 VFP1 VSS 1k
RBIAS VX2 VSS 1k
.ends dut
