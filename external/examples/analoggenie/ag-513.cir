* official Analog Canvas netlist; PDK X cards rewritten by convert.py
.model nch nmos

.subckt dut VDD VSS LO VBB Vout1 Vout2
C1 net1 net0 1p
L1 VDD Vout1 1n
L2 VDD Vout2 1n
M1 Vout1 net0 VSS VSS nch l=0.15 w=1 nf=1 m=1
M2 Vout2 NC0001 VSS VSS nch l=0.15 w=1 nf=1 m=1
M5 net1 LO VBB VSS nch l=0.15 w=1 nf=1 m=1
.ends dut
