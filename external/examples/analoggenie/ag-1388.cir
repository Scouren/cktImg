* official Analog Canvas netlist; PDK X cards rewritten by convert.py
.model nch nmos
.model pch pmos

.subckt dut VDD VSS VSTO VCONT1 VCONT2 VCONT3 VOUT
CL VOUT VSS 1p
CSTO VSTO VSS 1p
LRX VX VY 1n
M1 net2 VY VX VSS nch l=0.15 w=1 nf=1 m=1
M10 net3 net4 VSS VSS nch l=0.15 w=1 nf=1 m=1
M11 net5 net4 VSS VSS nch l=0.15 w=1 nf=1 m=1
M12 net1 VB5 VSS VSS nch l=0.15 w=1 nf=1 m=1
M13 VB5 VP VDD VDD pch l=0.15 w=1 nf=1 m=1
M14 VB5 VB5 net1 VSS nch l=0.15 w=1 nf=1 m=1
M15 VB4 VB4 VSS VSS nch l=0.15 w=1 nf=1 m=1
M16 VB4 VP VDD VDD pch l=0.15 w=1 nf=1 m=1
M17 VP VB4 net7 VSS nch l=0.15 w=1 nf=1 m=1
M18 VP VP VDD VDD pch l=0.15 w=1 nf=1 m=1
M19 net7 net6 VSS VSS nch l=0.15 w=1 nf=1 m=1
M2 net0 VB1 VDD VDD pch l=0.15 w=1 nf=1 m=1
M20 net6 net6 VSS VSS nch l=0.15 w=1 nf=1 m=1
M21 net6 VP VDD VDD pch l=0.15 w=1 nf=1 m=1
M3 net2 VB1 VDD VDD pch l=0.15 w=1 nf=1 m=1
M4 net0 VG VX VSS nch l=0.15 w=1 nf=1 m=1
M5 VX VB2 VSS VSS nch l=0.15 w=1 nf=1 m=1
M6 VG VB3 net0 VDD pch l=0.15 w=1 nf=1 m=1
M7 net4 VB3 net2 VDD pch l=0.15 w=1 nf=1 m=1
M8 VG VB5 net3 VSS nch l=0.15 w=1 nf=1 m=1
M9 net4 VB5 net5 VSS nch l=0.15 w=1 nf=1 m=1
MN1 VX VCONT2 VSS VSS nch l=0.15 w=1 nf=1 m=1
MN2 VY VCONT3 VSS VSS nch l=0.15 w=1 nf=1 m=1
MP2 VY VG VOUT VDD pch l=0.15 w=1 nf=1 m=1
MP3 VX VCONT1 VSTO VDD pch l=0.15 w=1 nf=1 m=1
.ends dut
