* official Analog Canvas netlist; PDK X cards rewritten by convert.py
.model nch nmos
.model pch pmos
.model qpnp pnp

.subckt opamp VDD VSS INN INP VB1 VB2 VB3 OUT
M1 net1 VB1 VDD VDD pch l=0.15 w=1 nf=1 m=1
M10 net3 VM VSS VSS nch l=0.15 w=1 nf=1 m=1
M11 net2 VM VSS VSS nch l=0.15 w=1 nf=1 m=1
M12 VM net4 VDD VDD pch l=0.15 w=1 nf=1 m=1
M13 net4 net4 VDD VDD pch l=0.15 w=1 nf=1 m=1
M14 VC net4 VDD VDD pch l=0.15 w=1 nf=1 m=1
M15 net4 VM VB4 VSS nch l=0.15 w=1 nf=1 m=1
M16 VM VB4 VSS VSS nch l=0.15 w=1 nf=1 m=1
M17 VC VC net0 VSS nch l=0.15 w=1 nf=1 m=1
M18 net0 VC VSS VSS nch l=0.15 w=1 nf=1 m=1
M2 net6 VB1 VDD VDD pch l=0.15 w=1 nf=1 m=1
M3 VM VB3 net1 VDD pch l=0.15 w=1 nf=1 m=1
M4 OUT VB3 net6 VDD pch l=0.15 w=1 nf=1 m=1
M5 net1 INN net5 VSS nch l=0.15 w=1 nf=1 m=1
M6 net6 INP net5 VSS nch l=0.15 w=1 nf=1 m=1
M7 net5 VB2 VSS VSS nch l=0.15 w=1 nf=1 m=1
M8 VM VC net3 VSS nch l=0.15 w=1 nf=1 m=1
M9 OUT VC net2 VSS nch l=0.15 w=1 nf=1 m=1
R4 VB4 VSS 1k
.ends opamp

.subckt dut VDD VSS Vout VB1 VB2 VB3
Q1 VSS VSS X qpnp m=1
Q2 VSS VSS net0 qpnp m=1
R1 Vout X 1k
R2 Vout Y 1k
R3 Y net0 1k
X1 VDD VSS Y X VB1 VB2 VB3 Vout opamp
.ends dut
