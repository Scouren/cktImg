* official Analog Canvas netlist; PDK X cards rewritten by convert.py
.model nch nmos
.model pch pmos

.subckt dut VDD VSS VSTO VCONT1 VCONT2 VCONT3 VOUT
CL VOUT VSS 1p
CSTO VSTO VSS 1p
LRX net3 VX 1n
M10 VG VG VDD VDD pch l=0.15 w=1 nf=1 m=1
M11 net1 VX net5 VSS nch l=0.15 w=1 nf=1 m=1
M12 VG VG net5 VSS nch l=0.15 w=1 nf=1 m=1
M13 net5 VB2 VSS VSS nch l=0.15 w=1 nf=1 m=1
M14 net4 net4 VSS VSS nch l=0.15 w=1 nf=1 m=1
M15 VG net4 VSS VSS nch l=0.15 w=1 nf=1 m=1
M16 net6 net6 VDD VDD pch l=0.15 w=1 nf=1 m=1
M17 net0 net6 VDD VDD pch l=0.15 w=1 nf=1 m=1
M18 net2 net2 VDD VDD pch l=0.15 w=1 nf=1 m=1
M19 VB2 net2 VDD VDD pch l=0.15 w=1 nf=1 m=1
M20 net0 net0 VSS VSS nch l=0.15 w=1 nf=1 m=1
M21 net2 net0 VSS VSS nch l=0.15 w=1 nf=1 m=1
M22 VB2 VB2 VSS VSS nch l=0.15 w=1 nf=1 m=1
M7 net4 net1 VDD VDD pch l=0.15 w=1 nf=1 m=1
M8 net1 net1 VDD VDD pch l=0.15 w=1 nf=1 m=1
M9 VG VG VDD VDD pch l=0.15 w=1 nf=1 m=1
MN1 net3 VCONT2 VSS VSS nch l=0.15 w=1 nf=1 m=1
MN2 VX VCONT3 VSS VSS nch l=0.15 w=1 nf=1 m=1
MP2 VX VG VOUT VDD pch l=0.15 w=1 nf=1 m=1
MP3 net3 VCONT1 VSTO VDD pch l=0.15 w=1 nf=1 m=1
R1 net6 VSS 1k
.ends dut
