* official Analog Canvas netlist; PDK X cards rewritten by convert.py
.model nch nmos
.model pch pmos

.subckt opamp VDD VSS vn vp vo VB3
M10 net0 vn VDD VDD pch l=0.15 w=1 nf=1 m=1
M11 net0 net0 VSS VSS nch l=0.15 w=1 nf=1 m=1
M3 vn net2 VDD VDD pch l=0.15 w=1 nf=1 m=1
M4 net1 net2 VDD VDD pch l=0.15 w=1 nf=1 m=1
M5 vn vn net3 VSS nch l=0.15 w=1 nf=1 m=1
M6 net1 vp net3 VSS nch l=0.15 w=1 nf=1 m=1
M7 net3 VB3 VSS VSS nch l=0.15 w=1 nf=1 m=1
M8 vo net1 VDD VDD pch l=0.15 w=1 nf=1 m=1
M9 vo net0 VSS VSS nch l=0.15 w=1 nf=1 m=1
.ends opamp

.subckt dut VDD VSS vci phi1 phi2 vco VB2 VB1
C1 net2 VSS 1p
C2 net4 vco 1p
M1 vci phi1 net2 VSS nch l=0.15 w=1 nf=1 m=1
M12 net1 VB4 VDD VDD pch l=0.15 w=1 nf=1 m=1
M13 net3 VB4 VDD VDD pch l=0.15 w=1 nf=1 m=1
M14 VB4 VB4 VDD VDD pch l=0.15 w=1 nf=1 m=1
M15 VB2 VB4 VDD VDD pch l=0.15 w=1 nf=1 m=1
M16 VB3 VB4 VDD VDD pch l=0.15 w=1 nf=1 m=1
M17 VB1 VB1 VDD VDD pch l=0.15 w=1 nf=1 m=1
M18 net1 net1 net0 VSS nch l=0.15 w=1 nf=1 m=1
M19 net0 net1 VB2 VSS nch l=0.15 w=1 nf=1 m=1
M2 net2 phi2 net4 VSS nch l=0.15 w=1 nf=1 m=1
M20 net3 net3 net5 VSS nch l=0.15 w=1 nf=1 m=1
M21 net5 net3 net0 VSS nch l=0.15 w=1 nf=1 m=1
M22 VB4 net5 VSS VSS nch l=0.15 w=1 nf=1 m=1
M23 VB2 VB2 VSS VSS nch l=0.15 w=1 nf=1 m=1
M24 VB3 VB3 VSS VSS nch l=0.15 w=1 nf=1 m=1
M25 VB1 VB3 VSS VSS nch l=0.15 w=1 nf=1 m=1
X1 VDD VSS net4 VSS vco VB3 opamp
.ends dut
