* official Analog Canvas netlist; PDK X cards rewritten by convert.py
.model nch nmos
.model pch pmos

.subckt dut VDD VSS VIN pb VOUT VERR VB1 VB2 VREF VB3 VB4
M1 net9 VEA VIN VDD pch l=0.15 w=1 nf=1 m=1
M10 net4 VB2 VSS VSS nch l=0.15 w=1 nf=1 m=1
M11 net8 VX VDD VDD pch l=0.15 w=1 nf=1 m=1
M12 VZ VB1 net8 VDD pch l=0.15 w=1 nf=1 m=1
M13 VZ VN net6 VSS nch l=0.15 w=1 nf=1 m=1
M14 net6 VZ VSS VSS nch l=0.15 w=1 nf=1 m=1
M15 net2 VY VDD VDD pch l=0.15 w=1 nf=1 m=1
M16 VEA VB1 net2 VDD pch l=0.15 w=1 nf=1 m=1
M17 VEA VN net1 VSS nch l=0.15 w=1 nf=1 m=1
M18 net1 VZ VSS VSS nch l=0.15 w=1 nf=1 m=1
M19 VN VP VDD VDD pch l=0.15 w=1 nf=1 m=1
M2 VX VX net9 VDD pch l=0.15 w=1 nf=1 m=1
M20 VN VN VEA VSS nch l=0.15 w=1 nf=1 m=1
M21 VEA VN VSS VSS nch l=0.15 w=1 nf=1 m=1
M22 VP VP VDD VDD pch l=0.15 w=1 nf=1 m=1
M23 VP VB4 VB3 VSS nch l=0.15 w=1 nf=1 m=1
M24 VB3 VW VSS VSS nch l=0.15 w=1 nf=1 m=1
M25 VB4 VP VDD VDD pch l=0.15 w=1 nf=1 m=1
M26 VB4 VB3 VSS VSS nch l=0.15 w=1 nf=1 m=1
M27 VW VP VDD VDD pch l=0.15 w=1 nf=1 m=1
M28 VW VW VSS VSS nch l=0.15 w=1 nf=1 m=1
M3 VX nb VSS VSS nch l=0.15 w=1 nf=1 m=1
M4 net3 VX VDD VDD pch l=0.15 w=1 nf=1 m=1
M5 VX VB1 net3 VDD pch l=0.15 w=1 nf=1 m=1
M6 VX VEA net4 VSS nch l=0.15 w=1 nf=1 m=1
M7 net5 VY VDD VDD pch l=0.15 w=1 nf=1 m=1
M8 VY VB1 net5 VDD pch l=0.15 w=1 nf=1 m=1
M9 VY VREF net4 VSS nch l=0.15 w=1 nf=1 m=1
MBIAS VERR nb VSS VSS nch l=0.15 w=1 nf=1 m=1
MCHG net7 pb VIN VDD pch l=0.15 w=1 nf=1 m=1
MCTRL VERR VX VOUT VDD pch l=0.15 w=1 nf=1 m=1
MGEN net0 net0 VSS VSS nch l=0.15 w=1 nf=1 m=1
MINJ VERR net0 VSS VSS nch l=0.15 w=1 nf=1 m=1
MRES VOUT VERR VIN VDD pch l=0.15 w=1 nf=1 m=1
MSEN net0 VEA net7 VDD pch l=0.15 w=1 nf=1 m=1
.ends dut
