* official Analog Canvas netlist; PDK X cards rewritten by convert.py
.model nch nmos

.subckt dut VDD VSS Vin Vb Vout
M1 VDD Vin Vout VSS nch l=0.15 w=1 nf=1 m=1
M2 Vout Vb VSS VSS nch l=0.15 w=1 nf=1 m=1
RL Vout VSS 1k
.ends dut
