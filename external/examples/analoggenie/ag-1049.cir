* official Analog Canvas netlist; PDK X cards rewritten by convert.py
.model nch nmos
.model pch pmos

.subckt dut VDD VSS S2_bar S2 Vout Vinp Vinn Vref Vbias
C1 net14 VG1 1p
C2 net3 VG2 1p
C3 VDD net11 1p
M1 VN1 net7 VDD VDD pch l=0.15 w=1 nf=1 m=1
M10 net4 VG2 net10 net10 nch l=0.15 w=1 nf=1 m=1
M11 net10 VBC VSS VSS nch l=0.15 w=1 nf=1 m=1
M12 VG1 S2_bar net7 VDD pch l=0.15 w=1 nf=1 m=1
M13 VG1 S2 VG1 VDD pch l=0.15 w=1 nf=1 m=1
M14 VG2 S2_bar net4 VDD pch l=0.15 w=1 nf=1 m=1
M15 VG2 S2 VG2 VDD pch l=0.15 w=1 nf=1 m=1
M16 Vout Vref VDD VDD pch l=0.15 w=1 nf=1 m=1
M17 Vout net2 VSS VSS nch l=0.15 w=1 nf=1 m=1
M18 net14 net6 VDD VDD pch l=0.15 w=1 nf=1 m=1
M19 net6 net6 VDD VDD pch l=0.15 w=1 nf=1 m=1
M2 net7 net7 VDD VDD pch l=0.15 w=1 nf=1 m=1
M20 net6 Vinp net0 net1 nch l=0.15 w=1 nf=1 m=1
M21 net8 Vinn net0 net1 nch l=0.15 w=1 nf=1 m=1
M22 net8 net8 VDD VDD pch l=0.15 w=1 nf=1 m=1
M23 net3 net8 VDD VDD pch l=0.15 w=1 nf=1 m=1
M24 VDD Vref net1 net1 nch l=0.15 w=1 nf=1 m=1
M25 net0 Vbias VSS VSS nch l=0.15 w=1 nf=1 m=1
M26 net1 Vbias VSS VSS nch l=0.15 w=1 nf=1 m=1
M27 net9 net9 VDD VDD pch l=0.15 w=1 nf=1 m=1
M28 net11 net9 VDD VDD pch l=0.15 w=1 nf=1 m=1
M29 net9 Vref net13 net13 nch l=0.15 w=1 nf=1 m=1
M3 net4 net7 VDD VDD pch l=0.15 w=1 nf=1 m=1
M30 net11 net5 net13 net13 nch l=0.15 w=1 nf=1 m=1
M31 net13 Vbias VSS VSS nch l=0.15 w=1 nf=1 m=1
M32 VBC net11 VDD VDD pch l=0.15 w=1 nf=1 m=1
M33 VBC VBC VSS VSS nch l=0.15 w=1 nf=1 m=1
M34 net12 VBC VSS VSS nch l=0.15 w=1 nf=1 m=1
M35 net5 net5 net12 VSS nch l=0.15 w=1 nf=1 m=1
M36 net5 net5 VDD VDD pch l=0.15 w=1 nf=1 m=1
M4 net7 net4 VDD VDD pch l=0.15 w=1 nf=1 m=1
M5 net4 net4 VDD VDD pch l=0.15 w=1 nf=1 m=1
M6 net2 net4 VDD VDD pch l=0.15 w=1 nf=1 m=1
M7 VN1 VN1 VSS VSS nch l=0.15 w=1 nf=1 m=1
M8 net2 VN1 VSS VSS nch l=0.15 w=1 nf=1 m=1
M9 net7 VG1 net10 net10 nch l=0.15 w=1 nf=1 m=1
R1 net14 VSS 1k
R2 net3 VSS 1k
.ends dut
