* official Analog Canvas netlist; PDK X cards rewritten by convert.py
.model nch nmos

.subckt dut VDD VSS Vcasc-n Iout
I3 VDD net2 DC 1m
Ibias VDD net0 DC 1m
Iin VDD net1 DC 1m
M1 Iout net2 net3 VSS nch l=0.15 w=1 nf=1 m=1
M2 net3 net1 VSS VSS nch l=0.15 w=1 nf=1 m=1
M3 net2 net0 VSS VSS nch l=0.15 w=1 nf=1 m=1
M4 net0 net0 net3 VSS nch l=0.15 w=1 nf=1 m=1
M5 net3 net1 VSS VSS nch l=0.15 w=1 nf=1 m=1
M6 net1 Vcasc-n net4 VSS nch l=0.15 w=1 nf=1 m=1
M7 net4 net1 VSS VSS nch l=0.15 w=1 nf=1 m=1
.ends dut
