* official Analog Canvas netlist; PDK X cards rewritten by convert.py
.model nch nmos
.model pch pmos

.subckt dut VDD VSS VREF VB4 VB3 VB2 VIN VB1 VOUT
CF1 VOUT VFB 1p
Cm1 VOUT VX 1p
Cm2 VX net1 1p
M11 net6 VBN VSS VSS nch l=0.15 w=1 nf=1 m=1
M12 VY VFB net6 VSS nch l=0.15 w=1 nf=1 m=1
M13 VZ VREF net6 VSS nch l=0.15 w=1 nf=1 m=1
M14 net0 net0 VSS VSS nch l=0.15 w=1 nf=1 m=1
M15 VX net0 VSS VSS nch l=0.15 w=1 nf=1 m=1
M16 VZ VB4 VIN VDD pch l=0.15 w=1 nf=1 m=1
M17 VZ VX VSS VSS nch l=0.15 w=1 nf=1 m=1
M18 VZ VZ VSS VSS nch l=0.15 w=1 nf=1 m=1
M21 net4 VX VSS VSS nch l=0.15 w=1 nf=1 m=1
M22 net7 VZ VSS VSS nch l=0.15 w=1 nf=1 m=1
M23 net4 net4 VIN VDD pch l=0.15 w=1 nf=1 m=1
M24 net7 net4 VIN VDD pch l=0.15 w=1 nf=1 m=1
M31 VY VY VIN VDD pch l=0.15 w=1 nf=1 m=1
M32 VX VY VIN VDD pch l=0.15 w=1 nf=1 m=1
M33 net0 VZ VIN VDD pch l=0.15 w=1 nf=1 m=1
M34 VZ VZ VIN VDD pch l=0.15 w=1 nf=1 m=1
MB1 VB1 VB1 VIN VDD pch l=0.15 w=1 nf=1 m=1
MB2 VB1 VBN VSS VSS nch l=0.15 w=1 nf=1 m=1
MB3 VBN net5 VIN VDD pch l=0.15 w=1 nf=1 m=1
MB4 VBN VBN VSS VSS nch l=0.15 w=1 nf=1 m=1
MB5 net5 net5 VIN VDD pch l=0.15 w=1 nf=1 m=1
MB6 net5 net2 VSS VSS nch l=0.15 w=1 nf=1 m=1
MB7 net2 net2 net9 VSS nch l=0.15 w=1 nf=1 m=1
MD1 net1 VX VSS VSS nch l=0.15 w=1 nf=1 m=1
MD2 net8 VB2 VSS VSS nch l=0.15 w=1 nf=1 m=1
MD3 net3 net1 net8 VSS nch l=0.15 w=1 nf=1 m=1
MD4 VY VB3 net8 VSS nch l=0.15 w=1 nf=1 m=1
MD5 net1 VY VIN VDD pch l=0.15 w=1 nf=1 m=1
MD6 VY VY VIN VDD pch l=0.15 w=1 nf=1 m=1
MD7 net3 net3 VIN VDD pch l=0.15 w=1 nf=1 m=1
MPT VOUT net7 VIN VDD pch l=0.15 w=1 nf=1 m=1
RB1 VIN net2 1k
RB2 net9 VSS 1k
RF1 VOUT VFB 1k
RF2 VFB VSS 1k
.ends dut
