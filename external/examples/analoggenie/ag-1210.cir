* official Analog Canvas netlist; PDK X cards rewritten by convert.py
.model nch nmos
.model pch pmos

.global VDD

.subckt BIAS VSS VB5 VB6
M23 VB5 net0 VDD VDD pch l=0.15 w=1 nf=1 m=1
M24 net0 net0 VDD VDD pch l=0.15 w=1 nf=1 m=1
M25 VB3 net0 VDD VDD pch l=0.15 w=1 nf=1 m=1
M26 net0 VB3 VSS VSS nch l=0.15 w=1 nf=1 m=1
M27 net1 VB3 VSS VSS nch l=0.15 w=1 nf=1 m=1
M28 VB5 VB5 VB6 VSS nch l=0.15 w=1 nf=1 m=1
M29 VB6 VB6 VSS VSS nch l=0.15 w=1 nf=1 m=1
R3 VB3 net1 1k
.ends BIAS

.subckt EA VSS VREF VFP1 VB6 VB5 VCTRL VDR3
M12 net1 VB1 VDD VDD pch l=0.15 w=1 nf=1 m=1
M13 net2 VB1 VDD VDD pch l=0.15 w=1 nf=1 m=1
M14 VCTRL VB2 net1 VDD pch l=0.15 w=1 nf=1 m=1
M15 VX VB2 net2 VDD pch l=0.15 w=1 nf=1 m=1
M16 VCTRL VB5 net3 VSS nch l=0.15 w=1 nf=1 m=1
M17 VX VB5 VDR3 VSS nch l=0.15 w=1 nf=1 m=1
M18 net3 VX VSS VSS nch l=0.15 w=1 nf=1 m=1
M19 VDR3 VX VSS VSS nch l=0.15 w=1 nf=1 m=1
M20 net1 VREF net0 VSS nch l=0.15 w=1 nf=1 m=1
M21 net2 VFP1 net0 VSS nch l=0.15 w=1 nf=1 m=1
M22 net0 VB6 VSS VSS nch l=0.15 w=1 nf=1 m=1
.ends EA

.subckt dut VDD VSS VCONT1 VCONT2 VCONT3 VIN VCONT5 VCONT4 VP VB4 VREF
.model DIODE D(IS=1e-14 N=1)
CFLY VX1 VX2 1p
CO VP VN 1p
COP VP VSS 1p
D1 VN VX2 DIODE
L1 VX1 VX3 1n
M1 VX1 VCONT2 VIN VDD pch l=0.15 w=1 nf=1 m=1
M10 net1 VDR3 VSS VSS nch l=0.15 w=1 nf=1 m=1
M11 VDR3 VB4 VSS VSS nch l=0.15 w=1 nf=1 m=1
M2 VX2 VCONT3 VIN VDD pch l=0.15 w=1 nf=1 m=1
M3 VP VCONT5 VX3 VDD pch l=0.15 w=1 nf=1 m=1
M4 VX3 VCONT4 VSS VSS nch l=0.15 w=1 nf=1 m=1
M5 net0 VCONT1 VIN VDD pch l=0.15 w=1 nf=1 m=1
M6 VX1 net1 net0 VDD pch l=0.15 w=1 nf=1 m=1
M7 net1 net1 net0 VDD pch l=0.15 w=1 nf=1 m=1
M8 VDR3 VCTRL net0 VDD pch l=0.15 w=1 nf=1 m=1
M9 VDR3 VDR3 VSS VSS nch l=0.15 w=1 nf=1 m=1
R1 VP VFP1 1k
R2 VFP1 VSS 1k
X1 VSS VREF VFP1 net2 net3 VCTRL VDR3 EA
X2 VSS net3 net2 BIAS
.ends dut
