* official Analog Canvas netlist; PDK X cards rewritten by convert.py
.model nch nmos
.model pch pmos

.subckt dut VDD VSS Vin Vb Vout
M1 net1 Vin net0 VSS nch l=0.15 w=1 nf=1 m=1
M2 Vout net1 VSS VSS nch l=0.15 w=1 nf=1 m=1
M3 net1 Vb VDD VDD pch l=0.15 w=1 nf=1 m=1
M4 Vout Vb VDD VDD pch l=0.15 w=1 nf=1 m=1
R1 net0 VSS 1k
R2 Vout net0 1k
.ends dut
