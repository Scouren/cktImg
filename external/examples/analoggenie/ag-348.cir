* official Analog Canvas netlist; PDK X cards rewritten by convert.py
.model nch nmos

.subckt dut VDD VSS Vout
CF X Vout 1p
CL Vout VSS 1p
I1 VDD Vout DC 1m
ISS X VSS DC 1m PULSE(0 1m 0 1ps 1ps 1 2)
MOUT Vout X VSS VSS nch l=0.15 w=1 nf=1 m=1
.ends dut
