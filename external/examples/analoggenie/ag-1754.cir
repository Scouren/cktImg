* official Analog Canvas netlist; PDK X cards rewritten by convert.py
.model nch nmos
.model pch pmos
.model qpnp pnp

.subckt dut VDD VSS Vout VB1 VB2 VB3
M1 X VG VDD VDD pch l=0.15 w=1 nf=1 m=1
M10 VG VB2 net5 VDD pch l=0.15 w=1 nf=1 m=1
M11 VG VB4 net2 VSS nch l=0.15 w=1 nf=1 m=1
M12 net2 Z VSS VSS nch l=0.15 w=1 nf=1 m=1
M13 net4 X Y VSS nch l=0.15 w=1 nf=1 m=1
M14 net5 Y Y VSS nch l=0.15 w=1 nf=1 m=1
M15 Y VB5 VSS VSS nch l=0.15 w=1 nf=1 m=1
M16 VB4 net1 VDD VDD pch l=0.15 w=1 nf=1 m=1
M17 VB4 VB4 VB5 VSS nch l=0.15 w=1 nf=1 m=1
M18 VB5 VB5 VSS VSS nch l=0.15 w=1 nf=1 m=1
M19 net1 net1 VDD VDD pch l=0.15 w=1 nf=1 m=1
M2 Vout VG VDD VDD pch l=0.15 w=1 nf=1 m=1
M20 net1 VB3 net6 VSS nch l=0.15 w=1 nf=1 m=1
M21 VB3 net1 VDD VDD pch l=0.15 w=1 nf=1 m=1
M22 VB3 VB3 VSS VSS nch l=0.15 w=1 nf=1 m=1
M3 net7 VG VDD VDD pch l=0.15 w=1 nf=1 m=1
M4 Z VG VDD VDD pch l=0.15 w=1 nf=1 m=1
M5 net4 VB1 VDD VDD pch l=0.15 w=1 nf=1 m=1
M6 Z VB2 net4 VDD pch l=0.15 w=1 nf=1 m=1
M7 Z VB4 net0 VSS nch l=0.15 w=1 nf=1 m=1
M8 net0 Z VSS VSS nch l=0.15 w=1 nf=1 m=1
M9 net5 VB1 VDD VDD pch l=0.15 w=1 nf=1 m=1
Q1 VSS VSS net7 qpnp m=1
Q2 VSS net7 X qpnp m=1
Q3 VSS VSS Z qpnp m=1
Q4 VSS Z net3 qpnp m=1
R1 Y net3 1k
R2 Vout Y 1k
R3 net6 VSS 1k
.ends dut
