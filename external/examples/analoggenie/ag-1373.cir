* official Analog Canvas netlist; PDK X cards rewritten by convert.py
.model nch nmos
.model pch pmos

.subckt opamp VDD VSS IN TAIL OUT
M1 net0 net1 VDD VDD pch l=0.15 w=1 nf=1 m=1
M10 net3 VB2 net5 VDD pch l=0.15 w=1 nf=1 m=1
M11 OUT VB2 net2 VDD pch l=0.15 w=1 nf=1 m=1
M12 net3 VB4 net6 VSS nch l=0.15 w=1 nf=1 m=1
M13 OUT VB4 net4 VSS nch l=0.15 w=1 nf=1 m=1
M14 net6 net3 VSS VSS nch l=0.15 w=1 nf=1 m=1
M15 net4 net3 VSS VSS nch l=0.15 w=1 nf=1 m=1
M16 net5 IN TAIL VSS nch l=0.15 w=1 nf=1 m=1
M17 net2 OUT TAIL VSS nch l=0.15 w=1 nf=1 m=1
M18 TAIL VB5 VSS VSS nch l=0.15 w=1 nf=1 m=1
M2 net1 net1 VDD VDD pch l=0.15 w=1 nf=1 m=1
M3 net7 net0 VSS VSS nch l=0.15 w=1 nf=1 m=1
M4 net1 net0 VSS VSS nch l=0.15 w=1 nf=1 m=1
M5 VB4 net1 VDD VDD pch l=0.15 w=1 nf=1 m=1
M6 VB4 VB4 VB5 VSS nch l=0.15 w=1 nf=1 m=1
M7 VB5 VB5 VSS VSS nch l=0.15 w=1 nf=1 m=1
M8 net5 VB1 VDD VDD pch l=0.15 w=1 nf=1 m=1
M9 net2 VB1 VDD VDD pch l=0.15 w=1 nf=1 m=1
R1 net0 net7 1k
.ends opamp

.subckt dut VSS VSTO VOUT VCONT1 VCONT2 VCONT3
CL VOUT VSS 1p
CSTO VSTO VSS 1p
LRX VX net0 1n
MN1 VX VCONT2 VSS VSS nch l=0.15 w=1 nf=1 m=1
MN2 net0 VCONT3 VSS VSS nch l=0.15 w=1 nf=1 m=1
MP2 net0 net1 VOUT VDD pch l=0.15 w=1 nf=1 m=1
MP3 VX VCONT1 VSTO VDD pch l=0.15 w=1 nf=1 m=1
X1 VDD VSS net0 VX net1 opamp
.ends dut
