* official Analog Canvas netlist; PDK X cards rewritten by convert.py
.model nch nmos
.model pch pmos

.subckt dut VDD VSS GND vi vo
M1 net1 vi net2 VSS nch l=0.15 w=1 nf=1 m=1
M10 vo net0 VSS VSS nch l=0.15 w=1 nf=1 m=1
M2 net4 GND net2 VSS nch l=0.15 w=1 nf=1 m=1
M3 net1 net1 VDD VDD pch l=0.15 w=1 nf=1 m=1
M4 net4 net1 VDD VDD pch l=0.15 w=1 nf=1 m=1
M5 net2 net0 VSS VSS nch l=0.15 w=1 nf=1 m=1
M6 net0 net0 VSS VSS nch l=0.15 w=1 nf=1 m=1
M7 net3 net4 VDD VDD pch l=0.15 w=1 nf=1 m=1
M8 net3 net0 VSS VSS nch l=0.15 w=1 nf=1 m=1
M9 VDD net3 vo VSS nch l=0.15 w=1 nf=1 m=1
R1 VDD net0 1k
.ends dut
