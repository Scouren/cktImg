* official Analog Canvas netlist; PDK X cards rewritten by convert.py
.model nch nmos
.model pch pmos
.model qnpn npn

.subckt opamp VDD VSS VB1 VB2 VC INP INN OUT
M1 OUT VC net9 VSS nch l=0.15 w=1 nf=1 m=1
M10 net5 VC net8 VSS nch l=0.15 w=1 nf=1 m=1
M11 net8 net4 VSS VSS nch l=0.15 w=1 nf=1 m=1
M12 net6 net3 VSS VSS nch l=0.15 w=1 nf=1 m=1
M13 net7 net5 VDD VDD pch l=0.15 w=1 nf=1 m=1
M14 net2 net5 VDD VDD pch l=0.15 w=1 nf=1 m=1
M15 net9 net3 VSS VSS nch l=0.15 w=1 nf=1 m=1
M2 net5 VB1 net7 VDD pch l=0.15 w=1 nf=1 m=1
M3 OUT VB1 net2 VDD pch l=0.15 w=1 nf=1 m=1
M4 net1 net4 VSS VSS nch l=0.15 w=1 nf=1 m=1
M5 net0 VB2 VDD VDD pch l=0.15 w=1 nf=1 m=1
M6 net4 INP net0 VDD pch l=0.15 w=1 nf=1 m=1
M7 net3 INN net0 VDD pch l=0.15 w=1 nf=1 m=1
M8 net4 VC net1 VSS nch l=0.15 w=1 nf=1 m=1
M9 net3 VC net6 VSS nch l=0.15 w=1 nf=1 m=1
.ends opamp

.subckt dut VDD VSS Vout VB1 VB2
M16 VC VC VZ VSS nch l=0.15 w=1 nf=1 m=1
M17 VZ VC VSS VSS nch l=0.15 w=1 nf=1 m=1
M20 VB4 VB3 VSS VSS nch l=0.15 w=1 nf=1 m=1
M21 VB4 net0 VDD VDD pch l=0.15 w=1 nf=1 m=1
M22 net0 VB4 VB3 VSS nch l=0.15 w=1 nf=1 m=1
M23 net0 net0 VDD VDD pch l=0.15 w=1 nf=1 m=1
M24 VC net0 VDD VDD pch l=0.15 w=1 nf=1 m=1
M25 net1 net1 VSS VSS nch l=0.15 w=1 nf=1 m=1
M26 net1 net0 VDD VDD pch l=0.15 w=1 nf=1 m=1
M27 VB3 net1 VSS VSS nch l=0.15 w=1 nf=1 m=1
Q1 X X VSS VSS qnpn m=1
Q2 VZ VZ VSS VSS qnpn m=1
R1 Vout X 1k
R2 Vout Y 1k
R3 Y VZ 1k
X1 VDD VSS VB1 VB2 VC X Y Vout opamp
.ends dut
