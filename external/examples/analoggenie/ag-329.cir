* official Analog Canvas netlist; PDK X cards rewritten by convert.py
.model nch nmos
.model pch pmos

.subckt dut VDD VSS VIN1 VIN2 VB5 VB3 VB2 VB1 VB4 VOUT1 VOUT2
M1 net3 VIN1 net1 VSS nch l=0.15 w=1 nf=1 m=1
M10 net4 VB4 VSS VSS nch l=0.15 w=1 nf=1 m=1
M11 net1 VB5 VSS VSS nch l=0.15 w=1 nf=1 m=1
M2 net2 VIN2 net1 VSS nch l=0.15 w=1 nf=1 m=1
M3 VOUT1 VB1 net0 VSS nch l=0.15 w=1 nf=1 m=1
M4 VOUT2 VB1 net4 VSS nch l=0.15 w=1 nf=1 m=1
M5 VOUT1 VB2 net3 VDD pch l=0.15 w=1 nf=1 m=1
M6 VOUT2 VB2 net2 VDD pch l=0.15 w=1 nf=1 m=1
M7 net3 VB3 VDD VDD pch l=0.15 w=1 nf=1 m=1
M8 net2 VB3 VDD VDD pch l=0.15 w=1 nf=1 m=1
M9 net0 VB4 VSS VSS nch l=0.15 w=1 nf=1 m=1
.ends dut
