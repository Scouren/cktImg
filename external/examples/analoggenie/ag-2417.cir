* official Analog Canvas netlist; PDK X cards rewritten by convert.py
.model nch nmos
.model pch pmos

.subckt dut VDD VSS VREF VIN pb nb VOUT VERR
M1 net1 net0 VIN VDD pch l=0.15 w=1 nf=1 m=1
M10 net7 VREF net8 VSS nch l=0.15 w=1 nf=1 m=1
M11 net4 net0 net8 VSS nch l=0.15 w=1 nf=1 m=1
M12 net8 VB3 VSS VSS nch l=0.15 w=1 nf=1 m=1
M13 net2 net2 VDD VDD pch l=0.15 w=1 nf=1 m=1
M14 VB3 net2 VDD VDD pch l=0.15 w=1 nf=1 m=1
M15 VB3 VB3 VSS VSS nch l=0.15 w=1 nf=1 m=1
M2 net3 net3 net1 VDD pch l=0.15 w=1 nf=1 m=1
M3 net3 nb VSS VSS nch l=0.15 w=1 nf=1 m=1
M4 net7 net7 VDD VDD pch l=0.15 w=1 nf=1 m=1
M5 net0 net7 VDD VDD pch l=0.15 w=1 nf=1 m=1
M6 net0 net4 VDD VDD pch l=0.15 w=1 nf=1 m=1
M7 net4 net4 VDD VDD pch l=0.15 w=1 nf=1 m=1
M8 net0 net0 VSS VSS nch l=0.15 w=1 nf=1 m=1
M9 net0 net0 VSS VSS nch l=0.15 w=1 nf=1 m=1
MBIAS VERR nb VSS VSS nch l=0.15 w=1 nf=1 m=1
MCHG net6 pb VIN VDD pch l=0.15 w=1 nf=1 m=1
MCTRL VERR net3 VOUT VDD pch l=0.15 w=1 nf=1 m=1
MGEN net5 net5 VSS VSS nch l=0.15 w=1 nf=1 m=1
MINJ VERR net5 VSS VSS nch l=0.15 w=1 nf=1 m=1
MRES VOUT VERR VIN VDD pch l=0.15 w=1 nf=1 m=1
MSEN net5 net0 net6 VDD pch l=0.15 w=1 nf=1 m=1
R1 net2 VSS 1k
.ends dut
