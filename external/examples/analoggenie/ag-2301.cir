* official Analog Canvas netlist; PDK X cards rewritten by convert.py
.model nch nmos
.model pch pmos

.subckt dut VDD VSS FB VREF VB2 VB1 VB3 VIN VOUT IBUF VB4
CL VOUT net3 1p
M10 EAO VB3 net1 VDD pch l=0.15 w=1 nf=1 m=1
M11 net8 VB1 VDD VDD pch l=0.15 w=1 nf=1 m=1
M12 net1 VB1 VDD VDD pch l=0.15 w=1 nf=1 m=1
M13 net10 VB4 VDD VDD pch l=0.15 w=1 nf=1 m=1
M14 net2 EAO net10 VDD pch l=0.15 w=1 nf=1 m=1
M15 net2 net2 VSS VSS nch l=0.15 w=1 nf=1 m=1
M16 GATE net2 VSS VSS nch l=0.15 w=1 nf=1 m=1
M17 VDD net10 GATE VSS nch l=0.15 w=1 nf=1 m=1
M18 net0 EAO IBUF IBUF nch l=0.15 w=1 nf=1 m=1
M19 net0 net0 VDD VDD pch l=0.15 w=1 nf=1 m=1
M20 GATE net0 VDD VDD pch l=0.15 w=1 nf=1 m=1
M21 VSS IBUF GATE VSS pch l=0.15 w=1 nf=1 m=1
M22 net6 VB2 VSS VSS nch l=0.15 w=1 nf=1 m=1
M23 VCN net5 VDD VDD pch l=0.15 w=1 nf=1 m=1
M24 net5 net5 net11 VDD pch l=0.15 w=1 nf=1 m=1
M25 VCN VCN net7 VSS nch l=0.15 w=1 nf=1 m=1
M26 net7 VCN VSS VSS nch l=0.15 w=1 nf=1 m=1
M3 net1 VREF net6 VSS nch l=0.15 w=1 nf=1 m=1
M4 net8 FB net6 VSS nch l=0.15 w=1 nf=1 m=1
M5 net9 VX VSS VSS nch l=0.15 w=1 nf=1 m=1
M6 net4 VX VSS VSS nch l=0.15 w=1 nf=1 m=1
M7 VX VCN net9 VSS nch l=0.15 w=1 nf=1 m=1
M8 EAO VCN net4 VSS nch l=0.15 w=1 nf=1 m=1
M9 VX VB3 net8 VDD pch l=0.15 w=1 nf=1 m=1
MNP VIN GATE VOUT VOUT nch l=0.15 w=1 nf=1 m=1
R1 FB VSS 1k
R2 VOUT FB 1k
R3 net3 VSS 1k
R4 VDD net11 1k
R5 net5 VSS 1k
RL VOUT VSS 1k
.ends dut
