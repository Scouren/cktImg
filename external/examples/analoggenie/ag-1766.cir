* official Analog Canvas netlist; PDK X cards rewritten by convert.py
.model nch nmos
.model pch pmos
.model qpnp pnp

.subckt dut VDD VSS Vout
M1 X VG VDD VDD pch l=0.15 w=1 nf=1 m=1
M10 net4 X Y VSS nch l=0.15 w=1 nf=1 m=1
M11 Y VB2 VSS VSS nch l=0.15 w=1 nf=1 m=1
M12 VG VB6 net8 VSS nch l=0.15 w=1 nf=1 m=1
M13 VE VB6 net3 VSS nch l=0.15 w=1 nf=1 m=1
M14 net8 VE VSS VSS nch l=0.15 w=1 nf=1 m=1
M15 net3 VE VSS VSS nch l=0.15 w=1 nf=1 m=1
M16 VB6 net2 VDD VDD pch l=0.15 w=1 nf=1 m=1
M17 VB5 net2 VDD VDD pch l=0.15 w=1 nf=1 m=1
M18 net2 net2 VDD VDD pch l=0.15 w=1 nf=1 m=1
M19 net7 net2 VDD VDD pch l=0.15 w=1 nf=1 m=1
M2 Vout VG VDD VDD pch l=0.15 w=1 nf=1 m=1
M20 VB6 VB6 net1 VSS nch l=0.15 w=1 nf=1 m=1
M21 net1 VB6 VSS VSS nch l=0.15 w=1 nf=1 m=1
M22 VB5 VB4 VSS VSS nch l=0.15 w=1 nf=1 m=1
M23 net2 VB5 VB4 VSS nch l=0.15 w=1 nf=1 m=1
M24 VB4 net7 VSS VSS nch l=0.15 w=1 nf=1 m=1
M25 net7 net7 VSS VSS nch l=0.15 w=1 nf=1 m=1
M3 VE VG VDD VDD pch l=0.15 w=1 nf=1 m=1
M4 net0 VG VDD VDD pch l=0.15 w=1 nf=1 m=1
M5 net5 VB1 VDD VDD pch l=0.15 w=1 nf=1 m=1
M6 net4 VB1 VDD VDD pch l=0.15 w=1 nf=1 m=1
M7 VG VB3 net5 VDD pch l=0.15 w=1 nf=1 m=1
M8 VE VB3 net4 VDD pch l=0.15 w=1 nf=1 m=1
M9 net5 Y Y VSS nch l=0.15 w=1 nf=1 m=1
Q1 VSS VSS VE qpnp m=1
Q2 VSS VE net6 qpnp m=1
Q3 VSS VSS net0 qpnp m=1
Q4 VSS net0 X qpnp m=1
R1 Y net6 1k
R2 Vout Y 1k
.ends dut
