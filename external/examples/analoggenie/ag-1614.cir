* official Analog Canvas netlist; PDK X cards rewritten by convert.py
.model nch nmos
.model pch pmos
.model qpnp pnp

.subckt A1 VDD VSS INN INP OUT
M1 VB2 VB1 VDD VDD pch l=0.15 w=1 nf=1 m=1
M10 VB1 net3 VSS VSS nch l=0.15 w=1 nf=1 m=1
M11 net3 net3 VSS VSS nch l=0.15 w=1 nf=1 m=1
M12 net0 net3 VSS VSS nch l=0.15 w=1 nf=1 m=1
M13 net4 INN net2 VSS nch l=0.15 w=1 nf=1 m=1
M14 net1 INP net2 VSS nch l=0.15 w=1 nf=1 m=1
M15 net2 VB2 VSS VSS nch l=0.15 w=1 nf=1 m=1
M16 net0 net0 VSS VSS nch l=0.15 w=1 nf=1 m=1
M17 OUT net0 VSS VSS nch l=0.15 w=1 nf=1 m=1
M2 VB1 VB1 VDD VDD pch l=0.15 w=1 nf=1 m=1
M3 net3 net0 VDD VDD pch l=0.15 w=1 nf=1 m=1
M4 net0 net0 VDD VDD pch l=0.15 w=1 nf=1 m=1
M5 net0 net4 VDD VDD pch l=0.15 w=1 nf=1 m=1
M6 net4 net4 VDD VDD pch l=0.15 w=1 nf=1 m=1
M7 net1 net1 VDD VDD pch l=0.15 w=1 nf=1 m=1
M8 OUT net1 VDD VDD pch l=0.15 w=1 nf=1 m=1
M9 VB2 VB2 VSS VSS nch l=0.15 w=1 nf=1 m=1
R4 VDD net3 1k
.ends A1

.subckt dut VDD VSS Vout
Q1 VSS VSS X qpnp m=1
Q2 VSS VSS net0 qpnp m=1
R1 Vout X 1k
R2 Vout Y 1k
R3 Y net0 1k
X1 VDD VSS Y X Vout A1
.ends dut
