* official Analog Canvas netlist; PDK X cards rewritten by convert.py
.model nch nmos
.model pch pmos

.subckt opamp VDD VSS INP INN OUT VX
M1 net4 INP net8 net10 pch l=0.15 w=1 nf=1 m=1
M10 VP VB4 net5 VSS nch l=0.15 w=1 nf=1 m=1
M11 OUT VB4 net0 VSS nch l=0.15 w=1 nf=1 m=1
M12 net5 net4 VSS VSS nch l=0.15 w=1 nf=1 m=1
M13 net0 VX VSS VSS nch l=0.15 w=1 nf=1 m=1
M14 net7 VP VDD VDD pch l=0.15 w=1 nf=1 m=1
M15 net6 VP VDD VDD pch l=0.15 w=1 nf=1 m=1
M16 VB4 net1 VDD VDD pch l=0.15 w=1 nf=1 m=1
M17 net1 net1 VDD VDD pch l=0.15 w=1 nf=1 m=1
M18 VB3 net1 VDD VDD pch l=0.15 w=1 nf=1 m=1
M19 VB4 VB4 net9 VSS nch l=0.15 w=1 nf=1 m=1
M2 VX INN net8 net10 pch l=0.15 w=1 nf=1 m=1
M20 net9 VB4 VSS VSS nch l=0.15 w=1 nf=1 m=1
M21 net1 VB3 VSS VSS nch l=0.15 w=1 nf=1 m=1
M22 net3 VB3 VSS VSS nch l=0.15 w=1 nf=1 m=1
M3 net11 net4 VSS VSS nch l=0.15 w=1 nf=1 m=1
M4 net2 VX VSS VSS nch l=0.15 w=1 nf=1 m=1
M5 net4 VB4 net11 VSS nch l=0.15 w=1 nf=1 m=1
M6 VX VB4 net2 VSS nch l=0.15 w=1 nf=1 m=1
M7 net8 VB2 VDD VDD pch l=0.15 w=1 nf=1 m=1
M8 VP VB1 net7 VDD pch l=0.15 w=1 nf=1 m=1
M9 OUT VB1 net6 VDD pch l=0.15 w=1 nf=1 m=1
R1 VB3 net3 1k
.ends opamp

.subckt dut VDD VSS Vref VIN VOUT
CL VOUT VX 1p
M1 VIN net0 VOUT VOUT nch l=0.15 w=1 nf=1 m=1
R1 VOUT FB 1k
R2 FB VSS 1k
R3 VX VSS 1k
X1 VDD VSS Vref FB net0 VX opamp
.ends dut
