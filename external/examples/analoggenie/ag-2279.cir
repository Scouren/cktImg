* official Analog Canvas netlist; PDK X cards rewritten by convert.py
.model nch nmos
.model pch pmos

.subckt bias VDD VSS VBN
M25 net0 VP VDD VDD pch l=0.15 w=1 nf=1 m=1
M26 VP VP VDD VDD pch l=0.15 w=1 nf=1 m=1
M27 VP VB4 VB3 VSS nch l=0.15 w=1 nf=1 m=1
M28 VB3 net0 VSS VSS nch l=0.15 w=1 nf=1 m=1
M29 net0 net0 VSS VSS nch l=0.15 w=1 nf=1 m=1
M30 VB4 VP VDD VDD pch l=0.15 w=1 nf=1 m=1
M31 VB4 VB3 VSS VSS nch l=0.15 w=1 nf=1 m=1
M32 VBN VP VDD VDD pch l=0.15 w=1 nf=1 m=1
M33 VBN VBN net1 VSS nch l=0.15 w=1 nf=1 m=1
M34 net1 VBN VSS VSS nch l=0.15 w=1 nf=1 m=1
.ends bias

.subckt dut VDD VSS VREF VB2 VB1 VB5 VIN VOUT
CL VOUT net5 1p
M1 VX VB2 VSS VSS nch l=0.15 w=1 nf=1 m=1
M10 net4 VB1 net6 VDD pch l=0.15 w=1 nf=1 m=1
M11 net9 net1 VDD VDD pch l=0.15 w=1 nf=1 m=1
M12 net6 net11 VDD VDD pch l=0.15 w=1 nf=1 m=1
M13 VX VB5 VDD VDD pch l=0.15 w=1 nf=1 m=1
M14 net0 EAO VX VDD pch l=0.15 w=1 nf=1 m=1
M15 net0 net0 VSS VSS nch l=0.15 w=1 nf=1 m=1
M16 GATE net0 VSS VSS nch l=0.15 w=1 nf=1 m=1
M17 net2 EAO IBUF VSS nch l=0.15 w=1 nf=1 m=1
M18 VDD VX GATE VSS nch l=0.15 w=1 nf=1 m=1
M19 net2 net2 VDD VDD pch l=0.15 w=1 nf=1 m=1
M2 net10 net1 VDD VDD pch l=0.15 w=1 nf=1 m=1
M20 GATE net2 VDD VDD pch l=0.15 w=1 nf=1 m=1
M21 VSS IBUF GATE VDD pch l=0.15 w=1 nf=1 m=1
M22 net1 VB1 net10 VDD pch l=0.15 w=1 nf=1 m=1
M23 net8 net11 VDD VDD pch l=0.15 w=1 nf=1 m=1
M24 net11 VB1 net8 VDD pch l=0.15 w=1 nf=1 m=1
M3 net1 VREF VX VSS nch l=0.15 w=1 nf=1 m=1
M4 net11 FB VX VSS nch l=0.15 w=1 nf=1 m=1
M5 net7 net4 VSS VSS nch l=0.15 w=1 nf=1 m=1
M6 net3 net4 VSS VSS nch l=0.15 w=1 nf=1 m=1
M7 EAO VBN net7 VSS nch l=0.15 w=1 nf=1 m=1
M8 net4 VBN net3 VSS nch l=0.15 w=1 nf=1 m=1
M9 EAO VB1 net9 VDD pch l=0.15 w=1 nf=1 m=1
MNP VIN GATE VOUT VSS nch l=0.15 w=1 nf=1 m=1
R1 FB VSS 1k
R2 VOUT FB 1k
R3 net5 VSS 1k
RL VOUT VSS 1k
X1 VDD VSS VBN bias
.ends dut
