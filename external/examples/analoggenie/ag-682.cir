* official Analog Canvas netlist; PDK X cards rewritten by convert.py
.model nch nmos
.model pch pmos

.subckt dut VDD VSS vi Vo
I1 VDD net1 DC 1m
I2 net0 VSS DC 1m
M1 net2 vi VSS VSS nch l=0.15 w=1 nf=1 m=1
M2 Vo net1 net2 VSS nch l=0.15 w=1 nf=1 m=1
M3 Vo net0 VDD VDD pch l=0.15 w=1 nf=1 m=1
M4 net0 net0 VDD VDD pch l=0.15 w=1 nf=1 m=1
M5 net3 net3 VSS VSS nch l=0.15 w=1 nf=1 m=1
M6 net1 net1 net3 VSS nch l=0.15 w=1 nf=1 m=1
.ends dut
