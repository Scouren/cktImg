* official Analog Canvas netlist; PDK X cards rewritten by convert.py
.model nch nmos
.model pch pmos

.subckt opamp VDD VSS INP INN VB2 VB1 OUT
M10 net1 VB2 VDD VDD pch l=0.15 w=1 nf=1 m=1
M11 net2 INP net1 VDD pch l=0.15 w=1 nf=1 m=1
M12 net2 VC net12 VSS nch l=0.15 w=1 nf=1 m=1
M13 net12 net2 VSS VSS nch l=0.15 w=1 nf=1 m=1
M14 net4 INN net1 VDD pch l=0.15 w=1 nf=1 m=1
M15 net4 VC net11 VSS nch l=0.15 w=1 nf=1 m=1
M16 net11 net4 VSS VSS nch l=0.15 w=1 nf=1 m=1
M17 net0 VX VDD VDD pch l=0.15 w=1 nf=1 m=1
M18 OUT VB1 net0 VDD pch l=0.15 w=1 nf=1 m=1
M19 OUT VC net3 VSS nch l=0.15 w=1 nf=1 m=1
M20 net3 net4 VSS VSS nch l=0.15 w=1 nf=1 m=1
M21 net8 VP VDD VDD pch l=0.15 w=1 nf=1 m=1
M22 net8 net8 VSS VSS nch l=0.15 w=1 nf=1 m=1
M23 VP VP VDD VDD pch l=0.15 w=1 nf=1 m=1
M24 VP net8 net9 VSS nch l=0.15 w=1 nf=1 m=1
M25 net9 net7 VSS VSS nch l=0.15 w=1 nf=1 m=1
M26 net7 VP VDD VDD pch l=0.15 w=1 nf=1 m=1
M27 net7 net7 VSS VSS nch l=0.15 w=1 nf=1 m=1
M28 VC VP VDD VDD pch l=0.15 w=1 nf=1 m=1
M29 VC VC net10 VSS nch l=0.15 w=1 nf=1 m=1
M30 net10 VC VSS VSS nch l=0.15 w=1 nf=1 m=1
M6 net6 VX VDD VDD pch l=0.15 w=1 nf=1 m=1
M7 VX VB1 net6 VDD pch l=0.15 w=1 nf=1 m=1
M8 VX VC net5 VSS nch l=0.15 w=1 nf=1 m=1
M9 net5 net2 VSS VSS nch l=0.15 w=1 nf=1 m=1
.ends opamp

.subckt dut VDD VSS Vref Vout biasp biascas biasn VB1 VB2
C1 Vset VSS 1p
C2 n3 Vout 1p
M1 Vout n3 VDD VDD pch l=0.15 w=1 nf=1 m=1
M2 n1 Vset Vout VDD pch l=0.15 w=1 nf=1 m=1
M3 n1 biasn VSS VSS nch l=0.15 w=1 nf=1 m=1
M4 n3 biasp VDD VDD pch l=0.15 w=1 nf=1 m=1
M5 n3 biascas n1 VSS nch l=0.15 w=1 nf=1 m=1
R1 fb VSS 1k
R2 Vout fb 1k
X1 VDD VSS Vref fb VB2 VB1 Vset opamp
.ends dut
