* official Analog Canvas netlist; PDK X cards rewritten by convert.py
.model nch nmos

.subckt dut VDD VSS Vb1 Vb2 Vout
C1 net1 net2 1p
L1 VDD Vout 1n
M1 Vout Vb1 net2 VSS nch l=0.15 w=1 nf=1 m=1
M2 net2 Vb2 VSS VSS nch l=0.15 w=1 nf=1 m=1
RS net0 net1 1k
Vin net0 VSS DC 1
.ends dut
