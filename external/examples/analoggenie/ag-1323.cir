* official Analog Canvas netlist; PDK X cards rewritten by convert.py
.model nch nmos
.model pch pmos

.subckt EA1 VDD VSS VO VFP1 VREF VX2
MN1 net3 net3 VSS VSS nch l=0.15 w=1 nf=1 m=1
MN10 net5 net2 net7 VSS nch l=0.15 w=1 nf=1 m=1
MN11 net1 net1 net7 VSS nch l=0.15 w=1 nf=1 m=1
MN12 net0 net1 net7 VSS nch l=0.15 w=1 nf=1 m=1
MN13 VB1 net5 VSS VSS nch l=0.15 w=1 nf=1 m=1
MN14 net0 net0 VSS VSS nch l=0.15 w=1 nf=1 m=1
MN2 VX2 VX2 VSS VSS nch l=0.15 w=1 nf=1 m=1
MN3 VO net3 VSS VSS nch l=0.15 w=1 nf=1 m=1
MN4 net6 VX2 VSS VSS nch l=0.15 w=1 nf=1 m=1
MN5 VBP net0 VSS VSS nch l=0.15 w=1 nf=1 m=1
MN9 net2 net2 net5 VSS nch l=0.15 w=1 nf=1 m=1
MP1 net3 VFP1 net4 VDD pch l=0.15 w=1 nf=1 m=1
MP10 VB1 VB1 VDD VDD pch l=0.15 w=1 nf=1 m=1
MP11 net2 VB1 VDD VDD pch l=0.15 w=1 nf=1 m=1
MP12 net1 VB1 VDD VDD pch l=0.15 w=1 nf=1 m=1
MP13 net0 VB1 VDD VDD pch l=0.15 w=1 nf=1 m=1
MP2 VX2 VREF net4 VDD pch l=0.15 w=1 nf=1 m=1
MP3 net4 VBP VDD VDD pch l=0.15 w=1 nf=1 m=1
MP7 VO net6 VDD VDD pch l=0.15 w=1 nf=1 m=1
MP8 net6 net6 VDD VDD pch l=0.15 w=1 nf=1 m=1
MP9 VBP VBP VDD VDD pch l=0.15 w=1 nf=1 m=1
.ends EA1

.subckt dut VDD VSS VCONT1 VB2 VCONT4 VCONT5 VP VIN VCONT2 VCONT3 VREF
.model DIODE D(IS=1e-14 N=1)
CFLY VX1 VX2 1p
CO VP VN 1p
COP VP VSS 1p
D1 VN VX2 DIODE
L1 VX1 VX3 1n
M1 VX1 VCONT2 VIN VDD pch l=0.15 w=1 nf=1 m=1
M2 VX2 VCONT3 VIN VDD pch l=0.15 w=1 nf=1 m=1
M3 VX3 VCONT5 VP VDD pch l=0.15 w=1 nf=1 m=1
M4 VX3 VCONT4 VSS VSS nch l=0.15 w=1 nf=1 m=1
M5 net2 VCONT1 VIN VDD pch l=0.15 w=1 nf=1 m=1
MN6 net1 net0 VSS VSS nch l=0.15 w=1 nf=1 m=1
MN7 net0 net0 VSS VSS nch l=0.15 w=1 nf=1 m=1
MN8 net0 VB2 VSS VSS nch l=0.15 w=1 nf=1 m=1
MP4 net1 net1 net2 VDD pch l=0.15 w=1 nf=1 m=1
MP5 VX1 net1 net2 VDD pch l=0.15 w=1 nf=1 m=1
MP6 net0 net3 net2 VDD pch l=0.15 w=1 nf=1 m=1
R1 VP VFP1 1k
R2 VFP1 VSS 1k
X1 VDD VSS net3 VFP1 VREF VX2 EA1
.ends dut
