* official Analog Canvas netlist; PDK X cards rewritten by convert.py
.model nch nmos

.subckt dut VDD VSS LO LO_bar VRF+ VRF- VIF1 VIF2
M1 net1 VRF+ VSS VSS nch l=0.15 w=1 nf=1 m=1
M2 VIF2 LO net1 VSS nch l=0.15 w=1 nf=1 m=1
M3 VIF1 LO_bar net1 VSS nch l=0.15 w=1 nf=1 m=1
M4 net0 VRF- VSS VSS nch l=0.15 w=1 nf=1 m=1
M5 VIF2 LO_bar net0 VSS nch l=0.15 w=1 nf=1 m=1
M6 VIF1 LO net0 VSS nch l=0.15 w=1 nf=1 m=1
RD1 VDD VIF1 1k
RD2 VDD VIF2 1k
.ends dut
