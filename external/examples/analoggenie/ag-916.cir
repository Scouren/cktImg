* official Analog Canvas netlist; PDK X cards rewritten by convert.py
.model qnpn npn

.subckt dut VEE VCC Vin1P Vin1N Vin2P Vin2N VoP VoN
IEE net0 VEE DC 1m
Q1 net2 Vin2P net0 VEE qnpn m=1
Q2 net1 Vin2N net0 VEE qnpn m=1
Q3 VoP Vin1P net2 VEE qnpn m=1
Q4 VoN Vin1N net2 VEE qnpn m=1
Q5 VoP Vin1N net1 VEE qnpn m=1
Q6 VoN Vin1P net1 VEE qnpn m=1
RC1 VCC VoP 1k
RC2 VCC VoN 1k
.ends dut
