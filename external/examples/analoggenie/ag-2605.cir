* official Analog Canvas netlist; PDK X cards rewritten by convert.py
.model nch nmos
.model pch pmos

.subckt AMP1 VDD VSS INN INP OUT
M10 net1 INN net3 VSS nch l=0.15 w=1 nf=1 m=1
M11 INN INP net3 VSS nch l=0.15 w=1 nf=1 m=1
M12 net3 VBN VSS VSS nch l=0.15 w=1 nf=1 m=1
M13 net4 net4 VSS VSS nch l=0.15 w=1 nf=1 m=1
M14 OUT net4 VSS VSS nch l=0.15 w=1 nf=1 m=1
M15 net0 net2 VSS VSS nch l=0.15 w=1 nf=1 m=1
M16 net2 net0 VDD VDD pch l=0.15 w=1 nf=1 m=1
M17 net2 net2 VSS VSS nch l=0.15 w=1 nf=1 m=1
M18 VB1 VB1 VDD VDD pch l=0.15 w=1 nf=1 m=1
M19 VB1 net2 VSS VSS nch l=0.15 w=1 nf=1 m=1
M20 VBN VB1 VDD VDD pch l=0.15 w=1 nf=1 m=1
M21 VBN VBN VSS VSS nch l=0.15 w=1 nf=1 m=1
M6 net4 net1 VDD VDD pch l=0.15 w=1 nf=1 m=1
M7 net1 net1 VDD VDD pch l=0.15 w=1 nf=1 m=1
M8 INN INN VDD VDD pch l=0.15 w=1 nf=1 m=1
M9 OUT INN VDD VDD pch l=0.15 w=1 nf=1 m=1
R3 VDD net0 1k
R4 VDD net2 1k
.ends AMP1

.subckt dut VDD VSS biasp biascas biasn Vref Vout
C1 Vset VSS 1p
C2 n3 Vout 1p
M1 Vout n3 VDD VDD pch l=0.15 w=1 nf=1 m=1
M2 n1 Vset Vout VDD pch l=0.15 w=1 nf=1 m=1
M3 n1 biasn VSS VSS nch l=0.15 w=1 nf=1 m=1
M4 n3 biasp VDD VDD pch l=0.15 w=1 nf=1 m=1
M5 n3 biascas n1 VSS nch l=0.15 w=1 nf=1 m=1
R1 fb VSS 1k
R2 Vout fb 1k
X1 VDD VSS fb Vref Vset AMP1
.ends dut
