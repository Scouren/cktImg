* official Analog Canvas netlist; PDK X cards rewritten by convert.py
.model nch nmos
.model pch pmos

.subckt error_amp VDD VSS VREF VBN OUT
M10 OUT OUT VSS VSS nch l=0.15 w=1 nf=1 m=1
M11 net0 OUT net2 VSS nch l=0.15 w=1 nf=1 m=1
M12 net2 VBN VSS VSS nch l=0.15 w=1 nf=1 m=1
M4 net1 net1 VDD VDD pch l=0.15 w=1 nf=1 m=1
M5 OUT net1 VDD VDD pch l=0.15 w=1 nf=1 m=1
M6 OUT net0 VDD VDD pch l=0.15 w=1 nf=1 m=1
M7 net0 net0 VDD VDD pch l=0.15 w=1 nf=1 m=1
M8 net1 VREF net2 VSS nch l=0.15 w=1 nf=1 m=1
M9 OUT OUT VSS VSS nch l=0.15 w=1 nf=1 m=1
.ends error_amp

.subckt bias VDD VSS VBN VB1
M13 VBN VP VDD VDD pch l=0.15 w=1 nf=1 m=1
M14 net1 VP VDD VDD pch l=0.15 w=1 nf=1 m=1
M15 VP VP VDD VDD pch l=0.15 w=1 nf=1 m=1
M16 VB1 VP VDD VDD pch l=0.15 w=1 nf=1 m=1
M17 VBN VBN VSS VSS nch l=0.15 w=1 nf=1 m=1
M18 net1 net1 VSS VSS nch l=0.15 w=1 nf=1 m=1
M19 VP VB1 net0 VSS nch l=0.15 w=1 nf=1 m=1
M20 net0 net1 VSS VSS nch l=0.15 w=1 nf=1 m=1
M21 VB1 VB1 VSS VSS nch l=0.15 w=1 nf=1 m=1
.ends bias

.subckt dut VDD VSS VREF VB1 VIN pb nb VOUT VERR
M1 net0 VEA VIN VDD pch l=0.15 w=1 nf=1 m=1
M2 net4 net4 net0 VDD pch l=0.15 w=1 nf=1 m=1
M3 net4 nb VSS VSS nch l=0.15 w=1 nf=1 m=1
MBIAS VERR nb VSS VSS nch l=0.15 w=1 nf=1 m=1
MCHG net2 pb VIN VDD pch l=0.15 w=1 nf=1 m=1
MCTRL VERR net4 VOUT VDD pch l=0.15 w=1 nf=1 m=1
MGEN net1 net1 VSS VSS nch l=0.15 w=1 nf=1 m=1
MINJ VERR net1 VSS VSS nch l=0.15 w=1 nf=1 m=1
MRES VOUT VERR VIN VDD pch l=0.15 w=1 nf=1 m=1
MSEN net1 VEA net2 VDD pch l=0.15 w=1 nf=1 m=1
X1 VDD VSS VREF net3 VEA error_amp
X2 VDD VSS net3 VB1 bias
.ends dut
