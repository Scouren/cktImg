* official Analog Canvas netlist; PDK X cards rewritten by convert.py
.model nch nmos
.model pch pmos

.subckt EA VDD VSS VFP1 VREF VCTRL VX2
MN1 VCTRL net0 VSS VSS nch l=0.15 w=1 nf=1 m=1
MN2 net0 net0 VSS VSS nch l=0.15 w=1 nf=1 m=1
MN3 VX2 VX2 VSS VSS nch l=0.15 w=1 nf=1 m=1
MN4 net4 VX2 VSS VSS nch l=0.15 w=1 nf=1 m=1
MN5 VBP VB1 VSS VSS nch l=0.15 w=1 nf=1 m=1
MN6 VB1 VB1 VSS VSS nch l=0.15 w=1 nf=1 m=1
MN7 net3 net1 VSS VSS nch l=0.15 w=1 nf=1 m=1
MN8 net1 net1 VSS VSS nch l=0.15 w=1 nf=1 m=1
MN9 net5 net1 VSS VSS nch l=0.15 w=1 nf=1 m=1
MP1 VCTRL net4 VDD VDD pch l=0.15 w=1 nf=1 m=1
MP2 net4 net4 VDD VDD pch l=0.15 w=1 nf=1 m=1
MP3 net6 VBP VDD VDD pch l=0.15 w=1 nf=1 m=1
MP4 net0 VFP1 net6 net2 pch l=0.15 w=1 nf=1 m=1
MP5 VX2 VREF net6 net2 pch l=0.15 w=1 nf=1 m=1
MP6 VBP VBP VDD VDD pch l=0.15 w=1 nf=1 m=1
MP7 VB1 net3 VDD VDD pch l=0.15 w=1 nf=1 m=1
MP8 net3 net3 VDD VDD pch l=0.15 w=1 nf=1 m=1
MP9 net1 net5 VDD VDD pch l=0.15 w=1 nf=1 m=1
RBIAS VDD net5 1k
RF VDD net1 1k
.ends EA

.subckt ISR VSS VS IOUT VCTRL VB2
MN10 net0 net0 VSS VSS nch l=0.15 w=1 nf=1 m=1
MN11 net0 VB2 VSS VSS nch l=0.15 w=1 nf=1 m=1
MN12 net1 net0 VSS VSS nch l=0.15 w=1 nf=1 m=1
MP10 net0 VCTRL VS VS pch l=0.15 w=1 nf=1 m=1
MP11 net1 net1 VS VS pch l=0.15 w=1 nf=1 m=1
MP12 IOUT net1 VS VS pch l=0.15 w=1 nf=1 m=1
.ends ISR

.subckt dut VDD VSS VIN VP VCONT1 VCONT2 VCONT3 VCONT4 VCONT5 VB2 VREF
.model DIODE D(IS=1e-14 N=1)
CFLY VX1 VX2 1p
CO VP VN 1p
COP VP VSS 1p
D1 VN VX2 DIODE
L1 VX1 VX3 1n
M1 VX1 VCONT2 VIN VIN pch l=0.15 w=1 nf=1 m=1
M2 VX2 VCONT3 VIN VIN pch l=0.15 w=1 nf=1 m=1
M3 VX3 VCONT4 VSS VSS nch l=0.15 w=1 nf=1 m=1
M4 VX3 VCONT5 VP VP pch l=0.15 w=1 nf=1 m=1
M5 net1 VCONT1 VIN VIN pch l=0.15 w=1 nf=1 m=1
R1 VP VFP1 1k
R2 VFP1 VSS 1k
X1 VSS net1 VX1 net0 VB2 ISR
X2 VDD VSS VFP1 VREF net0 VX2 EA
.ends dut
