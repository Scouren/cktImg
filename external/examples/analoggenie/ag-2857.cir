* official Analog Canvas netlist; PDK X cards rewritten by convert.py
.model nch nmos
.model pch pmos

.subckt opamp VDD VSS vn vcx vo vp
M10 VB2 VB2 VDD VDD pch l=0.15 w=1 nf=1 m=1
M11 VB2 vn net0 VSS nch l=0.15 w=1 nf=1 m=1
M12 vn VB2 VDD VDD pch l=0.15 w=1 nf=1 m=1
M13 vn net0 VSS VSS nch l=0.15 w=1 nf=1 m=1
M14 net1 net1 VDD VDD pch l=0.15 w=1 nf=1 m=1
M15 net1 net0 VSS VSS nch l=0.15 w=1 nf=1 m=1
M16 VB4 net1 VDD VDD pch l=0.15 w=1 nf=1 m=1
M17 VB4 VB4 VSS VSS nch l=0.15 w=1 nf=1 m=1
M18 VB1 VB1 VDD VDD pch l=0.15 w=1 nf=1 m=1
M19 VB1 VB4 VSS VSS nch l=0.15 w=1 nf=1 m=1
M3 net2 vcx VDD VDD pch l=0.15 w=1 nf=1 m=1
M4 net4 vcx VDD VDD pch l=0.15 w=1 nf=1 m=1
M5 vcx VB3 net2 VDD pch l=0.15 w=1 nf=1 m=1
M6 vo VB3 net4 VDD pch l=0.15 w=1 nf=1 m=1
M7 vcx vn net3 VSS nch l=0.15 w=1 nf=1 m=1
M8 vo vp net3 VSS nch l=0.15 w=1 nf=1 m=1
M9 net3 VB4 VSS VSS nch l=0.15 w=1 nf=1 m=1
R1 net0 VSS 1k
.ends opamp

.subckt dut VDD VSS vci phi1 phi2 vco
C1 net1 VSS 1p
C2 net0 vco 1p
M1 vci phi1 net1 VSS nch l=0.15 w=1 nf=1 m=1
M2 net1 phi2 net0 VSS nch l=0.15 w=1 nf=1 m=1
X1 VDD VSS net0 net1 vco VSS opamp
.ends dut
