* official Analog Canvas netlist; PDK X cards rewritten by convert.py
.model nch nmos
.model pch pmos
.model qpnp pnp

.subckt dut VDD VSS Vout
M1 net2 net3 VDD VDD pch l=0.15 w=1 nf=1 m=1
M10 VB3 VB1 VDD VDD pch l=0.15 w=1 nf=1 m=1
M11 VB1 VB1 VDD VDD pch l=0.15 w=1 nf=1 m=1
M12 VB2 VB2 VDD VDD pch l=0.15 w=1 nf=1 m=1
M13 net6 VB2 VDD VDD pch l=0.15 w=1 nf=1 m=1
M14 VB3 VB3 VSS VSS nch l=0.15 w=1 nf=1 m=1
M15 VB1 net1 VSS VSS nch l=0.15 w=1 nf=1 m=1
M16 VB2 net6 net1 VSS nch l=0.15 w=1 nf=1 m=1
M17 net6 net1 VSS VSS nch l=0.15 w=1 nf=1 m=1
M2 net3 net3 VDD VDD pch l=0.15 w=1 nf=1 m=1
M3 net0 net0 VDD VDD pch l=0.15 w=1 nf=1 m=1
M4 Vout net0 VDD VDD pch l=0.15 w=1 nf=1 m=1
M5 net3 Y net5 VSS nch l=0.15 w=1 nf=1 m=1
M6 net0 X net5 VSS nch l=0.15 w=1 nf=1 m=1
M7 net5 VB3 VSS VSS nch l=0.15 w=1 nf=1 m=1
M8 net2 net2 VSS VSS nch l=0.15 w=1 nf=1 m=1
M9 Vout net2 VSS VSS nch l=0.15 w=1 nf=1 m=1
Q1 VSS VSS X qpnp m=1
Q2 VSS VSS net4 qpnp m=1
R1 Vout X 1k
R2 Vout Y 1k
R3 Y net4 1k
R4 net1 VSS 1k
.ends dut
