* official Analog Canvas netlist; PDK X cards rewritten by convert.py
.model nch nmos
.model pch pmos

.subckt dut VDD VSS VIN VB1 VREF VB4 VB3 VB2 VOUT
CF1 VOUT VFB 1p
Cm1 VOUT V1 1p
Cm2 V1 net0 1p
M11 net2 VBN VSS VSS nch l=0.15 w=1 nf=1 m=1
M12 VY VFB net2 VSS nch l=0.15 w=1 nf=1 m=1
M13 VX VREF net2 VSS nch l=0.15 w=1 nf=1 m=1
M14 VY VY VIN VDD pch l=0.15 w=1 nf=1 m=1
M15 VX VX VIN VDD pch l=0.15 w=1 nf=1 m=1
M16 V1 VY VIN VDD pch l=0.15 w=1 nf=1 m=1
M17 net1 net1 VSS VSS nch l=0.15 w=1 nf=1 m=1
M18 V1 net1 VSS VSS nch l=0.15 w=1 nf=1 m=1
M19 net1 VX VIN VDD pch l=0.15 w=1 nf=1 m=1
M21 net3 V1 VSS VSS nch l=0.15 w=1 nf=1 m=1
M22 net7 VX VSS VSS nch l=0.15 w=1 nf=1 m=1
M23 net3 net3 VIN VDD pch l=0.15 w=1 nf=1 m=1
M24 net7 net3 VIN VDD pch l=0.15 w=1 nf=1 m=1
M25 VX VB4 VIN VDD pch l=0.15 w=1 nf=1 m=1
M26 VX V1 VSS VSS nch l=0.15 w=1 nf=1 m=1
M27 VX VX VSS VSS nch l=0.15 w=1 nf=1 m=1
MB1 VB1 VB1 VIN VDD pch l=0.15 w=1 nf=1 m=1
MB2 VB1 VBN VSS VSS nch l=0.15 w=1 nf=1 m=1
MB3 VBN VBN VSS VSS nch l=0.15 w=1 nf=1 m=1
MB4 VBN net6 VIN VDD pch l=0.15 w=1 nf=1 m=1
MB5 net6 net6 net8 VDD pch l=0.15 w=1 nf=1 m=1
MD1 net0 V1 VSS VSS nch l=0.15 w=1 nf=1 m=1
MD2 net4 VB2 VSS VSS nch l=0.15 w=1 nf=1 m=1
MD3 net5 net0 net4 VSS nch l=0.15 w=1 nf=1 m=1
MD4 VY VB3 net4 VSS nch l=0.15 w=1 nf=1 m=1
MD5 net0 VY VIN VDD pch l=0.15 w=1 nf=1 m=1
MD6 net5 net5 VIN VDD pch l=0.15 w=1 nf=1 m=1
MD7 VY VY VIN VDD pch l=0.15 w=1 nf=1 m=1
MPT VOUT net7 VIN VDD pch l=0.15 w=1 nf=1 m=1
RB1 VIN net8 1k
RB2 net6 VSS 1k
RF1 VOUT VFB 1k
RF2 VFB VSS 1k
.ends dut
