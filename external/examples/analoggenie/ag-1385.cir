* official Analog Canvas netlist; PDK X cards rewritten by convert.py
.model nch nmos
.model pch pmos

.subckt dut VDD VSS VSTO VCONT1 VCONT2 VCONT3 VOUT VB1 VB3 VB2 VB4
CL VOUT VSS 1p
CSTO VSTO VSS 1p
LRX VX VY 1n
M10 net0 VM VSS VSS nch l=0.15 w=1 nf=1 m=1
M11 net2 VG VX VSS nch l=0.15 w=1 nf=1 m=1
M12 VX VB2 VSS VSS nch l=0.15 w=1 nf=1 m=1
M13 net1 VY VX VSS nch l=0.15 w=1 nf=1 m=1
M14 VP VP VDD VDD pch l=0.15 w=1 nf=1 m=1
M15 VM VP VDD VDD pch l=0.15 w=1 nf=1 m=1
M16 VP VM VB4 VSS nch l=0.15 w=1 nf=1 m=1
M17 VM VB4 VSS VSS nch l=0.15 w=1 nf=1 m=1
M18 VC VP VDD VDD pch l=0.15 w=1 nf=1 m=1
M19 VC VC net3 VSS nch l=0.15 w=1 nf=1 m=1
M20 net3 VC VSS VSS nch l=0.15 w=1 nf=1 m=1
M3 net2 VB1 VDD VDD pch l=0.15 w=1 nf=1 m=1
M4 net1 VB1 VDD VDD pch l=0.15 w=1 nf=1 m=1
M5 VG VB3 net2 VDD pch l=0.15 w=1 nf=1 m=1
M6 VM VB3 net1 VDD pch l=0.15 w=1 nf=1 m=1
M7 VG VC net4 VSS nch l=0.15 w=1 nf=1 m=1
M8 VM VC net0 VSS nch l=0.15 w=1 nf=1 m=1
M9 net4 VM VSS VSS nch l=0.15 w=1 nf=1 m=1
MN1 VX VCONT2 VSS VSS nch l=0.15 w=1 nf=1 m=1
MN2 VY VCONT3 VSS VSS nch l=0.15 w=1 nf=1 m=1
MP2 VY VG VOUT VDD pch l=0.15 w=1 nf=1 m=1
MP3 VX VCONT1 VSTO VDD pch l=0.15 w=1 nf=1 m=1
R1 VB4 VSS 1k
.ends dut
