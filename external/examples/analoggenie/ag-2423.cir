* official Analog Canvas netlist; PDK X cards rewritten by convert.py
.model nch nmos
.model pch pmos

.subckt AEA VDD VSS INN OUT VB
M10 OUT OUT VSS VSS nch l=0.15 w=1 nf=1 m=1
M11 net0 OUT net2 VSS nch l=0.15 w=1 nf=1 m=1
M12 net2 VB VSS VSS nch l=0.15 w=1 nf=1 m=1
M4 net1 net1 VDD VDD pch l=0.15 w=1 nf=1 m=1
M5 OUT net1 VDD VDD pch l=0.15 w=1 nf=1 m=1
M6 OUT net0 VDD VDD pch l=0.15 w=1 nf=1 m=1
M7 net0 net0 VDD VDD pch l=0.15 w=1 nf=1 m=1
M8 net1 INN net2 VSS nch l=0.15 w=1 nf=1 m=1
M9 OUT OUT VSS VSS nch l=0.15 w=1 nf=1 m=1
.ends AEA

.subckt Bias_Circuit VDD VSS VB
M13 net1 net0 VDD VDD pch l=0.15 w=1 nf=1 m=1
M14 net0 net0 VDD VDD pch l=0.15 w=1 nf=1 m=1
M15 net2 net0 VDD VDD pch l=0.15 w=1 nf=1 m=1
M16 VB net0 VDD VDD pch l=0.15 w=1 nf=1 m=1
M17 net0 net2 net3 VSS nch l=0.15 w=1 nf=1 m=1
M18 net1 net1 VSS VSS nch l=0.15 w=1 nf=1 m=1
M19 net3 net1 VSS VSS nch l=0.15 w=1 nf=1 m=1
M20 net2 net3 VSS VSS nch l=0.15 w=1 nf=1 m=1
M21 VB VB VSS VSS nch l=0.15 w=1 nf=1 m=1
.ends Bias_Circuit

.subckt dut VDD VSS VIN VOUT VERR VREF
M1 net2 VEAOUT VIN VDD pch l=0.15 w=1 nf=1 m=1
M2 net4 net4 net2 VDD pch l=0.15 w=1 nf=1 m=1
M3 net4 nb VSS VSS nch l=0.15 w=1 nf=1 m=1
MBIAS VERR nb VSS VSS nch l=0.15 w=1 nf=1 m=1
MCHG net1 pb VIN VDD pch l=0.15 w=1 nf=1 m=1
MCTRL VERR net4 VOUT VDD pch l=0.15 w=1 nf=1 m=1
MGEN net3 net3 VSS VSS nch l=0.15 w=1 nf=1 m=1
MINJ VERR net3 VSS VSS nch l=0.15 w=1 nf=1 m=1
MRES VOUT VERR VIN VDD pch l=0.15 w=1 nf=1 m=1
MSEN net3 VEAOUT net1 VDD pch l=0.15 w=1 nf=1 m=1
X1 VDD VSS VREF VEAOUT net0 AEA
X2 VDD VSS net0 Bias_Circuit
.ends dut
