* official Analog Canvas netlist; PDK X cards rewritten by convert.py
.model nch nmos
.model pch pmos

.subckt EA1 VDD VSS INP INN OUT
M12 net1 net4 VDD VDD pch l=0.15 w=1 nf=1 m=1
M13 net5 net4 VDD VDD pch l=0.15 w=1 nf=1 m=1
M14 net4 VB2 net1 VDD pch l=0.15 w=1 nf=1 m=1
M15 OUT VB2 net5 VDD pch l=0.15 w=1 nf=1 m=1
M16 net4 VCN net7 VSS nch l=0.15 w=1 nf=1 m=1
M17 OUT VCN net2 VSS nch l=0.15 w=1 nf=1 m=1
M18 net7 VBN VSS VSS nch l=0.15 w=1 nf=1 m=1
M19 net2 VBN VSS VSS nch l=0.15 w=1 nf=1 m=1
M20 net8 VB1 VDD VDD pch l=0.15 w=1 nf=1 m=1
M21 net7 INP net8 VDD pch l=0.15 w=1 nf=1 m=1
M22 net2 INN net8 VDD pch l=0.15 w=1 nf=1 m=1
M23 VCN VBP VDD VDD pch l=0.15 w=1 nf=1 m=1
M24 VCN VCN VBN VSS nch l=0.15 w=1 nf=1 m=1
M25 VBN VBN VSS VSS nch l=0.15 w=1 nf=1 m=1
M26 VBP VBP VDD VDD pch l=0.15 w=1 nf=1 m=1
M27 VBP net6 VSS VSS nch l=0.15 w=1 nf=1 m=1
M28 net9 VBP VDD VDD pch l=0.15 w=1 nf=1 m=1
M29 net9 net9 net6 VSS nch l=0.15 w=1 nf=1 m=1
M30 net6 net9 net0 VSS nch l=0.15 w=1 nf=1 m=1
M31 net3 VBP VDD VDD pch l=0.15 w=1 nf=1 m=1
M32 net3 net3 net0 VSS nch l=0.15 w=1 nf=1 m=1
M33 net0 net3 VB3 VSS nch l=0.15 w=1 nf=1 m=1
M34 VB3 VBP VDD VDD pch l=0.15 w=1 nf=1 m=1
M35 VB3 VB3 VSS VSS nch l=0.15 w=1 nf=1 m=1
.ends EA1

.subckt dut VDD VSS VCONT1 VCONT2 VCONT3 VIN VB4 VCONT4 VCONT5 VP VREF
.model DIODE D(IS=1e-14 N=1)
CFLY VX1 VX2 1p
CO VP VN 1p
COP VP VSS 1p
D1 VN VX2 DIODE
L1 VX1 VX3 1n
M1 VX1 VCONT2 VIN VDD pch l=0.15 w=1 nf=1 m=1
M10 net0 net2 net3 VDD pch l=0.15 w=1 nf=1 m=1
M11 net0 VB4 VSS VSS nch l=0.15 w=1 nf=1 m=1
M2 VX2 VCONT3 VIN VDD pch l=0.15 w=1 nf=1 m=1
M3 VX3 VCONT5 VP VDD pch l=0.15 w=1 nf=1 m=1
M4 VX3 VCONT4 VSS VSS nch l=0.15 w=1 nf=1 m=1
M5 net3 VCONT1 VIN VDD pch l=0.15 w=1 nf=1 m=1
M6 VX1 net1 net3 VDD pch l=0.15 w=1 nf=1 m=1
M7 net1 net1 net3 VDD pch l=0.15 w=1 nf=1 m=1
M8 net1 net0 VSS VSS nch l=0.15 w=1 nf=1 m=1
M9 net0 net0 VSS VSS nch l=0.15 w=1 nf=1 m=1
R1 VP VFP1 1k
R2 VFP1 VSS 1k
X1 VDD VSS VREF VFP1 net2 EA1
.ends dut
