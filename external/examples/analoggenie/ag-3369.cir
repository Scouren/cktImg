* official Analog Canvas netlist; PDK X cards rewritten by convert.py
.model nch nmos
.model pch pmos

.subckt dut VDD VSS vci vco phi1 phi2
C1 net5 net2 1p
C2 net4 vco 1p
M1 vci phi1 net5 VSS nch l=0.15 w=1 nf=1 m=1
M10 net3 VB4 net1 VDD pch l=0.15 w=1 nf=1 m=1
M11 vco VB4 net6 VDD pch l=0.15 w=1 nf=1 m=1
M12 VB3 VB1 VDD VDD pch l=0.15 w=1 nf=1 m=1
M13 VB1 VB1 VDD VDD pch l=0.15 w=1 nf=1 m=1
M14 net0 VB2 VDD VDD pch l=0.15 w=1 nf=1 m=1
M15 VB2 VB2 VDD VDD pch l=0.15 w=1 nf=1 m=1
M16 VB3 VB3 VSS VSS nch l=0.15 w=1 nf=1 m=1
M17 VB1 net0 VSS VSS nch l=0.15 w=1 nf=1 m=1
M18 net7 net0 VSS VSS nch l=0.15 w=1 nf=1 m=1
M19 VB2 net0 VSS VSS nch l=0.15 w=1 nf=1 m=1
M2 net5 phi2 VSS VSS nch l=0.15 w=1 nf=1 m=1
M3 net2 phi1 VSS VSS nch l=0.15 w=1 nf=1 m=1
M4 net2 phi2 net4 VSS nch l=0.15 w=1 nf=1 m=1
M5 net3 net4 net8 VSS nch l=0.15 w=1 nf=1 m=1
M6 vco VSS net8 VSS nch l=0.15 w=1 nf=1 m=1
M7 net8 VB3 VSS VSS nch l=0.15 w=1 nf=1 m=1
M8 net1 net3 VDD VDD pch l=0.15 w=1 nf=1 m=1
M9 net6 net3 VDD VDD pch l=0.15 w=1 nf=1 m=1
R1 net0 net7 1k
.ends dut
