* official Analog Canvas netlist; PDK X cards rewritten by convert.py
.model nch nmos
.model pch pmos

.subckt dut VDD VSS GND vin- vin+ IBIAS vout
Cc vout net3 1p
CL vout GND 1p
CM net0 GND 1p
M1 net0 vin- net1 VSS nch l=0.15 w=1 nf=1 m=1
M10 net2 net2 VA VDD pch l=0.15 w=1 nf=1 m=1
M11 VA VA VDD VDD pch l=0.15 w=1 nf=1 m=1
M12 IBIAS IBIAS VSS VSS nch l=0.15 w=1 nf=1 m=1
M2 VB vin+ net1 VSS nch l=0.15 w=1 nf=1 m=1
M3 net0 net0 VDD VDD pch l=0.15 w=1 nf=1 m=1
M4 VB net0 VDD VDD pch l=0.15 w=1 nf=1 m=1
M5 net1 IBIAS VSS VSS nch l=0.15 w=1 nf=1 m=1
M6 vout VB VDD VDD pch l=0.15 w=1 nf=1 m=1
M7 vout IBIAS VSS VSS nch l=0.15 w=1 nf=1 m=1
M8 net3 net2 VB VDD pch l=0.15 w=1 nf=1 m=1
M9 net2 IBIAS VSS VSS nch l=0.15 w=1 nf=1 m=1
.ends dut
