* official Analog Canvas netlist; PDK X cards rewritten by convert.py
.model nch nmos

.subckt dut VDD VSS Vout Vb
C1 net0 net1 1p
M1 Vout net1 VSS VSS nch l=0.15 w=1 nf=1 m=1
R1 net1 Vb 1k
RD VDD Vout 1k
Vin net0 VSS DC 1
.ends dut
