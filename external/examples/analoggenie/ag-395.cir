* official Analog Canvas netlist; PDK X cards rewritten by convert.py
.model nch nmos
.model pch pmos

.subckt dut VDD VSS VINP VINN VCM VB VOUTN VOUTP S1 S2 S3 S4 S5 S6
.model ideal_switch SW(RON=1 ROFF=1e12 VT=0.5 VH=0)
C1 net3 net0 1p
C2 net1 net4 1p
C3 VOUTN net3 1p
C4 net1 VOUTP 1p
ISS net2 VSS DC 1m
M1 VOUTN net3 net2 VSS nch l=0.15 w=1 nf=1 m=1
M2 VOUTP net1 net2 VSS nch l=0.15 w=1 nf=1 m=1
M3 VOUTN VB VDD VDD pch l=0.15 w=1 nf=1 m=1
M4 VOUTP VB VDD VDD pch l=0.15 w=1 nf=1 m=1
S1 VINP net0 S1 VSS ideal_switch
S2 VINN net4 S2 VSS ideal_switch
S3 VCM net0 S3 VSS ideal_switch
S4 net4 VCM S4 VSS ideal_switch
S5 net3 VOUTN S5 VSS ideal_switch
S6 VOUTP net1 S6 VSS ideal_switch
.ends dut
