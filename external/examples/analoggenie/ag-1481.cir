* official Analog Canvas netlist; PDK X cards rewritten by convert.py
.model nch nmos
.model pch pmos
.model qnpn npn

.subckt opamp VDD VSS INN INP VB1 VB2 OUT
M1 net6 VB1 VDD VDD pch l=0.15 w=1 nf=1 m=1
M10 net5 INP net3 VSS nch l=0.15 w=1 nf=1 m=1
M11 net3 VB4 VSS VSS nch l=0.15 w=1 nf=1 m=1
M12 net0 net0 VDD VDD pch l=0.15 w=1 nf=1 m=1
M13 VB3 net0 VDD VDD pch l=0.15 w=1 nf=1 m=1
M14 VB3 VB3 VB4 VSS nch l=0.15 w=1 nf=1 m=1
M15 VB4 VB4 VSS VSS nch l=0.15 w=1 nf=1 m=1
M2 net5 VB1 VDD VDD pch l=0.15 w=1 nf=1 m=1
M3 net4 VB2 net6 VDD pch l=0.15 w=1 nf=1 m=1
M4 OUT VB2 net5 VDD pch l=0.15 w=1 nf=1 m=1
M5 net4 VB3 net1 VSS nch l=0.15 w=1 nf=1 m=1
M6 OUT VB3 net2 VSS nch l=0.15 w=1 nf=1 m=1
M7 net1 net4 VSS VSS nch l=0.15 w=1 nf=1 m=1
M8 net2 net4 VSS VSS nch l=0.15 w=1 nf=1 m=1
M9 net6 INN net3 VSS nch l=0.15 w=1 nf=1 m=1
R1 net0 VSS 1k
.ends opamp

.subckt dut VDD VSS VB1 VB2 Vout
Q1 X X VSS VSS qnpn m=1
Q2 net0 net0 VSS VSS qnpn m=1
R1 Vout X 1k
R2 Vout Y 1k
R3 Y net0 1k
X1 VDD VSS Y X VB1 VB2 Vout opamp
.ends dut
