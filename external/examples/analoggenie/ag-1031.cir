* official Analog Canvas netlist; PDK X cards rewritten by convert.py
.model nch nmos
.model pch pmos

.subckt dut VDD VSS GND vin- vin+ VBIAS vout
CII vout GND 1p
M1 net0 vin- net6 VSS nch l=0.15 w=1 nf=1 m=1
M10 net3 VE VSS VSS nch l=0.15 w=1 nf=1 m=1
M11 net7 VE VSS VSS nch l=0.15 w=1 nf=1 m=1
M12 vout VC net7 VSS nch l=0.15 w=1 nf=1 m=1
M13 net4 VBIAS VSS VSS nch l=0.15 w=1 nf=1 m=1
M14 net5 net4 net1 VDD pch l=0.15 w=1 nf=1 m=1
M15 net1 net5 VDD VDD pch l=0.15 w=1 nf=1 m=1
M2 net2 vin+ net6 VSS nch l=0.15 w=1 nf=1 m=1
M3 net0 net0 VDD VDD pch l=0.15 w=1 nf=1 m=1
M4 net2 net2 VDD VDD pch l=0.15 w=1 nf=1 m=1
M5 net6 VBIAS VSS VSS nch l=0.15 w=1 nf=1 m=1
M6 net8 net2 VDD VDD pch l=0.15 w=1 nf=1 m=1
M7 vout net4 net8 VDD pch l=0.15 w=1 nf=1 m=1
M8 VC net0 VDD VDD pch l=0.15 w=1 nf=1 m=1
M9 VE VC net3 VSS nch l=0.15 w=1 nf=1 m=1
R1 VC VE 1k
R2 net5 net4 1k
.ends dut
