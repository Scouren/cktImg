* official Analog Canvas netlist; PDK X cards rewritten by convert.py
.model nch nmos
.model pch pmos

.subckt Opamp VDD VSS INN INP OUT VX VB1
M1 net2 INP net1 VSS nch l=0.15 w=1 nf=1 m=1
M10 net0 net0 VSS VSS nch l=0.15 w=1 nf=1 m=1
M11 VB3 net0 VSS VSS nch l=0.15 w=1 nf=1 m=1
M12 net0 VB3 VDD VDD pch l=0.15 w=1 nf=1 m=1
M13 VB3 VB3 VDD VDD pch l=0.15 w=1 nf=1 m=1
M14 VB1 net0 VSS VSS nch l=0.15 w=1 nf=1 m=1
M15 VB1 VB1 VDD VDD pch l=0.15 w=1 nf=1 m=1
M16 VB2 VB1 VDD VDD pch l=0.15 w=1 nf=1 m=1
M17 VB2 VB2 VSS VSS nch l=0.15 w=1 nf=1 m=1
M2 VX INN net1 VSS nch l=0.15 w=1 nf=1 m=1
M3 net2 net2 VDD VDD pch l=0.15 w=1 nf=1 m=1
M4 VX VX VDD VDD pch l=0.15 w=1 nf=1 m=1
M5 OUT net2 VDD VDD pch l=0.15 w=1 nf=1 m=1
M6 VB3 VX VDD VDD pch l=0.15 w=1 nf=1 m=1
M7 OUT VB3 VSS VSS nch l=0.15 w=1 nf=1 m=1
M8 VB3 VB3 VSS VSS nch l=0.15 w=1 nf=1 m=1
M9 net1 VB2 VSS VSS nch l=0.15 w=1 nf=1 m=1
R4 VDD net0 1k
.ends Opamp

.subckt dut VDD VSS Vref VIN VOUT VB1
CL VOUT VX 1p
MNP VIN net0 VOUT VSS nch l=0.15 w=1 nf=1 m=1
R1 VOUT FB 1k
R2 FB VSS 1k
R3 VX VSS 1k
X1 VDD VSS FB Vref net0 VX VB1 Opamp
.ends dut
