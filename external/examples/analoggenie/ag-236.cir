* official Analog Canvas netlist; PDK X cards rewritten by convert.py
.model nch nmos

.subckt dut VDD VSS Iin Vb Iout
M1 Iout Vb Iin VSS nch l=0.15 w=1 nf=1 m=1
.ends dut
