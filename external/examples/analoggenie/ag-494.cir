* official Analog Canvas netlist; PDK X cards rewritten by convert.py
.model nch nmos

.subckt dut VSS VLO1 VRF1 VIF1
C1 VRF1 VLO1 1p
C2 VLO1 VIF1 1p
M1 VIF1 VLO1 VRF1 VSS nch l=0.15 w=1 nf=1 m=1
RL VIF1 VSS 1k
.ends dut
