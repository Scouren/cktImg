* official Analog Canvas netlist; PDK X cards rewritten by convert.py
.model nch nmos
.model pch pmos

.subckt dut VDD VSS VB4 VB1 VB3 VB2 VB5 IB VIN VOUT VREF
CL VOUT net1 1p
M10 EAO VB3 VZ VDD pch l=0.15 w=1 nf=1 m=1
M11 net5 VX VDD VDD pch l=0.15 w=1 nf=1 m=1
M12 VZ VX VDD VDD pch l=0.15 w=1 nf=1 m=1
M13 VY VB5 VDD VDD pch l=0.15 w=1 nf=1 m=1
M14 VX EAO VY VDD pch l=0.15 w=1 nf=1 m=1
M15 VX VX VSS VSS nch l=0.15 w=1 nf=1 m=1
M16 GATE VX VSS VSS nch l=0.15 w=1 nf=1 m=1
M17 VDD VY GATE VSS nch l=0.15 w=1 nf=1 m=1
M18 VZ EAO IB VSS nch l=0.15 w=1 nf=1 m=1
M19 VZ VZ VDD VDD pch l=0.15 w=1 nf=1 m=1
M2 net0 VB1 VDD VDD pch l=0.15 w=1 nf=1 m=1
M20 GATE VZ VDD VDD pch l=0.15 w=1 nf=1 m=1
M21 VSS IB GATE VDD pch l=0.15 w=1 nf=1 m=1
M22 VBN net2 VDD VDD pch l=0.15 w=1 nf=1 m=1
M23 VBN VBN net6 VSS nch l=0.15 w=1 nf=1 m=1
M24 net6 VBN VSS VSS nch l=0.15 w=1 nf=1 m=1
M25 net2 net2 VDD VDD pch l=0.15 w=1 nf=1 m=1
M26 net2 net0 VB4 VSS nch l=0.15 w=1 nf=1 m=1
M27 net0 net2 VDD VDD pch l=0.15 w=1 nf=1 m=1
M28 net0 VB4 VSS VSS nch l=0.15 w=1 nf=1 m=1
M3 net3 VREF net0 VDD pch l=0.15 w=1 nf=1 m=1
M4 net4 FB net0 VDD pch l=0.15 w=1 nf=1 m=1
M5 net3 VB2 VSS VSS nch l=0.15 w=1 nf=1 m=1
M6 net4 VB2 VSS VSS nch l=0.15 w=1 nf=1 m=1
M7 VX VBN net3 VSS nch l=0.15 w=1 nf=1 m=1
M8 EAO VBN net4 VSS nch l=0.15 w=1 nf=1 m=1
M9 VX VB3 net5 VDD pch l=0.15 w=1 nf=1 m=1
MNP VIN GATE VOUT VSS nch l=0.15 w=1 nf=1 m=1
R1 FB VSS 1k
R2 VOUT FB 1k
R3 VB4 VSS 1k
R4 net1 VSS 1k
RL VOUT VSS 1k
.ends dut
