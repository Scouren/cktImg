* official Analog Canvas netlist; PDK X cards rewritten by convert.py
.model nch nmos
.model pch pmos
.model qpnp pnp

.subckt opamp VDD VSS INN INP OUT
M10 net0 net0 VSS VSS nch l=0.15 w=1 nf=1 m=1
M11 OUT net0 VSS VSS nch l=0.15 w=1 nf=1 m=1
M12 VB2 VB2 VDD VDD pch l=0.15 w=1 nf=1 m=1
M13 VB2 net3 net5 VSS nch l=0.15 w=1 nf=1 m=1
M14 net3 VB2 VDD VDD pch l=0.15 w=1 nf=1 m=1
M15 net3 net3 VSS VSS nch l=0.15 w=1 nf=1 m=1
M16 net2 net2 VDD VDD pch l=0.15 w=1 nf=1 m=1
M17 net2 net3 VSS VSS nch l=0.15 w=1 nf=1 m=1
M18 VB3 net2 VDD VDD pch l=0.15 w=1 nf=1 m=1
M19 VB3 VB3 VSS VSS nch l=0.15 w=1 nf=1 m=1
M20 VB1 VB1 VDD VDD pch l=0.15 w=1 nf=1 m=1
M21 VB1 VB3 VSS VSS nch l=0.15 w=1 nf=1 m=1
M3 net6 INN net4 VSS nch l=0.15 w=1 nf=1 m=1
M4 net1 INP net4 VSS nch l=0.15 w=1 nf=1 m=1
M5 net1 net1 VDD VDD pch l=0.15 w=1 nf=1 m=1
M6 net6 net6 VDD VDD pch l=0.15 w=1 nf=1 m=1
M7 OUT net1 VDD VDD pch l=0.15 w=1 nf=1 m=1
M8 net0 net6 VDD VDD pch l=0.15 w=1 nf=1 m=1
M9 net4 VB3 VSS VSS nch l=0.15 w=1 nf=1 m=1
R1 net5 VSS 1k
.ends opamp

.subckt dut VDD VSS Vout
Q1 VSS VSS net1 qpnp m=1
Q2 net1 net1 X qpnp m=1
Q3 VSS VSS net2 qpnp m=1
Q4 net2 net2 net0 qpnp m=1
R1 Vout X 1k
R2 Vout Y 1k
R3 Y net0 1k
X1 VDD VSS Y X Vout opamp
.ends dut
