* official Analog Canvas netlist; PDK X cards rewritten by convert.py
.model nch nmos
.model pch pmos

.subckt opamp VDD VSS vcx INN OUT INP
M10 VB3 VB2 VDD VDD pch l=0.15 w=1 nf=1 m=1
M11 VB3 VB3 VSS VSS nch l=0.15 w=1 nf=1 m=1
M12 VB1 VB2 VDD VDD pch l=0.15 w=1 nf=1 m=1
M13 net4 VB2 VDD VDD pch l=0.15 w=1 nf=1 m=1
M14 net5 VB2 VDD VDD pch l=0.15 w=1 nf=1 m=1
M15 VB2 VB2 VDD VDD pch l=0.15 w=1 nf=1 m=1
M16 net4 net4 net7 VSS nch l=0.15 w=1 nf=1 m=1
M17 net7 net4 VB1 VSS nch l=0.15 w=1 nf=1 m=1
M18 net5 net5 net3 VSS nch l=0.15 w=1 nf=1 m=1
M19 net3 net5 net7 VSS nch l=0.15 w=1 nf=1 m=1
M20 VB2 net3 VSS VSS nch l=0.15 w=1 nf=1 m=1
M21 VB1 VB1 VSS VSS nch l=0.15 w=1 nf=1 m=1
M3 vcx INN net1 VSS nch l=0.15 w=1 nf=1 m=1
M4 OUT INP net1 VSS nch l=0.15 w=1 nf=1 m=1
M5 net1 VB3 VSS VSS nch l=0.15 w=1 nf=1 m=1
M6 net0 vcx VDD VDD pch l=0.15 w=1 nf=1 m=1
M7 net6 vcx VDD VDD pch l=0.15 w=1 nf=1 m=1
M8 vcx net2 net0 VDD pch l=0.15 w=1 nf=1 m=1
M9 OUT net2 net6 VDD pch l=0.15 w=1 nf=1 m=1
.ends opamp

.subckt dut VDD VSS vci phi1 phi2 vco
C1 vcx VSS 1p
C2 net0 vco 1p
M1 vci phi1 vcx VSS nch l=0.15 w=1 nf=1 m=1
M2 vcx phi2 net0 VSS nch l=0.15 w=1 nf=1 m=1
X1 VDD VSS vcx net0 vco VSS opamp
.ends dut
