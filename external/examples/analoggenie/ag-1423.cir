* official Analog Canvas netlist; PDK X cards rewritten by convert.py
.model nch nmos
.model pch pmos

.subckt dut VDD VSS VSTO VCONT1 VCONT2 VCONT3 VOUT
CL VOUT VSS 1p
CSTO VSTO VSS 1p
LRX net2 VX 1n
M10 net4 net4 VSS VSS nch l=0.15 w=1 nf=1 m=1
M11 net0 VX net3 VSS nch l=0.15 w=1 nf=1 m=1
M12 VG VG net3 VSS nch l=0.15 w=1 nf=1 m=1
M13 net3 VB3 VSS VSS nch l=0.15 w=1 nf=1 m=1
M14 VB2 VB2 VDD VDD pch l=0.15 w=1 nf=1 m=1
M15 net1 VB2 VDD VDD pch l=0.15 w=1 nf=1 m=1
M16 VB1 VB1 VDD VDD pch l=0.15 w=1 nf=1 m=1
M17 VB3 VB1 VDD VDD pch l=0.15 w=1 nf=1 m=1
M18 VB2 net1 net5 VSS nch l=0.15 w=1 nf=1 m=1
M19 net1 net1 VSS VSS nch l=0.15 w=1 nf=1 m=1
M20 VB1 net1 VSS VSS nch l=0.15 w=1 nf=1 m=1
M21 VB3 VB3 VSS VSS nch l=0.15 w=1 nf=1 m=1
M5 net0 net0 VDD VDD pch l=0.15 w=1 nf=1 m=1
M6 net4 net0 VDD VDD pch l=0.15 w=1 nf=1 m=1
M7 VG VG VDD VDD pch l=0.15 w=1 nf=1 m=1
M8 VG VG VDD VDD pch l=0.15 w=1 nf=1 m=1
M9 VG net4 VSS VSS nch l=0.15 w=1 nf=1 m=1
MN1 net2 VCONT2 VSS VSS nch l=0.15 w=1 nf=1 m=1
MN2 VX VCONT3 VSS VSS nch l=0.15 w=1 nf=1 m=1
MP2 VX VG VOUT VDD pch l=0.15 w=1 nf=1 m=1
MP3 net2 VCONT1 VSTO VDD pch l=0.15 w=1 nf=1 m=1
R1 net5 VSS 1k
.ends dut
