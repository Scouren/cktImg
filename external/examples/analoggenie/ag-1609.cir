* official Analog Canvas netlist; PDK X cards rewritten by convert.py
.model nch nmos
.model pch pmos
.model qpnp pnp

.subckt A1 VDD VSS INN INP OUT
M1 net1 net1 VDD VDD pch l=0.15 w=1 nf=1 m=1
M10 VX VX VSS VSS nch l=0.15 w=1 nf=1 m=1
M11 OUT VX VSS VSS nch l=0.15 w=1 nf=1 m=1
M12 VB2 net0 VDD VDD pch l=0.15 w=1 nf=1 m=1
M13 net0 net0 VDD VDD pch l=0.15 w=1 nf=1 m=1
M14 net4 net0 VDD VDD pch l=0.15 w=1 nf=1 m=1
M15 net0 net4 net5 VSS nch l=0.15 w=1 nf=1 m=1
M16 net4 net5 VSS VSS nch l=0.15 w=1 nf=1 m=1
M17 VB2 VB2 VSS VSS nch l=0.15 w=1 nf=1 m=1
M2 net2 net2 VDD VDD pch l=0.15 w=1 nf=1 m=1
M5 OUT net1 VDD VDD pch l=0.15 w=1 nf=1 m=1
M6 VX net2 VDD VDD pch l=0.15 w=1 nf=1 m=1
M7 net2 INN net3 VSS nch l=0.15 w=1 nf=1 m=1
M8 net1 INP net3 VSS nch l=0.15 w=1 nf=1 m=1
M9 net3 VB2 VSS VSS nch l=0.15 w=1 nf=1 m=1
R4 net5 VSS 1k
.ends A1

.subckt dut VDD VSS Vout
Q1 VSS VSS X qpnp m=1
Q2 VSS VSS net0 qpnp m=1
R1 Vout X 1k
R2 Vout Y 1k
R3 Y net0 1k
X1 VDD VSS Y X Vout A1
.ends dut
