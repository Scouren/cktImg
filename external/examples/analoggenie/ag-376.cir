* official Analog Canvas netlist; PDK X cards rewritten by convert.py
.model nch nmos
.model pch pmos
.model qpnp pnp

.subckt dut VDD VSS Iout
M1 net0 net0 X VSS nch l=0.15 w=1 nf=1 m=1
M2 net1 net0 Y VSS nch l=0.15 w=1 nf=1 m=1
M3 net0 net1 VDD VDD pch l=0.15 w=1 nf=1 m=1
M4 net1 net1 VDD VDD pch l=0.15 w=1 nf=1 m=1
M5 Iout net1 VDD VDD pch l=0.15 w=1 nf=1 m=1
Q1 VSS VSS X qpnp m=1
Q2 VSS VSS net2 qpnp m=1
R1 Y net2 1k
.ends dut
