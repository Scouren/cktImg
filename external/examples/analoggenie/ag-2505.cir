* official Analog Canvas netlist; PDK X cards rewritten by convert.py
.model nch nmos
.model pch pmos

.subckt dut VDD VSS VIN VREF VB4 VB3 VB2 VB1 VOUT
CF1 VOUT VFB 1p
Cm1 VOUT V1 1p
Cm2 V1 net4 1p
M11 net6 VBN VSS VSS nch l=0.15 w=1 nf=1 m=1
M12 VX VFB net6 VSS nch l=0.15 w=1 nf=1 m=1
M13 V2 VREF net6 VSS nch l=0.15 w=1 nf=1 m=1
M14 VX VX VIN VDD pch l=0.15 w=1 nf=1 m=1
M15 V2 V2 VIN VDD pch l=0.15 w=1 nf=1 m=1
M16 V2 VB4 VIN VDD pch l=0.15 w=1 nf=1 m=1
M17 V2 V2 VSS VSS nch l=0.15 w=1 nf=1 m=1
M18 V2 V1 VSS VSS nch l=0.15 w=1 nf=1 m=1
M21 net1 V1 VSS VSS nch l=0.15 w=1 nf=1 m=1
M22 net5 V2 VSS VSS nch l=0.15 w=1 nf=1 m=1
M23 net1 net1 VIN VDD pch l=0.15 w=1 nf=1 m=1
M24 net5 net1 VIN VDD pch l=0.15 w=1 nf=1 m=1
M25 V1 VX VIN VDD pch l=0.15 w=1 nf=1 m=1
M26 net0 V2 VIN VDD pch l=0.15 w=1 nf=1 m=1
M27 V1 net0 VSS VSS nch l=0.15 w=1 nf=1 m=1
M28 net0 net0 VSS VSS nch l=0.15 w=1 nf=1 m=1
MB1 net2 net2 VIN VDD pch l=0.15 w=1 nf=1 m=1
MB2 VB1 net2 VIN VDD pch l=0.15 w=1 nf=1 m=1
MB3 net2 VB1 VSS VSS nch l=0.15 w=1 nf=1 m=1
MB4 VB1 VB1 VSS VSS nch l=0.15 w=1 nf=1 m=1
MB5 VBN net2 VIN VDD pch l=0.15 w=1 nf=1 m=1
MB6 VBN VBN VSS VSS nch l=0.15 w=1 nf=1 m=1
MD1 net4 V1 VSS VSS nch l=0.15 w=1 nf=1 m=1
MD2 net7 VB2 VSS VSS nch l=0.15 w=1 nf=1 m=1
MD3 net3 net4 net7 VSS nch l=0.15 w=1 nf=1 m=1
MD4 VX VB3 net7 VSS nch l=0.15 w=1 nf=1 m=1
MD5 net4 VX VIN VDD pch l=0.15 w=1 nf=1 m=1
MD6 net3 net3 VIN VDD pch l=0.15 w=1 nf=1 m=1
MD7 VX VX VIN VDD pch l=0.15 w=1 nf=1 m=1
MPT VOUT net5 VIN VDD pch l=0.15 w=1 nf=1 m=1
RF1 VOUT VFB 1k
RF2 VFB VSS 1k
.ends dut
