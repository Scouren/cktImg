* official Analog Canvas netlist; PDK X cards rewritten by convert.py
.model nch nmos
.model pch pmos

.subckt dut VDD VSS Vref VIN VOUT
CL VOUT VX 1p
M1 VX FB net1 VSS nch l=0.15 w=1 nf=1 m=1
M10 VB3 VB1 VDD VDD pch l=0.15 w=1 nf=1 m=1
M11 VB3 VB3 VSS VSS nch l=0.15 w=1 nf=1 m=1
M12 VB1 VB1 VDD VDD pch l=0.15 w=1 nf=1 m=1
M13 VB1 net3 VSS VSS nch l=0.15 w=1 nf=1 m=1
M14 net3 VB2 VDD VDD pch l=0.15 w=1 nf=1 m=1
M15 net3 net3 VSS VSS nch l=0.15 w=1 nf=1 m=1
M16 VB2 VB2 VDD VDD pch l=0.15 w=1 nf=1 m=1
M17 VB2 net3 net5 VSS nch l=0.15 w=1 nf=1 m=1
M18 net5 net4 VSS VSS nch l=0.15 w=1 nf=1 m=1
M19 net4 VB2 VDD VDD pch l=0.15 w=1 nf=1 m=1
M2 net6 Vref net1 VSS nch l=0.15 w=1 nf=1 m=1
M20 net4 net4 VSS VSS nch l=0.15 w=1 nf=1 m=1
M3 VX VX VDD VDD pch l=0.15 w=1 nf=1 m=1
M4 net6 net6 VDD VDD pch l=0.15 w=1 nf=1 m=1
M5 net0 VX VDD VDD pch l=0.15 w=1 nf=1 m=1
M6 net2 net6 VDD VDD pch l=0.15 w=1 nf=1 m=1
M7 net0 net0 VSS VSS nch l=0.15 w=1 nf=1 m=1
M8 net2 net0 VSS VSS nch l=0.15 w=1 nf=1 m=1
M9 net1 VB3 VSS VSS nch l=0.15 w=1 nf=1 m=1
MNP VIN net2 VOUT VSS nch l=0.15 w=1 nf=1 m=1
R1 VOUT FB 1k
R2 FB VSS 1k
R3 VX VSS 1k
.ends dut
