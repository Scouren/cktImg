* official Analog Canvas netlist; PDK X cards rewritten by convert.py
.model nch nmos
.model pch pmos

.subckt opamp VDD VSS INN INP OUT
M10 net2 INP net5 VSS nch l=0.15 w=1 nf=1 m=1
M11 net5 VB3 VSS VSS nch l=0.15 w=1 nf=1 m=1
M12 net1 net1 VSS VSS nch l=0.15 w=1 nf=1 m=1
M13 OUT net1 VSS VSS nch l=0.15 w=1 nf=1 m=1
M14 VB1 VB1 VDD VDD pch l=0.15 w=1 nf=1 m=1
M15 VB3 VB1 VDD VDD pch l=0.15 w=1 nf=1 m=1
M16 VB1 VB4 VSS VSS nch l=0.15 w=1 nf=1 m=1
M17 VB3 VB3 VSS VSS nch l=0.15 w=1 nf=1 m=1
M18 VB2 VB2 VDD VDD pch l=0.15 w=1 nf=1 m=1
M19 VB4 VB2 VDD VDD pch l=0.15 w=1 nf=1 m=1
M20 net6 VB2 VDD VDD pch l=0.15 w=1 nf=1 m=1
M21 net3 VB2 VDD VDD pch l=0.15 w=1 nf=1 m=1
M22 VB2 VB5 VSS VSS nch l=0.15 w=1 nf=1 m=1
M23 net6 net6 net4 VSS nch l=0.15 w=1 nf=1 m=1
M24 net4 net6 VB4 VSS nch l=0.15 w=1 nf=1 m=1
M25 net3 net3 VB5 VSS nch l=0.15 w=1 nf=1 m=1
M26 VB5 net3 net4 VSS nch l=0.15 w=1 nf=1 m=1
M27 VB4 VB4 VSS VSS nch l=0.15 w=1 nf=1 m=1
M5 net1 net0 VDD VDD pch l=0.15 w=1 nf=1 m=1
M6 net0 net0 VDD VDD pch l=0.15 w=1 nf=1 m=1
M7 net2 net2 VDD VDD pch l=0.15 w=1 nf=1 m=1
M8 OUT net2 VDD VDD pch l=0.15 w=1 nf=1 m=1
M9 net0 INN net5 VSS nch l=0.15 w=1 nf=1 m=1
.ends opamp

.subckt dut VDD VSS vci vco phi1 phi2
C1 net0 net2 1p
C2 net1 vco 1p
M1 vci phi1 net0 VSS nch l=0.15 w=1 nf=1 m=1
M2 net0 phi2 VSS VSS nch l=0.15 w=1 nf=1 m=1
M3 net2 phi1 VSS VSS nch l=0.15 w=1 nf=1 m=1
M4 net2 phi2 net1 VSS nch l=0.15 w=1 nf=1 m=1
X1 VDD VSS net1 VSS vco opamp
.ends dut
