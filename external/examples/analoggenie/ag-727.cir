* official Analog Canvas netlist; PDK X cards rewritten by convert.py
.model nch nmos
.model pch pmos

.subckt dut VDD VSS Vg2 Ic Ib
C1 VDD Ib 1p
C2 Vg2 VSS 1p
M1 Vg2 Vg2 VSS VSS nch l=0.15 w=1 nf=1 m=1
M2 Ic Vg2 VSS VSS nch l=0.15 w=1 nf=1 m=1
M3 Vg2 Ib VDD VDD pch l=0.15 w=1 nf=1 m=1
M4 Ib Ib VDD VDD pch l=0.15 w=1 nf=1 m=1
.ends dut
