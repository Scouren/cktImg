* official Analog Canvas netlist; PDK X cards rewritten by convert.py
.model nch nmos
.model pch pmos

.subckt AMP1 VDD VSS INP INN OUT VB1
M10 INN INP net5 VSS nch l=0.15 w=1 nf=1 m=1
M11 net2 INN net5 VSS nch l=0.15 w=1 nf=1 m=1
M12 net6 net6 VSS VSS nch l=0.15 w=1 nf=1 m=1
M13 OUT net6 VSS VSS nch l=0.15 w=1 nf=1 m=1
M14 net5 VX VSS VSS nch l=0.15 w=1 nf=1 m=1
M15 VP VP VDD VDD pch l=0.15 w=1 nf=1 m=1
M16 net1 VP VDD VDD pch l=0.15 w=1 nf=1 m=1
M17 net0 VP VDD VDD pch l=0.15 w=1 nf=1 m=1
M18 VB1 VP VDD VDD pch l=0.15 w=1 nf=1 m=1
M19 VP net4 VSS VSS nch l=0.15 w=1 nf=1 m=1
M20 net1 net1 net4 VSS nch l=0.15 w=1 nf=1 m=1
M21 net0 net0 net3 VSS nch l=0.15 w=1 nf=1 m=1
M22 VB1 net0 net3 VSS nch l=0.15 w=1 nf=1 m=1
M23 VB1 VB1 VSS VSS nch l=0.15 w=1 nf=1 m=1
M24 net4 net1 net3 VSS nch l=0.15 w=1 nf=1 m=1
M25 VX VP VDD VDD pch l=0.15 w=1 nf=1 m=1
M26 VX VX VSS VSS nch l=0.15 w=1 nf=1 m=1
M6 INN INN VDD VDD pch l=0.15 w=1 nf=1 m=1
M7 net2 net2 VDD VDD pch l=0.15 w=1 nf=1 m=1
M8 net6 net2 VDD VDD pch l=0.15 w=1 nf=1 m=1
M9 OUT INN VDD VDD pch l=0.15 w=1 nf=1 m=1
.ends AMP1

.subckt dut VDD VSS VB1 Vref biasp biascas biasn Vout
C1 Vset VSS 1p
C2 n3 Vout 1p
M1 Vout n3 VDD VDD pch l=0.15 w=1 nf=1 m=1
M2 n1 Vset Vout VDD pch l=0.15 w=1 nf=1 m=1
M3 n1 biasn VSS VSS nch l=0.15 w=1 nf=1 m=1
M4 n3 biasp VDD VDD pch l=0.15 w=1 nf=1 m=1
M5 n3 biascas n1 VSS nch l=0.15 w=1 nf=1 m=1
R1 fb VSS 1k
R2 Vout fb 1k
X1 VDD VSS Vref fb Vset VB1 AMP1
.ends dut
