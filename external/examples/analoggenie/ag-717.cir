* official Analog Canvas netlist; PDK X cards rewritten by convert.py
.model nch nmos
.model pch pmos

.subckt dut VDD VEE VSS Vout+ Vout- VrefCM Vcntrl
I1 VDD net1 DC 1m
I2 VDD net0 DC 1m
M1 net2 Vout+ net1 VDD pch l=0.15 w=1 nf=1 m=1
M2 Vcntrl VrefCM net1 VDD pch l=0.15 w=1 nf=1 m=1
M3 Vcntrl VrefCM net0 VDD pch l=0.15 w=1 nf=1 m=1
M4 net2 Vout- net0 VDD pch l=0.15 w=1 nf=1 m=1
M5 Vcntrl Vcntrl VEE VSS nch l=0.15 w=1 nf=1 m=1
M6 net2 net2 VSS VSS nch l=0.15 w=1 nf=1 m=1
.ends dut
