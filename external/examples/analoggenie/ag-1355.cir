* official Analog Canvas netlist; PDK X cards rewritten by convert.py
.model nch nmos
.model pch pmos

.subckt comparator VDD VSS VB1 VX IN VB2 OUT
M1 net0 net1 VDD VDD pch l=0.15 w=1 nf=1 m=1
M10 net1 IN net5 VSS nch l=0.15 w=1 nf=1 m=1
M11 net4 OUT net5 VSS nch l=0.15 w=1 nf=1 m=1
M12 OUT VB4 net9 VSS nch l=0.15 w=1 nf=1 m=1
M13 net2 VX VSS VSS nch l=0.15 w=1 nf=1 m=1
M14 net5 VB2 VSS VSS nch l=0.15 w=1 nf=1 m=1
M15 net9 VX VSS VSS nch l=0.15 w=1 nf=1 m=1
M16 VB4 net11 VDD VDD pch l=0.15 w=1 nf=1 m=1
M17 net11 net11 VDD VDD pch l=0.15 w=1 nf=1 m=1
M18 VB3 net11 VDD VDD pch l=0.15 w=1 nf=1 m=1
M19 VB4 VB4 net8 VSS nch l=0.15 w=1 nf=1 m=1
M2 net3 net1 VDD VDD pch l=0.15 w=1 nf=1 m=1
M20 net11 VB3 VSS VSS nch l=0.15 w=1 nf=1 m=1
M21 net8 VB4 VSS VSS nch l=0.15 w=1 nf=1 m=1
M22 net6 VB3 VSS VSS nch l=0.15 w=1 nf=1 m=1
M3 net7 net4 VDD VDD pch l=0.15 w=1 nf=1 m=1
M4 net10 net4 VDD VDD pch l=0.15 w=1 nf=1 m=1
M5 VX VB1 net0 VDD pch l=0.15 w=1 nf=1 m=1
M6 net1 VB1 net3 VDD pch l=0.15 w=1 nf=1 m=1
M7 net4 VB1 net7 VDD pch l=0.15 w=1 nf=1 m=1
M8 OUT VB1 net10 VDD pch l=0.15 w=1 nf=1 m=1
M9 VX VB4 net2 VSS nch l=0.15 w=1 nf=1 m=1
R1 VB3 net6 1k
.ends comparator

.subckt dut VDD VSS VSTO VCONT1 VCONT2 VCONT3 VB1 VB2 VOUT
CL VOUT VSS 1p
CSTO VSTO VSS 1p
LRX VX net0 1n
MN1 VX VCONT2 VSS VSS nch l=0.15 w=1 nf=1 m=1
MN2 net0 VCONT3 VSS VSS nch l=0.15 w=1 nf=1 m=1
MP2 net0 net1 VOUT VDD pch l=0.15 w=1 nf=1 m=1
MP3 VX VCONT1 VSTO VDD pch l=0.15 w=1 nf=1 m=1
X1 VDD VSS VB1 VX net0 VB2 net1 comparator
.ends dut
