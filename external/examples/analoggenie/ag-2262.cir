* official Analog Canvas netlist; PDK X cards rewritten by convert.py
.model nch nmos
.model pch pmos

.subckt dut VDD VSS Vref VIN VOUT VB1 VB2
CL VOUT VX 1p
M1 VX FB net3 VSS nch l=0.15 w=1 nf=1 m=1
M10 VB1 VB1 VDD VDD pch l=0.15 w=1 nf=1 m=1
M11 VB1 VB3 VSS VSS nch l=0.15 w=1 nf=1 m=1
M12 VB3 net8 VDD VDD pch l=0.15 w=1 nf=1 m=1
M13 VB3 VB3 VSS VSS nch l=0.15 w=1 nf=1 m=1
M14 net8 net8 VDD VDD pch l=0.15 w=1 nf=1 m=1
M15 net8 net6 VSS VSS nch l=0.15 w=1 nf=1 m=1
M16 net6 VB2 VDD VDD pch l=0.15 w=1 nf=1 m=1
M17 net9 VB2 VDD VDD pch l=0.15 w=1 nf=1 m=1
M18 net9 net9 net2 VSS nch l=0.15 w=1 nf=1 m=1
M19 net2 net9 net6 VSS nch l=0.15 w=1 nf=1 m=1
M2 net0 Vref net3 VSS nch l=0.15 w=1 nf=1 m=1
M20 net6 net6 VSS VSS nch l=0.15 w=1 nf=1 m=1
M21 net4 VB2 VDD VDD pch l=0.15 w=1 nf=1 m=1
M22 net4 net4 net5 VSS nch l=0.15 w=1 nf=1 m=1
M23 net5 net4 net2 VSS nch l=0.15 w=1 nf=1 m=1
M24 VB2 VB2 VDD VDD pch l=0.15 w=1 nf=1 m=1
M25 VB2 net5 VSS VSS nch l=0.15 w=1 nf=1 m=1
M3 VX VX VDD VDD pch l=0.15 w=1 nf=1 m=1
M4 net0 net0 VDD VDD pch l=0.15 w=1 nf=1 m=1
M5 net7 VX VDD VDD pch l=0.15 w=1 nf=1 m=1
M6 net1 net0 VDD VDD pch l=0.15 w=1 nf=1 m=1
M7 net7 net7 VSS VSS nch l=0.15 w=1 nf=1 m=1
M8 net1 net7 VSS VSS nch l=0.15 w=1 nf=1 m=1
M9 net3 VB3 VSS VSS nch l=0.15 w=1 nf=1 m=1
MNP VIN net1 VOUT VSS nch l=0.15 w=1 nf=1 m=1
R1 VOUT FB 1k
R2 FB VSS 1k
R3 VX VSS 1k
.ends dut
