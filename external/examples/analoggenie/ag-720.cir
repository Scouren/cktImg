* official Analog Canvas netlist; PDK X cards rewritten by convert.py
.model nch nmos

.subckt dut VSS VB Vout
M1 net0 Vout VSS VSS nch l=0.15 w=1 nf=1 m=1
M2 Vout VB net0 VSS nch l=0.15 w=1 nf=1 m=1
.ends dut
