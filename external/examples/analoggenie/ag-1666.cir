* official Analog Canvas netlist; PDK X cards rewritten by convert.py
.model nch nmos
.model pch pmos
.model qpnp pnp

.subckt opamp VDD VSS INP INN OUT
M1 INP INP net1 VSS nch l=0.15 w=1 nf=1 m=1
M10 net4 net6 VSS VSS nch l=0.15 w=1 nf=1 m=1
M11 net1 VB5 VSS VSS nch l=0.15 w=1 nf=1 m=1
M12 VB4 VB4 VB5 VSS nch l=0.15 w=1 nf=1 m=1
M13 VB5 VB5 VSS VSS nch l=0.15 w=1 nf=1 m=1
M14 VB4 VBP VDD VDD pch l=0.15 w=1 nf=1 m=1
M15 VB3 VBP VDD VDD pch l=0.15 w=1 nf=1 m=1
M16 net3 VBP VDD VDD pch l=0.15 w=1 nf=1 m=1
M17 VBP VBP VDD VDD pch l=0.15 w=1 nf=1 m=1
M18 VBP VB3 net0 VSS nch l=0.15 w=1 nf=1 m=1
M19 net0 net3 VSS VSS nch l=0.15 w=1 nf=1 m=1
M2 net2 INN net1 VSS nch l=0.15 w=1 nf=1 m=1
M20 net3 net3 VSS VSS nch l=0.15 w=1 nf=1 m=1
M21 VB3 VB3 VSS VSS nch l=0.15 w=1 nf=1 m=1
M3 INP VB1 VDD VDD pch l=0.15 w=1 nf=1 m=1
M4 net2 VB1 VDD VDD pch l=0.15 w=1 nf=1 m=1
M5 net6 VB2 INP VDD pch l=0.15 w=1 nf=1 m=1
M6 OUT VB2 net2 VDD pch l=0.15 w=1 nf=1 m=1
M7 net6 VB4 net5 VSS nch l=0.15 w=1 nf=1 m=1
M8 OUT VB4 net4 VSS nch l=0.15 w=1 nf=1 m=1
M9 net5 net6 VSS VSS nch l=0.15 w=1 nf=1 m=1
.ends opamp

.subckt dut VDD VSS Vout
Q1 VSS VSS net0 qpnp m=1
Q2 net0 net0 net2 qpnp m=1
Q3 VSS VSS net1 qpnp m=1
Q4 net1 net1 Y qpnp m=1
R1 Vout X 1k
R2 Vout Y 1k
R3 X net2 1k
X1 VDD VSS X Y Vout opamp
.ends dut
