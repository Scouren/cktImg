* official Analog Canvas netlist; PDK X cards rewritten by convert.py
.model nch nmos
.model pch pmos

.subckt bias VDD VSS VIN VBN VB3
M31 VBN net0 VIN VDD pch l=0.15 w=1 nf=1 m=1
M32 net0 net0 VIN VDD pch l=0.15 w=1 nf=1 m=1
M33 VB3 net0 VIN VDD pch l=0.15 w=1 nf=1 m=1
M34 net0 VB3 net1 VSS nch l=0.15 w=1 nf=1 m=1
M35 VBN VBN VSS VSS nch l=0.15 w=1 nf=1 m=1
M36 VB3 VB3 VSS VSS nch l=0.15 w=1 nf=1 m=1
R3 net1 VSS 1k
.ends bias

.subckt dut VDD VSS VREF VB1 VB2 VB4 VOUT VIN VB3
CF1 VOUT VFB 1p
Cm1 VOUT V1 1p
Cm2 V1 net5 1p
M11 net2 VBN VSS VSS nch l=0.15 w=1 nf=1 m=1
M12 VY VFB net2 VSS nch l=0.15 w=1 nf=1 m=1
M13 VX VREF net2 VSS nch l=0.15 w=1 nf=1 m=1
M14 net3 net3 VSS VSS nch l=0.15 w=1 nf=1 m=1
M15 V1 net3 VSS VSS nch l=0.15 w=1 nf=1 m=1
M16 VX VB1 VIN VDD pch l=0.15 w=1 nf=1 m=1
M17 VX V1 VSS VSS nch l=0.15 w=1 nf=1 m=1
M18 VX VX VSS VSS nch l=0.15 w=1 nf=1 m=1
M21 net1 V1 VSS VSS nch l=0.15 w=1 nf=1 m=1
M22 net6 VX VSS VSS nch l=0.15 w=1 nf=1 m=1
M23 net1 net1 VIN VDD pch l=0.15 w=1 nf=1 m=1
M24 net6 net1 VIN VDD pch l=0.15 w=1 nf=1 m=1
M25 net3 VX VIN VDD pch l=0.15 w=1 nf=1 m=1
M26 VX VX VIN VDD pch l=0.15 w=1 nf=1 m=1
M27 VY VY VIN VDD pch l=0.15 w=1 nf=1 m=1
M28 V1 VY VIN VDD pch l=0.15 w=1 nf=1 m=1
MD1 net5 V1 VSS VSS nch l=0.15 w=1 nf=1 m=1
MD2 net4 VB2 VSS VSS nch l=0.15 w=1 nf=1 m=1
MD3 net0 net5 net4 VSS nch l=0.15 w=1 nf=1 m=1
MD4 VY VB4 net4 VSS nch l=0.15 w=1 nf=1 m=1
MD5 net5 VY VIN VDD pch l=0.15 w=1 nf=1 m=1
MD6 VY VY VIN VDD pch l=0.15 w=1 nf=1 m=1
MD7 net0 net0 VIN VDD pch l=0.15 w=1 nf=1 m=1
MPT VOUT net6 VIN VDD pch l=0.15 w=1 nf=1 m=1
RF1 VOUT VFB 1k
RF2 VFB VSS 1k
X1 VDD VSS VIN VBN VB3 bias
.ends dut
