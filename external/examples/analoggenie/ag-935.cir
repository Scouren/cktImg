* official Analog Canvas netlist; PDK X cards rewritten by convert.py
.model nch nmos

.subckt dut VSS IREF vOUT
M1 net1 net2 VSS VSS nch l=0.15 w=1 nf=1 m=1
M2 vOUT IREF net1 VSS nch l=0.15 w=1 nf=1 m=1
M3 net0 net2 VSS VSS nch l=0.15 w=1 nf=1 m=1
M4 net2 IREF net0 VSS nch l=0.15 w=1 nf=1 m=1
R IREF net2 1k
.ends dut
