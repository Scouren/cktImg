* official Analog Canvas netlist; PDK X cards rewritten by convert.py
.model nch nmos
.model pch pmos
.model qnpn npn

.subckt opamp VDD VSS VB1 INP INN OUT VB2
M1 net2 VB1 VDD VDD pch l=0.15 w=1 nf=1 m=1
M10 net5 VB5 VSS VSS nch l=0.15 w=1 nf=1 m=1
M11 net7 VB5 VSS VSS nch l=0.15 w=1 nf=1 m=1
M12 VB4 VB6 VDD VDD pch l=0.15 w=1 nf=1 m=1
M13 VB4 VB4 VB5 VSS nch l=0.15 w=1 nf=1 m=1
M14 VB5 VB5 VSS VSS nch l=0.15 w=1 nf=1 m=1
M15 VB6 VB6 VDD VDD pch l=0.15 w=1 nf=1 m=1
M16 net1 VB6 VDD VDD pch l=0.15 w=1 nf=1 m=1
M17 net8 VB6 VDD VDD pch l=0.15 w=1 nf=1 m=1
M18 VB3 VB6 VDD VDD pch l=0.15 w=1 nf=1 m=1
M19 VB6 net6 VSS VSS nch l=0.15 w=1 nf=1 m=1
M2 net5 INP net2 VDD pch l=0.15 w=1 nf=1 m=1
M20 net1 net1 net6 VSS nch l=0.15 w=1 nf=1 m=1
M21 net6 net1 net4 VSS nch l=0.15 w=1 nf=1 m=1
M22 net4 net8 VB3 VSS nch l=0.15 w=1 nf=1 m=1
M23 VB3 VB3 VSS VSS nch l=0.15 w=1 nf=1 m=1
M24 net8 net8 net4 VSS nch l=0.15 w=1 nf=1 m=1
M3 net7 INN net2 VDD pch l=0.15 w=1 nf=1 m=1
M4 net3 VX VDD VDD pch l=0.15 w=1 nf=1 m=1
M5 net0 VX VDD VDD pch l=0.15 w=1 nf=1 m=1
M6 VX VB2 net3 VDD pch l=0.15 w=1 nf=1 m=1
M7 OUT VB2 net0 VDD pch l=0.15 w=1 nf=1 m=1
M8 VX VB4 net5 VSS nch l=0.15 w=1 nf=1 m=1
M9 OUT VB4 net7 VSS nch l=0.15 w=1 nf=1 m=1
.ends opamp

.subckt dut VDD VSS Vout VB1 VB2
Q1 X X VSS VSS qnpn m=1
Q2 net0 net0 VSS VSS qnpn m=1
R1 Vout X 1k
R2 Vout Y 1k
R3 Y net0 1k
X1 VDD VSS VB1 X Y Vout VB2 opamp
.ends dut
