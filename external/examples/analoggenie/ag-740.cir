* official Analog Canvas netlist; PDK X cards rewritten by convert.py
.model nch nmos
.model pch pmos

.subckt dut VDD VSS Vout+ Vout- Vltch Vin+ Vin- Vref- Vref+
M1 net2 Vout+ net1 VSS nch l=0.15 w=1 nf=1 m=1
M10 Vout+ Vltch VDD VDD pch l=0.15 w=1 nf=1 m=1
M11 Vout- Vltch net2 VSS nch l=0.15 w=1 nf=1 m=1
M12 Vout+ Vltch net0 VSS nch l=0.15 w=1 nf=1 m=1
M2 net0 Vout- net3 VSS nch l=0.15 w=1 nf=1 m=1
M3 net1 Vin+ VSS VSS nch l=0.15 w=1 nf=1 m=1
M4 net1 Vref- VSS VSS nch l=0.15 w=1 nf=1 m=1
M5 net3 Vref+ VSS VSS nch l=0.15 w=1 nf=1 m=1
M6 net3 Vin- VSS VSS nch l=0.15 w=1 nf=1 m=1
M7 Vout- Vltch VDD VDD pch l=0.15 w=1 nf=1 m=1
M8 Vout- Vout+ VDD VDD pch l=0.15 w=1 nf=1 m=1
M9 Vout+ Vout- VDD VDD pch l=0.15 w=1 nf=1 m=1
.ends dut
