* official Analog Canvas netlist; PDK X cards rewritten by convert.py
.model nch nmos

.subckt dut VDD VSS Vin Vout
M1 net1 net2 VSS VSS nch l=0.15 w=1 nf=1 m=1
M2 Vout net1 net0 VSS nch l=0.15 w=1 nf=1 m=1
R1 Vin net2 1k
R2 net2 net0 1k
RD1 VDD net1 1k
RD2 VDD Vout 1k
RS net0 VSS 1k
.ends dut
