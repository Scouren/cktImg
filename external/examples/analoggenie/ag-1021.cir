* official Analog Canvas netlist; PDK X cards rewritten by convert.py
.model nch nmos

.subckt dut VDD VSS iOUT
IIN VDD net0 DC 1m
M1 net0 VDD VSS net0 nch l=0.15 w=1 nf=1 m=1
M2 iOUT VDD VSS net0 nch l=0.15 w=1 nf=1 m=1
.ends dut
