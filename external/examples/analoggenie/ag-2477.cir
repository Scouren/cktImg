* official Analog Canvas netlist; PDK X cards rewritten by convert.py
.model nch nmos
.model pch pmos

.subckt dut VDD VSS VB1 VB2 VREF VB6 VB7 VIN VB4 VB5 VOUT
CF1 VOUT VFB 1p
Cm1 VOUT VO1 1p
Cm2 VO1 net7 1p
M10 net0 net10 VSS VSS nch l=0.15 w=1 nf=1 m=1
M11 net3 VBN2 VSS VSS nch l=0.15 w=1 nf=1 m=1
M12 net2 VFB net3 VSS nch l=0.15 w=1 nf=1 m=1
M13 VF VREF net3 VSS nch l=0.15 w=1 nf=1 m=1
M14 net2 VB1 VIN VDD pch l=0.15 w=1 nf=1 m=1
M15 VF VB1 VIN VDD pch l=0.15 w=1 nf=1 m=1
M16 VO1 VB2 net2 VDD pch l=0.15 w=1 nf=1 m=1
M17 net10 VB2 VF VDD pch l=0.15 w=1 nf=1 m=1
M18 VO1 VBN1 net8 VSS nch l=0.15 w=1 nf=1 m=1
M19 net10 VBN1 net0 VSS nch l=0.15 w=1 nf=1 m=1
M20 net8 net10 VSS VSS nch l=0.15 w=1 nf=1 m=1
M21 net9 VO1 VSS VSS nch l=0.15 w=1 nf=1 m=1
M22 net6 VC2 VSS VSS nch l=0.15 w=1 nf=1 m=1
M23 net9 net9 VIN VDD pch l=0.15 w=1 nf=1 m=1
M24 net6 net9 VIN VDD pch l=0.15 w=1 nf=1 m=1
M25 VC2 VB5 VIN VDD pch l=0.15 w=1 nf=1 m=1
M26 VC2 VO1 VSS VSS nch l=0.15 w=1 nf=1 m=1
M27 VC2 VC2 VSS VSS nch l=0.15 w=1 nf=1 m=1
MB1 net5 VBP VIN VDD pch l=0.15 w=1 nf=1 m=1
MB10 VBN2 VBN2 VSS VSS nch l=0.15 w=1 nf=1 m=1
MB2 VBP VBP VIN VDD pch l=0.15 w=1 nf=1 m=1
MB3 VBP VB4 net4 VSS nch l=0.15 w=1 nf=1 m=1
MB4 net4 net5 VSS VSS nch l=0.15 w=1 nf=1 m=1
MB5 net5 net5 VSS VSS nch l=0.15 w=1 nf=1 m=1
MB6 VB4 VBP VIN VDD pch l=0.15 w=1 nf=1 m=1
MB7 VB4 net4 VSS VSS nch l=0.15 w=1 nf=1 m=1
MB8 VBN1 VBP VIN VDD pch l=0.15 w=1 nf=1 m=1
MB9 VBN1 VBN1 VBN2 VSS nch l=0.15 w=1 nf=1 m=1
MD1 net7 VO1 VSS VSS nch l=0.15 w=1 nf=1 m=1
MD2 net1 VB6 VSS VSS nch l=0.15 w=1 nf=1 m=1
MD3 VF net7 net1 VSS nch l=0.15 w=1 nf=1 m=1
MD4 VC1 VB7 net1 VSS nch l=0.15 w=1 nf=1 m=1
MD5 VF VF VIN VDD pch l=0.15 w=1 nf=1 m=1
MD6 VC1 VC1 VIN VDD pch l=0.15 w=1 nf=1 m=1
MD7 net7 VC1 VIN VDD pch l=0.15 w=1 nf=1 m=1
MPT VOUT net6 VIN VDD pch l=0.15 w=1 nf=1 m=1
RF1 VOUT VFB 1k
RF2 VFB VSS 1k
.ends dut
