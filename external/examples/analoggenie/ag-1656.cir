* official Analog Canvas netlist; PDK X cards rewritten by convert.py
.model nch nmos
.model pch pmos
.model qpnp pnp

.subckt opamp VDD VSS INN INP OUT Z VB1 VB2 VB3
M1 OUT VB4 Z VSS nch l=0.15 w=1 nf=1 m=1
M10 net7 net4 VSS VSS nch l=0.15 w=1 nf=1 m=1
M11 net0 net3 VSS VSS nch l=0.15 w=1 nf=1 m=1
M12 Z net4 VSS VSS nch l=0.15 w=1 nf=1 m=1
M13 VA VG VDD VDD pch l=0.15 w=1 nf=1 m=1
M14 VG VB4 net0 VSS nch l=0.15 w=1 nf=1 m=1
M15 VC VG VDD VDD pch l=0.15 w=1 nf=1 m=1
M16 VB5 VB5 VDD VDD pch l=0.15 w=1 nf=1 m=1
M17 VB5 VC VSS VSS nch l=0.15 w=1 nf=1 m=1
M18 VB4 VB5 VDD VDD pch l=0.15 w=1 nf=1 m=1
M19 VB4 VB4 net2 VSS nch l=0.15 w=1 nf=1 m=1
M2 VG VB1 VA VDD pch l=0.15 w=1 nf=1 m=1
M20 net2 VB4 VSS VSS nch l=0.15 w=1 nf=1 m=1
M21 VA VB5 VDD VDD pch l=0.15 w=1 nf=1 m=1
M22 VA VA net6 VSS nch l=0.15 w=1 nf=1 m=1
M23 net6 VA VB3 VSS nch l=0.15 w=1 nf=1 m=1
M24 net5 VB5 VDD VDD pch l=0.15 w=1 nf=1 m=1
M25 net5 net5 VC VSS nch l=0.15 w=1 nf=1 m=1
M26 VC net5 net6 VSS nch l=0.15 w=1 nf=1 m=1
M27 VB3 VB5 VDD VDD pch l=0.15 w=1 nf=1 m=1
M28 VB3 VB3 VSS VSS nch l=0.15 w=1 nf=1 m=1
M3 OUT VB1 VC VDD pch l=0.15 w=1 nf=1 m=1
M4 INP net3 VSS VSS nch l=0.15 w=1 nf=1 m=1
M5 net1 VB2 VDD VDD pch l=0.15 w=1 nf=1 m=1
M6 net3 INN net1 VDD pch l=0.15 w=1 nf=1 m=1
M7 net4 INP net1 VDD pch l=0.15 w=1 nf=1 m=1
M8 net3 VB4 INP VSS nch l=0.15 w=1 nf=1 m=1
M9 net4 VB4 net7 VSS nch l=0.15 w=1 nf=1 m=1
.ends opamp

.subckt dut VDD VSS Vout VB1 VB2 VB3
Q1 VSS VSS net1 qpnp m=1
Q2 net1 net1 net2 qpnp m=1
Q3 VSS VSS net0 qpnp m=1
Q4 net0 net0 Y qpnp m=1
R1 Vout X 1k
R2 Vout Y 1k
R3 X net2 1k
X1 VDD VSS Y X Vout net0 VB1 VB2 VB3 opamp
.ends dut
