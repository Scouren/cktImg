* official Analog Canvas netlist; PDK X cards rewritten by convert.py
.model nch nmos
.model pch pmos

.subckt EA VDD VSS OUT INN INP VX2
MN1 net0 net0 VSS VSS nch l=0.15 w=1 nf=1 m=1
MN10 net2 net3 VSS VSS nch l=0.15 w=1 nf=1 m=1
MN11 VB1 VB1 VSS VSS nch l=0.15 w=1 nf=1 m=1
MN12 VB3 VB1 VSS VSS nch l=0.15 w=1 nf=1 m=1
MN2 VX2 VX2 VSS VSS nch l=0.15 w=1 nf=1 m=1
MN3 OUT net0 VSS VSS nch l=0.15 w=1 nf=1 m=1
MN4 VX VX2 VSS VSS nch l=0.15 w=1 nf=1 m=1
MN9 net3 net3 VSS VSS nch l=0.15 w=1 nf=1 m=1
MP1 net0 INN net1 VDD pch l=0.15 w=1 nf=1 m=1
MP10 VB1 net2 VDD VDD pch l=0.15 w=1 nf=1 m=1
MP11 VB3 VB3 VDD VDD pch l=0.15 w=1 nf=1 m=1
MP2 VX2 INP net1 VDD pch l=0.15 w=1 nf=1 m=1
MP3 net1 VB3 VDD VDD pch l=0.15 w=1 nf=1 m=1
MP7 VX VX VDD VDD pch l=0.15 w=1 nf=1 m=1
MP8 OUT VX VDD VDD pch l=0.15 w=1 nf=1 m=1
MP9 net2 net2 VDD VDD pch l=0.15 w=1 nf=1 m=1
RBIAS VDD net3 1k
.ends EA

.subckt ISR VDD VSS VS VCTRL VB2 IOUT
MN6 net0 net1 VSS VSS nch l=0.15 w=1 nf=1 m=1
MN7 net1 net1 VSS VSS nch l=0.15 w=1 nf=1 m=1
MN8 net1 VB2 VSS VSS nch l=0.15 w=1 nf=1 m=1
MP4 net0 net0 VS VDD pch l=0.15 w=1 nf=1 m=1
MP5 IOUT net0 VS VDD pch l=0.15 w=1 nf=1 m=1
MP6 net1 VCTRL VS VDD pch l=0.15 w=1 nf=1 m=1
.ends ISR

.subckt dut VDD VSS VIN VCONT1 VCONT2 VCONT3 VCONT4 VCONT5 VP VREF VB2
.model DIODE D(IS=1e-14 N=1)
CFLY VX1 VX2 1p
CO VP VN 1p
COP VP VSS 1p
D1 VN VX2 DIODE
L1 VX1 VX3 1n
M1 VX1 VCONT2 VIN VDD pch l=0.15 w=1 nf=1 m=1
M2 VX2 VCONT3 VIN VDD pch l=0.15 w=1 nf=1 m=1
M3 VP VCONT5 VX3 VDD pch l=0.15 w=1 nf=1 m=1
M4 VX3 VCONT4 VSS VSS nch l=0.15 w=1 nf=1 m=1
M5 net0 VCONT1 VIN VDD pch l=0.15 w=1 nf=1 m=1
R1 VP VFP1 1k
R2 VFP1 VSS 1k
X1 VDD VSS net1 VFP1 VREF VX2 EA
X2 VDD VSS net0 net1 VB2 VX1 ISR
.ends dut
