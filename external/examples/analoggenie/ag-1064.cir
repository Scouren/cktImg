* official Analog Canvas netlist; PDK X cards rewritten by convert.py
.model nch nmos
.model pch pmos

* Ideal inverter: switches at V(VDD,VSS)/2; vt sets the step width, td the delay
.subckt inverter VDD VSS A Y params: vt=10m td=10p
BhA hA 0 V={0.5*(1+tanh((V(A,VSS)-0.5*V(VDD,VSS))/vt))}
Bf nfn VSS V={V(VDD,VSS)*(1-V(hA))}
Rd nfn ndl 1k
Cd ndl VSS {td/1000}
BY Y VSS V={V(ndl,VSS)}
.ends inverter

.subckt dut VDD VSS V2 V1 Out
I1 net1 VSS DC 10nA
M1 net1 net1 VDD VDD pch l=0.15 w=1 nf=1 m=1
M10 net5 Out VDD VDD pch l=0.15 w=1 nf=1 m=1
M11 net5 net3 VSS VSS nch l=0.15 w=1 nf=1 m=1
M12 net5 Out VSS VSS nch l=0.15 w=1 nf=1 m=1
M2 net4 net1 VDD VDD pch l=0.15 w=1 nf=1 m=1
M3 net3 net1 VDD VDD pch l=0.15 w=1 nf=1 m=1
M4 net0 V2 net4 VDD pch l=0.15 w=1 nf=1 m=1
M5 net2 V1 net4 VDD pch l=0.15 w=1 nf=1 m=1
M6 net0 net0 VSS VSS nch l=0.15 w=1 nf=1 m=1
M7 net2 net0 VSS VSS nch l=0.15 w=1 nf=1 m=1
M8 net3 net2 VSS VSS nch l=0.15 w=1 nf=1 m=1
M9 net5 net3 VDD VDD pch l=0.15 w=1 nf=1 m=1
X1 VDD VSS net5 Out inverter td=10p vt=10m
.ends dut
