* official Analog Canvas netlist; PDK X cards rewritten by convert.py
.model nch nmos
.model pch pmos
.model qpnp pnp

.subckt dut VDD VSS Vout VB1 VB2
M1 X VG VDD VDD pch l=0.15 w=1 nf=1 m=1
M10 Z VB1 net1 VDD pch l=0.15 w=1 nf=1 m=1
M11 net2 VB1 net8 VDD pch l=0.15 w=1 nf=1 m=1
M12 VG VB1 net13 VDD pch l=0.15 w=1 nf=1 m=1
M13 Y VB4 net14 VSS nch l=0.15 w=1 nf=1 m=1
M14 Z X net4 VSS nch l=0.15 w=1 nf=1 m=1
M15 net2 Y net4 VSS nch l=0.15 w=1 nf=1 m=1
M16 VG VB4 net9 VSS nch l=0.15 w=1 nf=1 m=1
M17 net14 Y VSS VSS nch l=0.15 w=1 nf=1 m=1
M18 net4 VB2 VSS VSS nch l=0.15 w=1 nf=1 m=1
M19 net9 Y VSS VSS nch l=0.15 w=1 nf=1 m=1
M2 Vout VG VDD VDD pch l=0.15 w=1 nf=1 m=1
M20 VB5 VB5 VDD VDD pch l=0.15 w=1 nf=1 m=1
M21 net11 VB5 VDD VDD pch l=0.15 w=1 nf=1 m=1
M22 net10 VB5 VDD VDD pch l=0.15 w=1 nf=1 m=1
M23 VB3 VB5 VDD VDD pch l=0.15 w=1 nf=1 m=1
M24 VB4 VB5 VDD VDD pch l=0.15 w=1 nf=1 m=1
M25 VB5 net0 VSS VSS nch l=0.15 w=1 nf=1 m=1
M26 net11 net11 net0 VSS nch l=0.15 w=1 nf=1 m=1
M27 net10 net10 net7 VSS nch l=0.15 w=1 nf=1 m=1
M28 VB4 VB4 net5 VSS nch l=0.15 w=1 nf=1 m=1
M29 net0 net11 net7 VSS nch l=0.15 w=1 nf=1 m=1
M3 net12 VG VDD VDD pch l=0.15 w=1 nf=1 m=1
M30 net7 net10 VB3 VSS nch l=0.15 w=1 nf=1 m=1
M31 VB3 VB3 VSS VSS nch l=0.15 w=1 nf=1 m=1
M32 net5 VB4 VSS VSS nch l=0.15 w=1 nf=1 m=1
M4 Z VG VDD VDD pch l=0.15 w=1 nf=1 m=1
M5 net3 Z VDD VDD pch l=0.15 w=1 nf=1 m=1
M6 net1 Z VDD VDD pch l=0.15 w=1 nf=1 m=1
M7 net8 net2 VDD VDD pch l=0.15 w=1 nf=1 m=1
M8 net13 net2 VDD VDD pch l=0.15 w=1 nf=1 m=1
M9 Y VB1 net3 VDD pch l=0.15 w=1 nf=1 m=1
Q1 VSS VSS net12 qpnp m=1
Q2 VSS net12 X qpnp m=1
Q3 VSS VSS Z qpnp m=1
Q4 VSS Z net6 qpnp m=1
R1 Y net6 1k
R2 Vout Y 1k
.ends dut
