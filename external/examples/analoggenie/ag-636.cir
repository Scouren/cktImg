* official Analog Canvas netlist; PDK X cards rewritten by convert.py
.model qnpn npn
.model qpnp pnp

.subckt dut +5V -5V VSS In+ In- Output
Igain +5V net6 DC 1m
Q1 net2 In+ net6 qpnp m=1
Q10 net5 net5 net3 qpnp m=1
Q11 net4 net4 +5V qpnp m=1
Q12 Output net5 net4 qpnp m=1
Q2 net7 In- net6 qpnp m=1
Q3 net2 net0 -5V -5V qnpn m=1
Q4 Output net2 net0 -5V qnpn m=1
Q5 net0 net0 -5V -5V qnpn m=1
Q6 net7 net1 -5V -5V qnpn m=1
Q7 net5 net7 net1 -5V qnpn m=1
Q8 net1 net1 -5V -5V qnpn m=1
Q9 net3 net4 +5V qpnp m=1
Rload Output VSS 30kΩ
.ends dut
