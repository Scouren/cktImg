* official Analog Canvas netlist; PDK X cards rewritten by convert.py
.model nch nmos

.subckt dut VDD VSS VCONT1
IDD VDD net0 DC 1m
M1 net0 net0 VSS VSS nch l=0.15 w=1 nf=1 m=1
M2 net0 net0 VSS VSS nch l=0.15 w=1 nf=1 m=1
MV1 VCONT1 net0 VCONT1 VSS nch l=0.15 w=1 nf=1 m=1
MV2 VCONT1 net0 VCONT1 VSS nch l=0.15 w=1 nf=1 m=1
.ends dut
