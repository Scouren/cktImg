* official Analog Canvas netlist; PDK X cards rewritten by convert.py
.model nch nmos
.model pch pmos
.model qpnp pnp

.subckt dut VDD VSS Vout VB1 VB2
M1 X VG VDD VDD pch l=0.15 w=1 nf=1 m=1
M10 VG VB2 net8 VDD pch l=0.15 w=1 nf=1 m=1
M11 VG VB4 net0 VSS nch l=0.15 w=1 nf=1 m=1
M12 net0 Z VSS VSS nch l=0.15 w=1 nf=1 m=1
M13 net5 X Y VSS nch l=0.15 w=1 nf=1 m=1
M14 net8 Y Y VSS nch l=0.15 w=1 nf=1 m=1
M15 Y VB5 VSS VSS nch l=0.15 w=1 nf=1 m=1
M16 net2 net3 VDD VDD pch l=0.15 w=1 nf=1 m=1
M17 net3 net3 VDD VDD pch l=0.15 w=1 nf=1 m=1
M18 VB3 net3 VDD VDD pch l=0.15 w=1 nf=1 m=1
M19 VB4 net3 VDD VDD pch l=0.15 w=1 nf=1 m=1
M2 Vout VG VDD VDD pch l=0.15 w=1 nf=1 m=1
M20 net3 VB3 net1 VSS nch l=0.15 w=1 nf=1 m=1
M21 net1 net2 VSS VSS nch l=0.15 w=1 nf=1 m=1
M22 net2 net2 VSS VSS nch l=0.15 w=1 nf=1 m=1
M23 VB3 VB3 VSS VSS nch l=0.15 w=1 nf=1 m=1
M24 VB4 VB4 VB5 VSS nch l=0.15 w=1 nf=1 m=1
M25 VB5 VB5 VSS VSS nch l=0.15 w=1 nf=1 m=1
M3 net6 VG VDD VDD pch l=0.15 w=1 nf=1 m=1
M4 Z VG VDD VDD pch l=0.15 w=1 nf=1 m=1
M5 net5 VB1 VDD VDD pch l=0.15 w=1 nf=1 m=1
M6 Z VB2 net5 VDD pch l=0.15 w=1 nf=1 m=1
M7 Z VB4 net7 VSS nch l=0.15 w=1 nf=1 m=1
M8 net7 Z VSS VSS nch l=0.15 w=1 nf=1 m=1
M9 net8 VB1 VDD VDD pch l=0.15 w=1 nf=1 m=1
Q1 VSS VSS net6 qpnp m=1
Q2 VSS net6 X qpnp m=1
Q3 VSS VSS Z qpnp m=1
Q4 VSS Z net4 qpnp m=1
R1 Y net4 1k
R2 Vout Y 1k
.ends dut
