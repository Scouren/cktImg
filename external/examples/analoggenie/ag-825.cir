* official Analog Canvas netlist; PDK X cards rewritten by convert.py
.model qnpn npn

.subckt dut VDD VSS VIN1 IOUT1
IBIAS net0 VSS DC 1m
Q1 VDD VIN1 net0 VSS qnpn m=1
Q2 VDD net0 IOUT1 VSS qnpn m=1
.ends dut
