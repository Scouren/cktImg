* official Analog Canvas netlist; PDK X cards rewritten by convert.py
.model nch nmos
.model pch pmos
.model qpnp pnp

.subckt opamp VDD VSS INN INP VE OUT VBN
M10 VE VBN net2 VSS nch l=0.15 w=1 nf=1 m=1
M11 OUT VB1 net1 VDD pch l=0.15 w=1 nf=1 m=1
M12 net7 VB1 net0 VDD pch l=0.15 w=1 nf=1 m=1
M13 net0 net7 VDD VDD pch l=0.15 w=1 nf=1 m=1
M14 net1 net7 VDD VDD pch l=0.15 w=1 nf=1 m=1
M15 net7 VBN net5 VSS nch l=0.15 w=1 nf=1 m=1
M16 OUT VBN net6 VSS nch l=0.15 w=1 nf=1 m=1
M17 net3 VN VSS VSS nch l=0.15 w=1 nf=1 m=1
M18 net2 VE VSS VSS nch l=0.15 w=1 nf=1 m=1
M19 net5 VE VSS VSS nch l=0.15 w=1 nf=1 m=1
M20 net6 VN VSS VSS nch l=0.15 w=1 nf=1 m=1
M5 net4 VB2 VDD VDD pch l=0.15 w=1 nf=1 m=1
M6 VE INP net4 VDD pch l=0.15 w=1 nf=1 m=1
M7 VN INN net4 VDD pch l=0.15 w=1 nf=1 m=1
M9 VN VBN net3 VSS nch l=0.15 w=1 nf=1 m=1
.ends opamp

.subckt dut VDD VSS Vout
M1 X net2 VDD VDD pch l=0.15 w=1 nf=1 m=1
M2 Vout net2 VDD VDD pch l=0.15 w=1 nf=1 m=1
M21 VBN net5 VDD VDD pch l=0.15 w=1 nf=1 m=1
M22 VBN VBN net0 VSS nch l=0.15 w=1 nf=1 m=1
M23 net5 net5 X VDD pch l=0.15 w=1 nf=1 m=1
M24 net0 VBN VSS VSS nch l=0.15 w=1 nf=1 m=1
M3 net3 net2 VDD VDD pch l=0.15 w=1 nf=1 m=1
M4 net4 net2 VDD VDD pch l=0.15 w=1 nf=1 m=1
Q1 VSS VSS net3 qpnp m=1
Q2 VSS net3 X qpnp m=1
Q3 VSS VSS net4 qpnp m=1
Q4 VSS net4 net1 qpnp m=1
R1 Y net1 1k
R2 Vout Y 1k
R3 VDD X 1k
R4 net5 VSS 1k
X1 VDD VSS X Y net1 net2 VBN opamp
.ends dut
