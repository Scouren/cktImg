* official Analog Canvas netlist; PDK X cards rewritten by convert.py
.model nch nmos
.model pch pmos

.subckt dut VDD VSS vci phi1 phi2 vco VB1
C1 vcx VSS 1p
C2 net4 vco 1p
M1 vci phi1 vcx VSS nch l=0.15 w=1 nf=1 m=1
M10 VB3 VB3 VSS VSS nch l=0.15 w=1 nf=1 m=1
M11 net3 VB3 VSS VSS nch l=0.15 w=1 nf=1 m=1
M12 VB2 VB3 VSS VSS nch l=0.15 w=1 nf=1 m=1
M13 VB2 VB2 net5 VDD pch l=0.15 w=1 nf=1 m=1
M14 net5 VB2 VDD VDD pch l=0.15 w=1 nf=1 m=1
M2 vcx phi2 net4 VSS nch l=0.15 w=1 nf=1 m=1
M3 net0 net4 vcx VSS nch l=0.15 w=1 nf=1 m=1
M4 vco VSS vcx VSS nch l=0.15 w=1 nf=1 m=1
M5 vcx VB1 VSS VSS nch l=0.15 w=1 nf=1 m=1
M6 net2 net0 VDD VDD pch l=0.15 w=1 nf=1 m=1
M7 net1 net0 VDD VDD pch l=0.15 w=1 nf=1 m=1
M8 net0 VB2 net2 VDD pch l=0.15 w=1 nf=1 m=1
M9 vco VB2 net1 VDD pch l=0.15 w=1 nf=1 m=1
R1 VDD VB3 1k
R2 VB3 net3 1k
R3 VDD net3 1k
.ends dut
