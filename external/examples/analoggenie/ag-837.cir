* official Analog Canvas netlist; PDK X cards rewritten by convert.py
.model nch nmos

.subckt dut VDD VSS VOUT
IIN VDD net3 DC 1m
M1 net2 net1 VSS VSS nch l=0.15 w=1 nf=1 m=1
M2 VOUT net0 net2 VSS nch l=0.15 w=1 nf=1 m=1
M3 net1 net1 VSS VSS nch l=0.15 w=1 nf=1 m=1
M4 net3 net3 net1 VSS nch l=0.15 w=1 nf=1 m=1
M5 VDD net3 net0 VSS nch l=0.15 w=1 nf=1 m=1
M6 net0 net1 VSS VSS nch l=0.15 w=1 nf=1 m=1
.ends dut
