* official Analog Canvas netlist; PDK X cards rewritten by convert.py
.model nch nmos
.model pch pmos

.subckt EA VDD VSS IN- IN+ VX3 VB1 VSR ISR
MN1 net4 IN- net6 VSS nch l=0.15 w=1 nf=1 m=1
MN2 VX3 IN+ net6 VSS nch l=0.15 w=1 nf=1 m=1
MN3 net6 VB2 VSS VSS nch l=0.15 w=1 nf=1 m=1
MN4 net2 net2 VSS VSS nch l=0.15 w=1 nf=1 m=1
MN5 net3 net2 VSS VSS nch l=0.15 w=1 nf=1 m=1
MN6 VB2 VB2 VSS VSS nch l=0.15 w=1 nf=1 m=1
MN7 net5 net5 VSS VSS nch l=0.15 w=1 nf=1 m=1
MN8 net5 VB1 VSS VSS nch l=0.15 w=1 nf=1 m=1
MN9 net0 net5 VSS VSS nch l=0.15 w=1 nf=1 m=1
MP1 net4 net4 VDD VDD pch l=0.15 w=1 nf=1 m=1
MP2 net2 net4 VDD VDD pch l=0.15 w=1 nf=1 m=1
MP3 VX3 VX3 VDD VDD pch l=0.15 w=1 nf=1 m=1
MP4 net3 VX3 VDD VDD pch l=0.15 w=1 nf=1 m=1
MP5 net1 net1 VDD VDD pch l=0.15 w=1 nf=1 m=1
MP6 VB2 net1 VDD VDD pch l=0.15 w=1 nf=1 m=1
MP7 net5 net3 VSR VDD pch l=0.15 w=1 nf=1 m=1
MP8 net0 net0 VSR VDD pch l=0.15 w=1 nf=1 m=1
MP9 ISR net0 VSR VDD pch l=0.15 w=1 nf=1 m=1
RBIAS net1 VSS 1k
.ends EA

.subckt dut VDD VSS VIN VP VCONT2 VCONT3 VCONT4 VCONT5 VCONT1 VREF VB1
.model DIODE D(IS=1e-14 N=1)
CFLY net1 net3 1p
CO VP net2 1p
COP VP VSS 1p
D1 net2 net3 DIODE
L1 net1 net0 1n
M1 net1 VCONT2 VIN VDD pch l=0.15 w=1 nf=1 m=1
M2 net3 VCONT3 VIN VDD pch l=0.15 w=1 nf=1 m=1
M3 VP VCONT5 net0 VDD pch l=0.15 w=1 nf=1 m=1
M4 net0 VCONT4 VSS VSS nch l=0.15 w=1 nf=1 m=1
M5 net4 VCONT1 VIN VDD pch l=0.15 w=1 nf=1 m=1
R1 VP VFP1 1k
R2 VFP1 VSS 1k
X1 VDD VSS VFP1 VREF net0 VB1 net4 net1 EA
.ends dut
