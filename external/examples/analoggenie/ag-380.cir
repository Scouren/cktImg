* official Analog Canvas netlist; PDK X cards rewritten by convert.py
.model nch nmos
.model pch pmos
.model qpnp pnp

.subckt dut VDD VSS Vb1 Vb2
M1 net6 net1 VDD VDD pch l=0.15 w=1 nf=1 m=1
M2 net2 net1 VDD VDD pch l=0.15 w=1 nf=1 m=1
M3 net1 Vb1 net6 VDD pch l=0.15 w=1 nf=1 m=1
M4 net5 Vb1 net2 VDD pch l=0.15 w=1 nf=1 m=1
M5 net1 Vb2 net7 VSS nch l=0.15 w=1 nf=1 m=1
M6 net5 Vb2 net8 VSS nch l=0.15 w=1 nf=1 m=1
M7 net7 net5 net4 VSS nch l=0.15 w=1 nf=1 m=1
M8 net8 net5 net3 VSS nch l=0.15 w=1 nf=1 m=1
Q1 VSS VSS net0 qpnp m=1
Q2 VSS VSS net3 qpnp m=1
R1 net4 net0 1k
.ends dut
