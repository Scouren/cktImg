* official Analog Canvas netlist; PDK X cards rewritten by convert.py
.model nch nmos
.model pch pmos
.model qnpn npn

.subckt opamp VDD VSS VB1 INP INN OUT VB2
M1 net5 VX VDD VDD pch l=0.15 w=1 nf=1 m=1
M10 net6 INP net1 VDD pch l=0.15 w=1 nf=1 m=1
M11 net3 INN net1 VDD pch l=0.15 w=1 nf=1 m=1
M12 VB4 net4 VDD VDD pch l=0.15 w=1 nf=1 m=1
M13 VB4 VB4 VB5 VSS nch l=0.15 w=1 nf=1 m=1
M14 VB5 VB5 VSS VSS nch l=0.15 w=1 nf=1 m=1
M15 net4 net4 VDD VDD pch l=0.15 w=1 nf=1 m=1
M16 net4 VB3 net2 VSS nch l=0.15 w=1 nf=1 m=1
M17 VB3 net4 VDD VDD pch l=0.15 w=1 nf=1 m=1
M18 VB3 VB3 VSS VSS nch l=0.15 w=1 nf=1 m=1
M2 VX VB2 net5 VDD pch l=0.15 w=1 nf=1 m=1
M3 VX VB4 net6 VSS nch l=0.15 w=1 nf=1 m=1
M4 net6 VB5 VSS VSS nch l=0.15 w=1 nf=1 m=1
M5 net0 VX VDD VDD pch l=0.15 w=1 nf=1 m=1
M6 OUT VB2 net0 VDD pch l=0.15 w=1 nf=1 m=1
M7 OUT VB4 net3 VSS nch l=0.15 w=1 nf=1 m=1
M8 net3 VB5 VSS VSS nch l=0.15 w=1 nf=1 m=1
M9 net1 VB1 VDD VDD pch l=0.15 w=1 nf=1 m=1
R1 net2 VSS 1k
.ends opamp

.subckt dut VDD VSS Vout VB1 VB2
Q1 X X VSS VSS qnpn m=1
Q2 net0 net0 VSS VSS qnpn m=1
R1 Vout X 1k
R2 Vout Y 1k
R3 Y net0 1k
X1 VDD VSS VB1 X Y Vout VB2 opamp
.ends dut
