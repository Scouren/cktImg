* official Analog Canvas netlist; PDK X cards rewritten by convert.py
.model nch nmos
.model pch pmos

.subckt opamp VDD VSS INN INP OUT VB1 VB2 VB3 VX
M1 net0 VC VDD VDD pch l=0.15 w=1 nf=1 m=1
M10 net3 VB4 net7 VSS nch l=0.15 w=1 nf=1 m=1
M11 VC VB4 net1 VSS nch l=0.15 w=1 nf=1 m=1
M12 net6 VX VSS VSS nch l=0.15 w=1 nf=1 m=1
M13 net9 VX VSS VSS nch l=0.15 w=1 nf=1 m=1
M14 net7 net3 VSS VSS nch l=0.15 w=1 nf=1 m=1
M15 net1 net3 VSS VSS nch l=0.15 w=1 nf=1 m=1
M16 VB4 net4 VDD VDD pch l=0.15 w=1 nf=1 m=1
M17 VB4 VB4 net5 VSS nch l=0.15 w=1 nf=1 m=1
M18 net5 VB4 VSS VSS nch l=0.15 w=1 nf=1 m=1
M19 net4 net4 VDD VDD pch l=0.15 w=1 nf=1 m=1
M2 net8 VB2 VDD VDD pch l=0.15 w=1 nf=1 m=1
M20 net4 VB3 net2 VSS nch l=0.15 w=1 nf=1 m=1
M21 VB3 net4 VDD VDD pch l=0.15 w=1 nf=1 m=1
M22 VB3 VB3 VSS VSS nch l=0.15 w=1 nf=1 m=1
M3 net10 VC VDD VDD pch l=0.15 w=1 nf=1 m=1
M4 OUT VB1 net0 VDD pch l=0.15 w=1 nf=1 m=1
M5 VC VB1 net10 VDD pch l=0.15 w=1 nf=1 m=1
M6 VX INN net8 VDD pch l=0.15 w=1 nf=1 m=1
M7 net3 INP net8 VDD pch l=0.15 w=1 nf=1 m=1
M8 OUT VB4 net6 VSS nch l=0.15 w=1 nf=1 m=1
M9 VX VB4 net9 VSS nch l=0.15 w=1 nf=1 m=1
R1 net2 VSS 1k
.ends opamp

.subckt dut VDD VSS VIN VOUT Vref VB1 VB2 VB3
CL VOUT VX 1p
MNP VIN net0 VOUT VSS nch l=0.15 w=1 nf=1 m=1
R1 VOUT FB 1k
R2 FB VSS 1k
R3 VX VSS 1k
X1 VDD VSS FB Vref net0 VB1 VB2 VB3 VX opamp
.ends dut
