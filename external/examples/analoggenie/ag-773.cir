* official Analog Canvas netlist; PDK X cards rewritten by convert.py
.model nch nmos
.model pch pmos

.subckt dut VDD VSS VC1 vin VC2 Vout
M1a Vout vin net1 VDD pch l=0.15 w=1 nf=1 m=1
M1b VDD VC1 net1 VSS nch l=0.15 w=1 nf=1 m=1
M2a Vout vin net0 VSS nch l=0.15 w=1 nf=1 m=1
M2b VSS VC2 net0 VDD pch l=0.15 w=1 nf=1 m=1
.ends dut
