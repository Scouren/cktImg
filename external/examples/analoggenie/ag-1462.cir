* official Analog Canvas netlist; PDK X cards rewritten by convert.py
.model nch nmos
.model pch pmos
.model qnpn npn

.subckt opamp VDD VSS INN INP VB2 OUT VB1 VB4
M1 net4 net1 VDD VDD pch l=0.15 w=1 nf=1 m=1
M10 net1 INN net7 VSS nch l=0.15 w=1 nf=1 m=1
M11 net3 INP net7 VSS nch l=0.15 w=1 nf=1 m=1
M12 OUT VB4 net8 VSS nch l=0.15 w=1 nf=1 m=1
M13 net0 VX VSS VSS nch l=0.15 w=1 nf=1 m=1
M14 net7 VB2 VSS VSS nch l=0.15 w=1 nf=1 m=1
M15 net8 VX VSS VSS nch l=0.15 w=1 nf=1 m=1
M2 net2 net1 VDD VDD pch l=0.15 w=1 nf=1 m=1
M3 net5 net3 VDD VDD pch l=0.15 w=1 nf=1 m=1
M4 net6 net3 VDD VDD pch l=0.15 w=1 nf=1 m=1
M5 VX VB1 net4 VDD pch l=0.15 w=1 nf=1 m=1
M6 net1 VB1 net2 VDD pch l=0.15 w=1 nf=1 m=1
M7 net3 VB1 net5 VDD pch l=0.15 w=1 nf=1 m=1
M8 OUT VB1 net6 VDD pch l=0.15 w=1 nf=1 m=1
M9 VX VB4 net0 VSS nch l=0.15 w=1 nf=1 m=1
.ends opamp

.subckt dut VDD VSS Vout VB1 VB2
M16 VB4 net0 VDD VDD pch l=0.15 w=1 nf=1 m=1
M17 VB4 VB4 net2 VSS nch l=0.15 w=1 nf=1 m=1
M18 net2 VB4 VSS VSS nch l=0.15 w=1 nf=1 m=1
M19 net0 net0 VDD VDD pch l=0.15 w=1 nf=1 m=1
M20 net0 VB3 VSS VSS nch l=0.15 w=1 nf=1 m=1
M21 VB3 net0 VDD VDD pch l=0.15 w=1 nf=1 m=1
M22 net1 VB3 VSS VSS nch l=0.15 w=1 nf=1 m=1
Q1 X X VSS VSS qnpn m=1
Q2 net2 net2 VSS VSS qnpn m=1
R1 Vout X 1k
R2 Vout Y 1k
R3 Y net2 1k
R4 VB3 net1 1k
X1 VDD VSS Y X VB2 Vout VB1 VB4 opamp
.ends dut
