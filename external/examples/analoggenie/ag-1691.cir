* official Analog Canvas netlist; PDK X cards rewritten by convert.py
.model nch nmos
.model pch pmos
.model qpnp pnp

.subckt A1 VDD VSS VB1 INP Z INN OUT VB3 VB5 VB2
M1 net0 VB1 VDD VDD pch l=0.15 w=1 nf=1 m=1
M10 VA VB2 VSS VSS nch l=0.15 w=1 nf=1 m=1
M11 Z VB2 VSS VSS nch l=0.15 w=1 nf=1 m=1
M2 VA INP net0 VDD pch l=0.15 w=1 nf=1 m=1
M3 Z INN net0 VDD pch l=0.15 w=1 nf=1 m=1
M4 INN net1 VDD VDD pch l=0.15 w=1 nf=1 m=1
M5 net2 net1 VDD VDD pch l=0.15 w=1 nf=1 m=1
M6 OUT VB3 INN VDD pch l=0.15 w=1 nf=1 m=1
M7 net1 VB3 net2 VDD pch l=0.15 w=1 nf=1 m=1
M8 OUT VB5 VA VSS nch l=0.15 w=1 nf=1 m=1
M9 net1 VB5 Z VSS nch l=0.15 w=1 nf=1 m=1
.ends A1

.subckt dut VDD VSS Vout VB1 VB3 VB2
M12 net4 net1 VDD VDD pch l=0.15 w=1 nf=1 m=1
M13 net4 net4 net2 VSS nch l=0.15 w=1 nf=1 m=1
M14 net2 net4 VSS VSS nch l=0.15 w=1 nf=1 m=1
M15 net1 net1 VDD VDD pch l=0.15 w=1 nf=1 m=1
M16 net1 VB4 net0 VSS nch l=0.15 w=1 nf=1 m=1
M17 VB4 net1 VDD VDD pch l=0.15 w=1 nf=1 m=1
M18 VB4 VB4 VSS VSS nch l=0.15 w=1 nf=1 m=1
Q1 VSS VSS net5 qpnp m=1
Q2 net5 net5 net3 qpnp m=1
Q3 VSS VSS net6 qpnp m=1
Q4 net6 net6 Y qpnp m=1
R1 Vout X 1k
R2 Vout Y 1k
R3 X net3 1k
R4 net0 VSS 1k
X1 VDD VSS VB1 X net6 Y Vout VB3 net4 VB2 A1
.ends dut
