* official Analog Canvas netlist; PDK X cards rewritten by convert.py
.model nch nmos
.model pch pmos
.model qpnp pnp

.subckt opamp VDD VSS INP INN OUT
M1 net3 VB1 VDD VDD pch l=0.15 w=1 nf=1 m=1
M10 net1 VB2 VSS VSS nch l=0.15 w=1 nf=1 m=1
M11 net7 VB2 VSS VSS nch l=0.15 w=1 nf=1 m=1
M12 net0 net0 VDD VDD pch l=0.15 w=1 nf=1 m=1
M13 VB4 net0 VDD VDD pch l=0.15 w=1 nf=1 m=1
M14 VB4 VB4 net4 VSS nch l=0.15 w=1 nf=1 m=1
M15 net4 VB4 VSS VSS nch l=0.15 w=1 nf=1 m=1
M2 net1 INP net3 VDD pch l=0.15 w=1 nf=1 m=1
M3 net7 INN net3 VDD pch l=0.15 w=1 nf=1 m=1
M4 net6 net5 VDD VDD pch l=0.15 w=1 nf=1 m=1
M5 net2 net5 VDD VDD pch l=0.15 w=1 nf=1 m=1
M6 net5 VB3 net6 VDD pch l=0.15 w=1 nf=1 m=1
M7 OUT VB3 net2 VDD pch l=0.15 w=1 nf=1 m=1
M8 net5 VB4 net1 VSS nch l=0.15 w=1 nf=1 m=1
M9 OUT VB4 net7 VSS nch l=0.15 w=1 nf=1 m=1
R4 net0 VSS 1k
.ends opamp

.subckt dut VDD VSS Vout
Q1 VSS VSS X qpnp m=1
Q2 VSS VSS net0 qpnp m=1
R1 Vout X 1k
R2 Vout Y 1k
R3 Y net0 1k
X1 VDD VSS X Y Vout opamp
.ends dut
