* official Analog Canvas netlist; PDK X cards rewritten by convert.py
.model nch nmos
.model pch pmos

.subckt dut VDD VSS vi1 vi2 vout
IBIAS VDD net2 DC 1m
M1 net1 vi1 net4 VSS nch l=0.15 w=1 nf=1 m=1
M10 net3 net3 VSS VSS nch l=0.15 w=1 nf=1 m=1
M11 vout net3 VSS VSS nch l=0.15 w=1 nf=1 m=1
M12 vout net0 VDD VDD pch l=0.15 w=1 nf=1 m=1
M2 net0 vi2 net4 VSS nch l=0.15 w=1 nf=1 m=1
M3 net1 net1 VDD VDD pch l=0.15 w=1 nf=1 m=1
M4 net0 net0 VDD VDD pch l=0.15 w=1 nf=1 m=1
M5 net4 net2 VSS VSS nch l=0.15 w=1 nf=1 m=1
M6 net0 net1 VDD VDD pch l=0.15 w=1 nf=1 m=1
M7 net1 net0 VDD VDD pch l=0.15 w=1 nf=1 m=1
M8 net2 net2 VSS VSS nch l=0.15 w=1 nf=1 m=1
M9 net3 net1 VDD VDD pch l=0.15 w=1 nf=1 m=1
.ends dut
