* official Analog Canvas netlist; PDK X cards rewritten by convert.py
.model nch nmos
.model pch pmos

.subckt comparator VDD VSS IN OUT
M1 net4 net0 VDD VDD pch l=0.15 w=1 nf=1 m=1
M10 net2 net1 VDD VDD pch l=0.15 w=1 nf=1 m=1
M11 OUT OUT VDD VDD pch l=0.15 w=1 nf=1 m=1
M12 OUT OUT VDD VDD pch l=0.15 w=1 nf=1 m=1
M13 net1 IN net7 VSS nch l=0.15 w=1 nf=1 m=1
M14 OUT OUT net7 VSS nch l=0.15 w=1 nf=1 m=1
M15 net7 net6 VSS VSS nch l=0.15 w=1 nf=1 m=1
M16 net2 net2 VSS VSS nch l=0.15 w=1 nf=1 m=1
M17 OUT net2 VSS VSS nch l=0.15 w=1 nf=1 m=1
M2 net0 net0 VDD VDD pch l=0.15 w=1 nf=1 m=1
M3 net5 net5 VDD VDD pch l=0.15 w=1 nf=1 m=1
M4 net6 net5 VDD VDD pch l=0.15 w=1 nf=1 m=1
M5 net0 net4 net3 VSS nch l=0.15 w=1 nf=1 m=1
M6 net4 net3 VSS VSS nch l=0.15 w=1 nf=1 m=1
M7 net5 net3 VSS VSS nch l=0.15 w=1 nf=1 m=1
M8 net6 net6 VSS VSS nch l=0.15 w=1 nf=1 m=1
M9 net1 net1 VDD VDD pch l=0.15 w=1 nf=1 m=1
R1 net3 VSS 1k
.ends comparator

.subckt dut VDD VSS VSTO VCONT1 VCONT2 VCONT3 VOUT
CL VOUT VSS 1p
CSTO VSTO VSS 1p
LRX net2 net1 1n
MN1 net2 VCONT2 VSS VSS nch l=0.15 w=1 nf=1 m=1
MN2 net1 VCONT3 VSS VSS nch l=0.15 w=1 nf=1 m=1
MP2 net1 net0 VOUT VDD pch l=0.15 w=1 nf=1 m=1
MP3 net2 VCONT1 VSTO VDD pch l=0.15 w=1 nf=1 m=1
X1 VDD VSS net1 net0 comparator
.ends dut
