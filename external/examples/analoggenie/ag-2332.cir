* official Analog Canvas netlist; PDK X cards rewritten by convert.py
.model nch nmos
.model pch pmos

.subckt dut VDD VSS VREF VB2 IBUF VIN VOUT
CL VOUT net4 1p
M1 net0 net0 VDD VDD pch l=0.15 w=1 nf=1 m=1
M13 net5 VB2 VDD VDD pch l=0.15 w=1 nf=1 m=1
M14 VX EAO net5 VDD pch l=0.15 w=1 nf=1 m=1
M15 VX VX VSS VSS nch l=0.15 w=1 nf=1 m=1
M16 GATE VX VSS VSS nch l=0.15 w=1 nf=1 m=1
M17 VDD net5 GATE VSS nch l=0.15 w=1 nf=1 m=1
M18 net2 EAO IBUF VSS nch l=0.15 w=1 nf=1 m=1
M19 net2 net2 VDD VDD pch l=0.15 w=1 nf=1 m=1
M2 net6 net6 VDD VDD pch l=0.15 w=1 nf=1 m=1
M20 GATE net2 VDD VDD pch l=0.15 w=1 nf=1 m=1
M21 VSS IBUF GATE VDD pch l=0.15 w=1 nf=1 m=1
M22 VBP VBP VDD VDD pch l=0.15 w=1 nf=1 m=1
M23 VBN VBP VDD VDD pch l=0.15 w=1 nf=1 m=1
M24 net1 VBP VDD VDD pch l=0.15 w=1 nf=1 m=1
M25 VB1 VBP VDD VDD pch l=0.15 w=1 nf=1 m=1
M26 VBN VBN VSS VSS nch l=0.15 w=1 nf=1 m=1
M27 net1 net1 VSS VSS nch l=0.15 w=1 nf=1 m=1
M28 net3 net1 VSS VSS nch l=0.15 w=1 nf=1 m=1
M29 VBP VB1 net3 VSS nch l=0.15 w=1 nf=1 m=1
M3 net0 VREF VX VSS nch l=0.15 w=1 nf=1 m=1
M30 VB1 VB1 VSS VSS nch l=0.15 w=1 nf=1 m=1
M4 net6 FB VX VSS nch l=0.15 w=1 nf=1 m=1
M5 VX VBN VSS VSS nch l=0.15 w=1 nf=1 m=1
M6 EAO net0 VDD VDD pch l=0.15 w=1 nf=1 m=1
M7 net7 net6 VDD VDD pch l=0.15 w=1 nf=1 m=1
M8 net7 net7 VSS VSS nch l=0.15 w=1 nf=1 m=1
M9 EAO net7 VSS VSS nch l=0.15 w=1 nf=1 m=1
MNP VIN GATE VOUT VSS nch l=0.15 w=1 nf=1 m=1
R1 FB VSS 1k
R2 VOUT FB 1k
R3 net4 VSS 1k
RL VOUT VSS 1k
.ends dut
