* official Analog Canvas netlist; PDK X cards rewritten by convert.py
.model nch nmos

.subckt dut VDD VSS ID1
CB net0 VSS 1p
IREF VDD net1 DC 1m
M1 ID1 net0 VSS VSS nch l=0.15 w=1 nf=1 m=1
MREF net1 net1 VSS VSS nch l=0.15 w=1 nf=1 m=1
RB net1 net0 1k
.ends dut
