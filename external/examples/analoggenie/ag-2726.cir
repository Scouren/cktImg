* official Analog Canvas netlist; PDK X cards rewritten by convert.py
.model nch nmos
.model pch pmos

.subckt dut VDD VSS vci phi1 phi2 vco
C1 vcx VSS 1p
C2 net2 vco 1p
M1 vci phi1 vcx VSS nch l=0.15 w=1 nf=1 m=1
M10 VX vcx VDD VDD pch l=0.15 w=1 nf=1 m=1
M11 VX VX VSS VSS nch l=0.15 w=1 nf=1 m=1
M12 VB2 VB1 VDD VDD pch l=0.15 w=1 nf=1 m=1
M13 VB2 VB2 VSS VSS nch l=0.15 w=1 nf=1 m=1
M14 VB1 VB1 VDD VDD pch l=0.15 w=1 nf=1 m=1
M15 VB1 net0 VSS VSS nch l=0.15 w=1 nf=1 m=1
M16 net0 VY VDD VDD pch l=0.15 w=1 nf=1 m=1
M17 net0 net0 VSS VSS nch l=0.15 w=1 nf=1 m=1
M18 VY VY net0 VDD pch l=0.15 w=1 nf=1 m=1
M2 vcx phi2 net2 VSS nch l=0.15 w=1 nf=1 m=1
M3 vcx net2 net3 VSS nch l=0.15 w=1 nf=1 m=1
M4 net1 VSS net3 VSS nch l=0.15 w=1 nf=1 m=1
M5 net3 VB2 VSS VSS nch l=0.15 w=1 nf=1 m=1
M6 vcx vcx VDD VDD pch l=0.15 w=1 nf=1 m=1
M7 net1 net1 VDD VDD pch l=0.15 w=1 nf=1 m=1
M8 vco net1 VDD VDD pch l=0.15 w=1 nf=1 m=1
M9 vco VX VSS VSS nch l=0.15 w=1 nf=1 m=1
R1 VDD net0 1k
R2 VY VSS 1k
.ends dut
