* official Analog Canvas netlist; PDK X cards rewritten by convert.py
.model nch nmos
.model pch pmos

.subckt opamp VDD VSS INN OUT
M10 OUT VB4 net1 VSS nch l=0.15 w=1 nf=1 m=1
M11 net3 VB4 net4 VSS nch l=0.15 w=1 nf=1 m=1
M12 net1 VB2 VSS VSS nch l=0.15 w=1 nf=1 m=1
M13 net4 VB2 VSS VSS nch l=0.15 w=1 nf=1 m=1
M14 net2 net2 net5 VDD pch l=0.15 w=1 nf=1 m=1
M15 VB4 net2 VDD VDD pch l=0.15 w=1 nf=1 m=1
M16 VB4 VB4 net7 VSS nch l=0.15 w=1 nf=1 m=1
M17 net7 VB4 VSS VSS nch l=0.15 w=1 nf=1 m=1
M3 net6 VB1 VDD VDD pch l=0.15 w=1 nf=1 m=1
M4 net1 INN net6 VDD pch l=0.15 w=1 nf=1 m=1
M5 net4 OUT net6 VDD pch l=0.15 w=1 nf=1 m=1
M6 net0 net3 VDD VDD pch l=0.15 w=1 nf=1 m=1
M7 net8 net3 VDD VDD pch l=0.15 w=1 nf=1 m=1
M8 OUT VB3 net0 VDD pch l=0.15 w=1 nf=1 m=1
M9 net3 VB3 net8 VDD pch l=0.15 w=1 nf=1 m=1
R1 VDD net5 1k
R2 net2 VSS 1k
.ends opamp

.subckt dut VDD VSS VSTO VCONT1 VCONT2 VCONT3 VOUT
CL VOUT VSS 1p
CSTO VSTO VSS 1p
LRX net2 net1 1n
MN1 net2 VCONT2 VSS VSS nch l=0.15 w=1 nf=1 m=1
MN2 net1 VCONT3 VSS VSS nch l=0.15 w=1 nf=1 m=1
MP2 net1 net0 VOUT VDD pch l=0.15 w=1 nf=1 m=1
MP3 net2 VCONT1 VSTO VDD pch l=0.15 w=1 nf=1 m=1
X1 VDD VSS net1 net0 opamp
.ends dut
