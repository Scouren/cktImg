* official Analog Canvas netlist; PDK X cards rewritten by convert.py
.model nch nmos
.model pch pmos

.subckt dut VDD VSS VIN VCONT1 VB5 VCONT2 VCONT3 VCONT5 VCONT4 VP VB2 VB1 VREF
.model DIODE D(IS=1e-14 N=1)
CFLY VX1 VX2 1p
CO VP VN 1p
COP VP VSS 1p
D1 VN VX2 DIODE
L1 VX1 VX3 1n
M1 VX1 VCONT2 VIN VDD pch l=0.15 w=1 nf=1 m=1
M2 VX2 VCONT3 VIN VDD pch l=0.15 w=1 nf=1 m=1
M3 VX3 VCONT4 VSS VSS nch l=0.15 w=1 nf=1 m=1
M4 VP VCONT5 VX3 VDD pch l=0.15 w=1 nf=1 m=1
M5 net7 VCONT1 VIN VDD pch l=0.15 w=1 nf=1 m=1
MN1 VX VB6 net2 VSS nch l=0.15 w=1 nf=1 m=1
MN10 VB8 net5 net6 VSS nch l=0.15 w=1 nf=1 m=1
MN11 net5 net6 VSS VSS nch l=0.15 w=1 nf=1 m=1
MN12 net6 VX2 VSS VSS nch l=0.15 w=1 nf=1 m=1
MN13 VX2 VX2 VSS VSS nch l=0.15 w=1 nf=1 m=1
MN2 VEA1 VB6 net3 VSS nch l=0.15 w=1 nf=1 m=1
MN3 net2 VB7 VSS VSS nch l=0.15 w=1 nf=1 m=1
MN4 net3 VB7 VSS VSS nch l=0.15 w=1 nf=1 m=1
MN5 VB6 VB6 VB7 VSS nch l=0.15 w=1 nf=1 m=1
MN6 net1 net0 VSS VSS nch l=0.15 w=1 nf=1 m=1
MN7 net0 net0 VSS VSS nch l=0.15 w=1 nf=1 m=1
MN8 net0 VB5 VSS VSS nch l=0.15 w=1 nf=1 m=1
MN9 VB7 VB7 VSS VSS nch l=0.15 w=1 nf=1 m=1
MP1 net4 VB1 VDD VDD pch l=0.15 w=1 nf=1 m=1
MP10 VEA1 VB2 net9 VDD pch l=0.15 w=1 nf=1 m=1
MP11 VB6 VB8 VDD VDD pch l=0.15 w=1 nf=1 m=1
MP12 VB8 VB8 VDD VDD pch l=0.15 w=1 nf=1 m=1
MP13 net5 VB8 VDD VDD pch l=0.15 w=1 nf=1 m=1
MP14 VX2 VB8 VDD VDD pch l=0.15 w=1 nf=1 m=1
MP2 net2 VREF net4 VDD pch l=0.15 w=1 nf=1 m=1
MP3 net3 VFP1 net4 VDD pch l=0.15 w=1 nf=1 m=1
MP4 net1 net1 net7 VDD pch l=0.15 w=1 nf=1 m=1
MP5 VX1 net1 net7 VDD pch l=0.15 w=1 nf=1 m=1
MP6 net0 VEA1 net7 VDD pch l=0.15 w=1 nf=1 m=1
MP7 net8 VX VDD VDD pch l=0.15 w=1 nf=1 m=1
MP8 net9 VX VDD VDD pch l=0.15 w=1 nf=1 m=1
MP9 VX VB2 net8 VDD pch l=0.15 w=1 nf=1 m=1
R1 VP VFP1 1k
R2 VFP1 VSS 1k
.ends dut
