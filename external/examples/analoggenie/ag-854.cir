* official Analog Canvas netlist; PDK X cards rewritten by convert.py
.model nch nmos
.model pch pmos

.subckt dut VDD VSS IBIAS2 IBIAS1
M1 net1 net2 VSS VSS nch l=0.15 w=1 nf=1 m=1
M2 net0 net1 net2 VSS nch l=0.15 w=1 nf=1 m=1
M3 IBIAS1 net2 VSS VSS nch l=0.15 w=1 nf=1 m=1
M4 net1 net0 VDD VDD pch l=0.15 w=1 nf=1 m=1
M5 net0 net0 VDD VDD pch l=0.15 w=1 nf=1 m=1
M6 IBIAS2 net0 VDD VDD pch l=0.15 w=1 nf=1 m=1
R1 net2 VSS 1k
.ends dut
