* official Analog Canvas netlist; PDK X cards rewritten by convert.py
.model nch nmos
.model pch pmos

.subckt dut VDD VSS VIN VP VCONT1 VCONT2 VCONT3 VCONT4 VCONT5 VB5 VB4 VB1 VB3 VREF VB2
.model DIODE D(IS=1e-14 N=1)
CFLY VX1 VX2 1p
CO VP VN 1p
COP VP VSS 1p
D1 VN VX2 DIODE
L1 VX1 VX3 1n
M1 VX1 VCONT2 VIN VDD pch l=0.15 w=1 nf=1 m=1
M2 VX2 VCONT3 VIN VDD pch l=0.15 w=1 nf=1 m=1
M3 VP VCONT5 VX3 VDD pch l=0.15 w=1 nf=1 m=1
M4 VX3 VCONT4 VSS VSS nch l=0.15 w=1 nf=1 m=1
M5 net8 VCONT1 VIN VDD pch l=0.15 w=1 nf=1 m=1
MN1 net4 VB6 net6 VSS nch l=0.15 w=1 nf=1 m=1
MN10 net10 VB6 VSS VSS nch l=0.15 w=1 nf=1 m=1
MN11 VB4 VB4 VSS VSS nch l=0.15 w=1 nf=1 m=1
MN12 net0 VB4 VX2 VSS nch l=0.15 w=1 nf=1 m=1
MN2 VCTRL VB6 net5 VSS nch l=0.15 w=1 nf=1 m=1
MN3 net6 VB2 VSS VSS nch l=0.15 w=1 nf=1 m=1
MN4 net5 VB2 VSS VSS nch l=0.15 w=1 nf=1 m=1
MN6 net1 net7 VSS VSS nch l=0.15 w=1 nf=1 m=1
MN7 net7 net7 VSS VSS nch l=0.15 w=1 nf=1 m=1
MN8 net7 VB5 VSS VSS nch l=0.15 w=1 nf=1 m=1
MN9 VB6 VB6 net10 VSS nch l=0.15 w=1 nf=1 m=1
MP1 net3 VB1 VDD VDD pch l=0.15 w=1 nf=1 m=1
MP10 VCTRL VB3 net2 VDD pch l=0.15 w=1 nf=1 m=1
MP11 VB6 net0 VDD VDD pch l=0.15 w=1 nf=1 m=1
MP12 net0 net0 VDD VDD pch l=0.15 w=1 nf=1 m=1
MP13 VB4 net0 VDD VDD pch l=0.15 w=1 nf=1 m=1
MP2 net6 VREF net3 VDD pch l=0.15 w=1 nf=1 m=1
MP3 net5 VFP1 net3 VDD pch l=0.15 w=1 nf=1 m=1
MP4 net1 net1 net8 VDD pch l=0.15 w=1 nf=1 m=1
MP5 VX1 net1 net8 VDD pch l=0.15 w=1 nf=1 m=1
MP6 net7 VCTRL net8 VDD pch l=0.15 w=1 nf=1 m=1
MP7 net9 net4 VDD VDD pch l=0.15 w=1 nf=1 m=1
MP8 net2 net4 VDD VDD pch l=0.15 w=1 nf=1 m=1
MP9 net4 VB3 net9 VDD pch l=0.15 w=1 nf=1 m=1
R1 VP VFP1 1k
R2 VFP1 VSS 1k
RBIAS VX2 VSS 1k
.ends dut
