* official Analog Canvas netlist; PDK X cards rewritten by convert.py
.model nch nmos
.model pch pmos

.subckt dut VDD VSS VB1 VB2 VREF VIN VB4 VB5 VB6 VOUT
CF1 VOUT VFB 1p
Cm1 VOUT V1 1p
Cm2 V1 net3 1p
M11 net2 VB2 VIN VDD pch l=0.15 w=1 nf=1 m=1
M12 net8 VFB net2 VDD pch l=0.15 w=1 nf=1 m=1
M13 V2 VREF net2 VDD pch l=0.15 w=1 nf=1 m=1
M14 V3 net8 VSS VSS nch l=0.15 w=1 nf=1 m=1
M15 net9 V2 VSS VSS nch l=0.15 w=1 nf=1 m=1
M16 V2 VB4 VIN VDD pch l=0.15 w=1 nf=1 m=1
M17 V2 V2 VSS VSS nch l=0.15 w=1 nf=1 m=1
M18 V2 V1 VSS VSS nch l=0.15 w=1 nf=1 m=1
M21 net0 V1 VSS VSS nch l=0.15 w=1 nf=1 m=1
M22 net11 V2 VSS VSS nch l=0.15 w=1 nf=1 m=1
M23 net0 net0 VIN VDD pch l=0.15 w=1 nf=1 m=1
M24 net11 net0 VIN VDD pch l=0.15 w=1 nf=1 m=1
M25 net8 VC V3 VSS nch l=0.15 w=1 nf=1 m=1
M26 V2 VC net9 VSS nch l=0.15 w=1 nf=1 m=1
M27 VX VC net10 VSS nch l=0.15 w=1 nf=1 m=1
M28 V1 VC net6 VSS nch l=0.15 w=1 nf=1 m=1
M29 net10 net8 VSS VSS nch l=0.15 w=1 nf=1 m=1
M30 net6 V2 VSS VSS nch l=0.15 w=1 nf=1 m=1
M31 VX VB1 VY VDD pch l=0.15 w=1 nf=1 m=1
M32 V1 VB1 VZ VDD pch l=0.15 w=1 nf=1 m=1
M33 VY VX VIN VDD pch l=0.15 w=1 nf=1 m=1
M34 VZ VX VIN VDD pch l=0.15 w=1 nf=1 m=1
M35 VC VP VIN VDD pch l=0.15 w=1 nf=1 m=1
M36 VC VC net5 VSS nch l=0.15 w=1 nf=1 m=1
M37 net5 VC VSS VSS nch l=0.15 w=1 nf=1 m=1
M38 VP VP VIN VDD pch l=0.15 w=1 nf=1 m=1
M39 VP VZ VSS VSS nch l=0.15 w=1 nf=1 m=1
M40 net12 VP VIN VDD pch l=0.15 w=1 nf=1 m=1
M41 net12 net12 VZ VSS nch l=0.15 w=1 nf=1 m=1
M42 VZ net12 net7 VSS nch l=0.15 w=1 nf=1 m=1
M43 VY VP VIN VDD pch l=0.15 w=1 nf=1 m=1
M44 VY VY net7 VSS nch l=0.15 w=1 nf=1 m=1
M45 net7 VY VB3 VSS nch l=0.15 w=1 nf=1 m=1
M46 VB3 VP VIN VDD pch l=0.15 w=1 nf=1 m=1
M47 VB3 VB3 VSS VSS nch l=0.15 w=1 nf=1 m=1
MD1 net3 V1 VSS VSS nch l=0.15 w=1 nf=1 m=1
MD2 net1 VB5 VSS VSS nch l=0.15 w=1 nf=1 m=1
MD3 V3 net3 net1 VSS nch l=0.15 w=1 nf=1 m=1
MD4 net4 VB6 net1 VSS nch l=0.15 w=1 nf=1 m=1
MD5 net3 net4 VIN VDD pch l=0.15 w=1 nf=1 m=1
MD6 net4 net4 VIN VDD pch l=0.15 w=1 nf=1 m=1
MD7 V3 V3 VIN VDD pch l=0.15 w=1 nf=1 m=1
MPT VOUT net11 VIN VDD pch l=0.15 w=1 nf=1 m=1
RF1 VOUT VFB 1k
RF2 VFB VSS 1k
.ends dut
