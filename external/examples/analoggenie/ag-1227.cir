* official Analog Canvas netlist; PDK X cards rewritten by convert.py
.model nch nmos
.model pch pmos

.subckt dut VDD VSS VCONT1 VB4 VCONT2 VCONT4 VCONT5 VP VCONT3 VIN VB1 VB2 VREF
.model DIODE D(IS=1e-14 N=1)
CFLY VX1 VX2 1p
CO VP VN 1p
COP VP VSS 1p
D1 VN VX2 DIODE
L1 VX1 VX3 1n
M1 VIN VCONT1 net0 VDD pch l=0.15 w=1 nf=1 m=1
M2 VIN VCONT2 VX1 VDD pch l=0.15 w=1 nf=1 m=1
M3 VX3 VCONT4 VSS VSS nch l=0.15 w=1 nf=1 m=1
M4 VP VCONT5 VX3 VDD pch l=0.15 w=1 nf=1 m=1
M5 VIN VCONT3 VX2 VDD pch l=0.15 w=1 nf=1 m=1
MN1 net8 VB6 VSS VSS nch l=0.15 w=1 nf=1 m=1
MN10 VB7 net1 VSS VSS nch l=0.15 w=1 nf=1 m=1
MN11 net1 net1 VSS VSS nch l=0.15 w=1 nf=1 m=1
MN2 net7 VB6 VSS VSS nch l=0.15 w=1 nf=1 m=1
MN3 VM VB5 net8 VSS nch l=0.15 w=1 nf=1 m=1
MN4 VCTRL VB5 net7 VSS nch l=0.15 w=1 nf=1 m=1
MN5 VB5 VB5 VB6 VSS nch l=0.15 w=1 nf=1 m=1
MN6 net4 net5 VSS VSS nch l=0.15 w=1 nf=1 m=1
MN7 net5 net5 VSS VSS nch l=0.15 w=1 nf=1 m=1
MN8 net5 VB4 VSS VSS nch l=0.15 w=1 nf=1 m=1
MN9 VB6 VB6 VSS VSS nch l=0.15 w=1 nf=1 m=1
MP1 net3 VB1 VDD VDD pch l=0.15 w=1 nf=1 m=1
MP10 net2 VM VDD VDD pch l=0.15 w=1 nf=1 m=1
MP11 VB5 VB7 VDD VDD pch l=0.15 w=1 nf=1 m=1
MP12 VB7 VB7 VDD VDD pch l=0.15 w=1 nf=1 m=1
MP13 net1 VB7 VDD VDD pch l=0.15 w=1 nf=1 m=1
MP2 net8 VREF net3 VDD pch l=0.15 w=1 nf=1 m=1
MP3 net7 VFP1 net3 VDD pch l=0.15 w=1 nf=1 m=1
MP4 net4 net4 net0 VDD pch l=0.15 w=1 nf=1 m=1
MP5 VX1 net4 net0 VDD pch l=0.15 w=1 nf=1 m=1
MP6 net5 VCTRL net0 VDD pch l=0.15 w=1 nf=1 m=1
MP7 VM VB2 net6 VDD pch l=0.15 w=1 nf=1 m=1
MP8 VCTRL VB2 net2 VDD pch l=0.15 w=1 nf=1 m=1
MP9 net6 VM VDD VDD pch l=0.15 w=1 nf=1 m=1
R1 VP VFP1 1k
R2 VFP1 VSS 1k
.ends dut
