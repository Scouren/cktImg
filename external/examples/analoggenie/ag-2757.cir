* official Analog Canvas netlist; PDK X cards rewritten by convert.py
.model nch nmos
.model pch pmos

.subckt opamp VDD VSS INN INP OUT VB1
M10 net3 net2 VSS VSS nch l=0.15 w=1 nf=1 m=1
M11 OUT VX VSS VSS nch l=0.15 w=1 nf=1 m=1
M12 VB1 VB1 VDD VDD pch l=0.15 w=1 nf=1 m=1
M13 net0 VB1 VDD VDD pch l=0.15 w=1 nf=1 m=1
M14 net1 net1 VDD VDD pch l=0.15 w=1 nf=1 m=1
M15 VB1 net0 VSS VSS nch l=0.15 w=1 nf=1 m=1
M16 net4 net0 VSS VSS nch l=0.15 w=1 nf=1 m=1
M17 net1 net0 VSS VSS nch l=0.15 w=1 nf=1 m=1
M3 VX INN net5 VDD pch l=0.15 w=1 nf=1 m=1
M4 net2 INP net5 VDD pch l=0.15 w=1 nf=1 m=1
M5 net5 net1 VDD VDD pch l=0.15 w=1 nf=1 m=1
M6 net3 net3 VDD VDD pch l=0.15 w=1 nf=1 m=1
M7 OUT net3 VDD VDD pch l=0.15 w=1 nf=1 m=1
M8 VX VX VSS VSS nch l=0.15 w=1 nf=1 m=1
M9 net2 net2 VSS VSS nch l=0.15 w=1 nf=1 m=1
R1 net0 net4 1k
.ends opamp

.subckt dut VDD VSS vci phi1 phi2 vco VB1
C1 net1 VSS 1p
C2 net0 vco 1p
M1 vci phi1 net1 VSS nch l=0.15 w=1 nf=1 m=1
M2 net1 phi2 net0 VSS nch l=0.15 w=1 nf=1 m=1
X1 VDD VSS net0 VSS vco VB1 opamp
.ends dut
