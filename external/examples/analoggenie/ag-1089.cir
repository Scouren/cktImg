* official Analog Canvas netlist; PDK X cards rewritten by convert.py
.model nch nmos
.model pch pmos

.subckt dut VDD VSS IN OUT Vgn1 Vgp1 By-Pass S2
.model ideal_switch SW(RON=1 ROFF=1e12 VT=0.5 VH=0)
C1 IN net0 1p
C2 1.6V VSS 1p
IREF net3 VSS DC 1m
Mn1 net1 Vgn1 IN VSS nch l=0.15 w=1 nf=1 m=1
Mn2 OUT net0 VSS VSS nch l=0.15 w=1 nf=1 m=1
Mn3 net2 net2 VSS VSS nch l=0.15 w=1 nf=1 m=1
Mn4 OUT net2 VSS VSS nch l=0.15 w=1 nf=1 m=1
Mp1 net2 Vgp1 IN VDD pch l=0.15 w=1 nf=1 m=1
Mp2 OUT net0 1.6V VDD pch l=0.15 w=1 nf=1 m=1
Mp3 net1 net1 VDD VDD pch l=0.15 w=1 nf=1 m=1
Mp4 OUT net1 VDD VDD pch l=0.15 w=1 nf=1 m=1
Mp5 net5 net5 VDD VDD pch l=0.15 w=1 nf=1 m=1
Mp6 1.6V net4 VDD VDD pch l=0.15 w=1 nf=1 m=1
R1 net4 net5 1k
Rf OUT net0 1k
S1 IN OUT By-Pass VSS ideal_switch
S2 net5 net3 S2 VSS ideal_switch
.ends dut
