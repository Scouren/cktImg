* official Analog Canvas netlist; PDK X cards rewritten by convert.py
.model nch nmos
.model pch pmos

.subckt dut VDD VSS VIN VOUT VERR pb nb VREF VB2 VB1
M1 net6 VEAOUT VIN VDD pch l=0.15 w=1 nf=1 m=1
M10 net0 VBN VSS VSS nch l=0.15 w=1 nf=1 m=1
M11 VEAOUT VEAOUT VSS VSS nch l=0.15 w=1 nf=1 m=1
M12 VEAOUT VEAOUT VSS VSS nch l=0.15 w=1 nf=1 m=1
M13 VB2 VB2 VDD VDD pch l=0.15 w=1 nf=1 m=1
M14 VB2 net4 VSS VSS nch l=0.15 w=1 nf=1 m=1
M15 net4 VB2 VDD VDD pch l=0.15 w=1 nf=1 m=1
M16 net4 net4 VSS VSS nch l=0.15 w=1 nf=1 m=1
M17 net3 net3 VDD VDD pch l=0.15 w=1 nf=1 m=1
M18 net3 net4 VSS VSS nch l=0.15 w=1 nf=1 m=1
M19 VBN net3 VDD VDD pch l=0.15 w=1 nf=1 m=1
M2 net2 net2 net6 VDD pch l=0.15 w=1 nf=1 m=1
M20 VBN VBN VSS VSS nch l=0.15 w=1 nf=1 m=1
M21 VB1 VB1 VDD VDD pch l=0.15 w=1 nf=1 m=1
M22 VB1 VBN VSS VSS nch l=0.15 w=1 nf=1 m=1
M3 net2 nb VSS VSS nch l=0.15 w=1 nf=1 m=1
M4 VEAOUT net5 VDD VDD pch l=0.15 w=1 nf=1 m=1
M5 net5 net5 VDD VDD pch l=0.15 w=1 nf=1 m=1
M6 net8 net8 VDD VDD pch l=0.15 w=1 nf=1 m=1
M7 VEAOUT net8 VDD VDD pch l=0.15 w=1 nf=1 m=1
M8 net5 VREF net0 VSS nch l=0.15 w=1 nf=1 m=1
M9 net8 VEAOUT net0 VSS nch l=0.15 w=1 nf=1 m=1
MBIAS VERR nb VSS VSS nch l=0.15 w=1 nf=1 m=1
MCHG net1 pb VIN VDD pch l=0.15 w=1 nf=1 m=1
MCTRL VERR net2 VOUT VDD pch l=0.15 w=1 nf=1 m=1
MGEN net7 net7 VSS VSS nch l=0.15 w=1 nf=1 m=1
MINJ VERR net7 VSS VSS nch l=0.15 w=1 nf=1 m=1
MRES VOUT VERR VIN VDD pch l=0.15 w=1 nf=1 m=1
MSEN net7 VEAOUT net1 VDD pch l=0.15 w=1 nf=1 m=1
.ends dut
