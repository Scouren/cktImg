* official Analog Canvas netlist; PDK X cards rewritten by convert.py
.model nch nmos
.model pch pmos

.subckt dut VDD VSS VC5 VC1 VC2 VIN VC3 VC4 VP VREF VB1
.model DIODE D(IS=1e-14 N=1)
CFLY VX1 VX2 1p
CO VP VN 1p
COP VP VSS 1p
D1 VN VX2 DIODE
L1 VX1 VX3 1n
M1 VX1 VC1 VIN VDD pch l=0.15 w=1 nf=1 m=1
M2 VX2 VC2 VIN VDD pch l=0.15 w=1 nf=1 m=1
M3 VP VC3 VX3 VDD pch l=0.15 w=1 nf=1 m=1
M4 VX3 VC4 VSS VSS nch l=0.15 w=1 nf=1 m=1
M5 VISR VC5 VIN VDD pch l=0.15 w=1 nf=1 m=1
MN1 net3 VFP1 net1 VSS nch l=0.15 w=1 nf=1 m=1
MN2 VX3 VREF net1 VSS nch l=0.15 w=1 nf=1 m=1
MN3 VB2 VB2 VSS VSS nch l=0.15 w=1 nf=1 m=1
MN4 net1 VB2 VSS VSS nch l=0.15 w=1 nf=1 m=1
MN5 net2 net2 VSS VSS nch l=0.15 w=1 nf=1 m=1
MN6 VCTRL net2 VSS VSS nch l=0.15 w=1 nf=1 m=1
MN7 net5 net5 VSS VSS nch l=0.15 w=1 nf=1 m=1
MN8 net4 net5 VSS VSS nch l=0.15 w=1 nf=1 m=1
MN9 net5 VB1 VSS VSS nch l=0.15 w=1 nf=1 m=1
MP1 net3 net3 VDD VDD pch l=0.15 w=1 nf=1 m=1
MP2 VX3 VX3 VDD VDD pch l=0.15 w=1 nf=1 m=1
MP3 VCTRL VX3 VDD VDD pch l=0.15 w=1 nf=1 m=1
MP4 net2 net3 VDD VDD pch l=0.15 w=1 nf=1 m=1
MP5 VB2 net0 VDD VDD pch l=0.15 w=1 nf=1 m=1
MP6 net0 net0 net6 VDD pch l=0.15 w=1 nf=1 m=1
MP7 net5 VCTRL VISR VDD pch l=0.15 w=1 nf=1 m=1
MP8 net4 net4 VISR VDD pch l=0.15 w=1 nf=1 m=1
MP9 VX1 net4 VISR VDD pch l=0.15 w=1 nf=1 m=1
R1 VP VFP1 1k
R2 VFP1 VSS 1k
RBIAS1 VDD net6 1k
RBIAS2 net0 VSS 1k
.ends dut
