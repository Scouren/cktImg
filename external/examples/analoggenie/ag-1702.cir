* official Analog Canvas netlist; PDK X cards rewritten by convert.py
.model nch nmos
.model pch pmos
.model qpnp pnp

.subckt dut VDD VSS Vout VB1
M1 net6 Y net3 VSS nch l=0.15 w=1 nf=1 m=1
M10 VB2 VP VDD VDD pch l=0.15 w=1 nf=1 m=1
M11 VB2 VB2 VSS VSS nch l=0.15 w=1 nf=1 m=1
M12 VB1 VP VDD VDD pch l=0.15 w=1 nf=1 m=1
M13 VB1 VB1 VSS VSS nch l=0.15 w=1 nf=1 m=1
M14 VP VP VDD VDD pch l=0.15 w=1 nf=1 m=1
M15 VP VB1 net1 VSS nch l=0.15 w=1 nf=1 m=1
M16 net1 net4 VSS VSS nch l=0.15 w=1 nf=1 m=1
M17 net4 VP VDD VDD pch l=0.15 w=1 nf=1 m=1
M18 net4 net4 VSS VSS nch l=0.15 w=1 nf=1 m=1
M2 net6 net6 VDD VDD pch l=0.15 w=1 nf=1 m=1
M3 net5 net5 VDD VDD pch l=0.15 w=1 nf=1 m=1
M4 net5 X net3 VSS nch l=0.15 w=1 nf=1 m=1
M5 net3 VB2 VSS VSS nch l=0.15 w=1 nf=1 m=1
M6 net8 net6 VDD VDD pch l=0.15 w=1 nf=1 m=1
M7 Vout net5 VDD VDD pch l=0.15 w=1 nf=1 m=1
M8 net8 net8 VSS VSS nch l=0.15 w=1 nf=1 m=1
M9 Vout net8 VSS VSS nch l=0.15 w=1 nf=1 m=1
Q1 VSS VSS net7 qpnp m=1
Q2 net7 net7 X qpnp m=1
Q3 VSS VSS net2 qpnp m=1
Q4 net2 net2 net0 qpnp m=1
R1 Vout X 1k
R2 Vout Y 1k
R3 Y net0 1k
.ends dut
