* official Analog Canvas netlist; PDK X cards rewritten by convert.py
.model nch nmos
.model pch pmos

.subckt dut VDD VSS Vcontrol Vinductor Vbias
.model DIODE D(IS=1e-14 N=1)
Cbypass Vcontrol VSS 1p
D1 net4 Vcontrol DIODE
D2 net1 Vcontrol DIODE
L1 net4 net3 1n
L2 net3 net6 1n
L3 net1 net5 1n
L4 net5 net6 1n
L5 net0 VSS 1n
L6 net2 VSS 1n
M1 net4 net1 VDD VDD pch l=0.15 w=1 nf=1 m=1
M2 net1 net4 VDD VDD pch l=0.15 w=1 nf=1 m=1
M3 VSS Vbias net6 VDD pch l=0.15 w=1 nf=1 m=1
M4 net3 Vinductor net6 VSS nch l=0.15 w=1 nf=1 m=1
M5 net5 Vinductor net6 VSS nch l=0.15 w=1 nf=1 m=1
M6 net0 net4 VDD VDD pch l=0.15 w=1 nf=1 m=1
M7 net2 net1 VDD VDD pch l=0.15 w=1 nf=1 m=1
.ends dut
