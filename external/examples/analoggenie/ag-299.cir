* official Analog Canvas netlist; PDK X cards rewritten by convert.py
.model nch nmos
.model pch pmos

.subckt dut VDD VSS Vb3 Vb2 Vb1 Vin1 Vin2 Vb4 Vout1 Vout2
ISS net3 VSS DC 1m
M1 net2 Vin1 net3 VSS nch l=0.15 w=1 nf=1 m=1
M10 Vout2 Y VDD VDD pch l=0.15 w=1 nf=1 m=1
M11 Vout1 Vb4 VSS VSS nch l=0.15 w=1 nf=1 m=1
M12 Vout2 Vb4 VSS VSS nch l=0.15 w=1 nf=1 m=1
M2 net1 Vin2 net3 VSS nch l=0.15 w=1 nf=1 m=1
M3 X Vb1 net2 VSS nch l=0.15 w=1 nf=1 m=1
M4 Y Vb1 net1 VSS nch l=0.15 w=1 nf=1 m=1
M5 X Vb2 net0 VDD pch l=0.15 w=1 nf=1 m=1
M6 Y Vb2 net4 VDD pch l=0.15 w=1 nf=1 m=1
M7 net0 Vb3 VDD VDD pch l=0.15 w=1 nf=1 m=1
M8 net4 Vb3 VDD VDD pch l=0.15 w=1 nf=1 m=1
M9 Vout1 X VDD VDD pch l=0.15 w=1 nf=1 m=1
.ends dut
