* official Analog Canvas netlist; PDK X cards rewritten by convert.py
.model nch nmos
.model pch pmos

.subckt opamp VDD VSS vp vn vout
M10 VB2 net3 VSS VSS nch l=0.15 w=1 nf=1 m=1
M11 net4 VB2 VDD VDD pch l=0.15 w=1 nf=1 m=1
M12 net4 net4 VSS VSS nch l=0.15 w=1 nf=1 m=1
M13 net5 net5 VDD VDD pch l=0.15 w=1 nf=1 m=1
M14 net5 net4 VSS VSS nch l=0.15 w=1 nf=1 m=1
M15 VB1 net5 VDD VDD pch l=0.15 w=1 nf=1 m=1
M16 VB1 VB1 VSS VSS nch l=0.15 w=1 nf=1 m=1
M17 net7 VB1 VSS VSS nch l=0.15 w=1 nf=1 m=1
M18 net7 net7 VDD VDD pch l=0.15 w=1 nf=1 m=1
M19 net2 net7 VDD VDD pch l=0.15 w=1 nf=1 m=1
M20 vn vp net2 VDD pch l=0.15 w=1 nf=1 m=1
M21 vout vn net2 VDD pch l=0.15 w=1 nf=1 m=1
M22 vn vn VSS VSS nch l=0.15 w=1 nf=1 m=1
M23 vout vn VSS VSS nch l=0.15 w=1 nf=1 m=1
M3 net1 VB2 VDD VDD pch l=0.15 w=1 nf=1 m=1
M4 net1 net1 net0 VSS nch l=0.15 w=1 nf=1 m=1
M5 net6 VB2 VDD VDD pch l=0.15 w=1 nf=1 m=1
M6 net6 net6 net3 VSS nch l=0.15 w=1 nf=1 m=1
M7 net3 net6 net0 VSS nch l=0.15 w=1 nf=1 m=1
M8 net0 net1 net4 VSS nch l=0.15 w=1 nf=1 m=1
M9 VB2 VB2 VDD VDD pch l=0.15 w=1 nf=1 m=1
.ends opamp

.subckt dut VDD VSS vci phi1 phi2 vco
C1 net0 VSS 1p
C2 net1 vco 1p
M1 vci phi1 net0 VSS nch l=0.15 w=1 nf=1 m=1
M2 net0 phi2 net1 VSS nch l=0.15 w=1 nf=1 m=1
X1 VDD VSS VSS net1 vco opamp
.ends dut
