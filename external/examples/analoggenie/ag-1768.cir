* official Analog Canvas netlist; PDK X cards rewritten by convert.py
.model nch nmos
.model pch pmos
.model qpnp pnp

.subckt A1 VDD VSS INP INN OUT VE3 VE4
M10 OUT VB2 net0 VDD pch l=0.15 w=1 nf=1 m=1
M11 VE4 VB2 net5 VDD pch l=0.15 w=1 nf=1 m=1
M12 OUT VB4 net4 VSS nch l=0.15 w=1 nf=1 m=1
M13 VE4 VB4 net2 VSS nch l=0.15 w=1 nf=1 m=1
M14 net4 VB5 VSS VSS nch l=0.15 w=1 nf=1 m=1
M15 net2 VB5 VSS VSS nch l=0.15 w=1 nf=1 m=1
M16 VB4 net1 VDD VDD pch l=0.15 w=1 nf=1 m=1
M17 VB4 VB4 VB5 VSS nch l=0.15 w=1 nf=1 m=1
M18 VB5 VB5 VSS VSS nch l=0.15 w=1 nf=1 m=1
M19 net1 net1 VDD VDD pch l=0.15 w=1 nf=1 m=1
M20 net1 VB3 VSS VSS nch l=0.15 w=1 nf=1 m=1
M21 VB3 net1 VDD VDD pch l=0.15 w=1 nf=1 m=1
M22 net3 VB3 VSS VSS nch l=0.15 w=1 nf=1 m=1
M5 net2 INP VE3 VDD pch l=0.15 w=1 nf=1 m=1
M6 net4 INN VE3 VDD pch l=0.15 w=1 nf=1 m=1
M7 VE3 VB1 VDD VDD pch l=0.15 w=1 nf=1 m=1
M8 net0 VE4 VDD VDD pch l=0.15 w=1 nf=1 m=1
M9 net5 VE4 VDD VDD pch l=0.15 w=1 nf=1 m=1
R3 VB3 net3 1k
.ends A1

.subckt dut VDD VSS Vout
M1 X net1 VDD VDD pch l=0.15 w=1 nf=1 m=1
M2 Vout net1 VDD VDD pch l=0.15 w=1 nf=1 m=1
M3 net2 net1 VDD VDD pch l=0.15 w=1 nf=1 m=1
M4 VE3 net1 VDD VDD pch l=0.15 w=1 nf=1 m=1
Q1 VSS VSS net2 qpnp m=1
Q2 VSS net2 X qpnp m=1
Q3 VSS VSS VE3 qpnp m=1
Q4 VSS VE3 net0 qpnp m=1
R1 Y net0 1k
R2 Vout Y 1k
X1 VDD VSS Y X net1 VE3 net0 A1
.ends dut
