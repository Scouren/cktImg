* official Analog Canvas netlist; PDK X cards rewritten by convert.py
.model nch nmos
.model pch pmos

.subckt opamp VDD VSS INN INP OUT VB1 VB2
M1 net2 INN net9 VSS nch l=0.15 w=1 nf=1 m=1
M10 net0 net4 VDD VDD pch l=0.15 w=1 nf=1 m=1
M11 OUT VB1 net0 VDD pch l=0.15 w=1 nf=1 m=1
M12 OUT VB4 net8 VSS nch l=0.15 w=1 nf=1 m=1
M13 net8 OUT VSS VSS nch l=0.15 w=1 nf=1 m=1
M14 OUT VB4 net6 VSS nch l=0.15 w=1 nf=1 m=1
M15 net6 OUT VSS VSS nch l=0.15 w=1 nf=1 m=1
M16 VB3 net7 VDD VDD pch l=0.15 w=1 nf=1 m=1
M17 VB3 VB3 VSS VSS nch l=0.15 w=1 nf=1 m=1
M18 net7 net7 VDD VDD pch l=0.15 w=1 nf=1 m=1
M19 net7 VB3 VSS VSS nch l=0.15 w=1 nf=1 m=1
M2 net4 INP net9 VSS nch l=0.15 w=1 nf=1 m=1
M20 VB4 net7 VDD VDD pch l=0.15 w=1 nf=1 m=1
M21 VB4 VB4 net10 VSS nch l=0.15 w=1 nf=1 m=1
M22 net10 VB4 VSS VSS nch l=0.15 w=1 nf=1 m=1
M3 net9 VB2 VSS VSS nch l=0.15 w=1 nf=1 m=1
M4 net1 net2 VDD VDD pch l=0.15 w=1 nf=1 m=1
M5 net2 VB1 net1 VDD pch l=0.15 w=1 nf=1 m=1
M6 net3 net4 VDD VDD pch l=0.15 w=1 nf=1 m=1
M7 net4 VB1 net3 VDD pch l=0.15 w=1 nf=1 m=1
M8 net5 net2 VDD VDD pch l=0.15 w=1 nf=1 m=1
M9 OUT VB1 net5 VDD pch l=0.15 w=1 nf=1 m=1
.ends opamp

.subckt dut VDD VSS VIN Vref VOUT VB1 VB2
CL VOUT net1 1p
MNP VIN net0 VOUT VOUT nch l=0.15 w=1 nf=1 m=1
R1 VOUT FB 1k
R2 FB VSS 1k
RESR net1 VSS 1k
X1 VDD VSS FB Vref net0 VB1 VB2 opamp
.ends dut
