* official Analog Canvas netlist; PDK X cards rewritten by convert.py
.model nch nmos
.model pch pmos
.model qpnp pnp

.subckt opamp VDD VSS INN INP OUT VB2
M1 net3 net3 VDD VDD pch l=0.15 w=1 nf=1 m=1
M2 net2 net2 VDD VDD pch l=0.15 w=1 nf=1 m=1
M3 net2 INN net0 VSS nch l=0.15 w=1 nf=1 m=1
M4 net3 INP net0 VSS nch l=0.15 w=1 nf=1 m=1
M5 OUT net3 VDD VDD pch l=0.15 w=1 nf=1 m=1
M6 net1 net2 VDD VDD pch l=0.15 w=1 nf=1 m=1
M7 net1 net1 VSS VSS nch l=0.15 w=1 nf=1 m=1
M8 OUT net1 VSS VSS nch l=0.15 w=1 nf=1 m=1
M9 net0 VB2 VSS VSS nch l=0.15 w=1 nf=1 m=1
.ends opamp

.subckt dut VDD VSS Vout
M10 net0 net0 net1 VDD pch l=0.15 w=1 nf=1 m=1
M11 VB2 net0 VDD VDD pch l=0.15 w=1 nf=1 m=1
M12 VB2 VB2 VSS VSS nch l=0.15 w=1 nf=1 m=1
M13 VB1 VB2 VSS VSS nch l=0.15 w=1 nf=1 m=1
M14 VB1 VB1 VDD VDD pch l=0.15 w=1 nf=1 m=1
Q1 VSS VSS X qpnp m=1
Q2 VSS VSS net2 qpnp m=1
R1 Vout X 1k
R2 Vout Y 1k
R3 Y net2 1k
R4 VDD net1 1k
R5 net0 VSS 1k
X1 VDD VSS Y X Vout VB2 opamp
.ends dut
