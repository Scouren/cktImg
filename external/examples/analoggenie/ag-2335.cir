* official Analog Canvas netlist; PDK X cards rewritten by convert.py
.model nch nmos
.model pch pmos

.subckt dut VDD VSS VREF IB VB2 VIN VOUT VB1
CL VOUT net1 1p
M1 net2 net2 VDD VDD pch l=0.15 w=1 nf=1 m=1
M10 VB1 VB1 VDD VDD pch l=0.15 w=1 nf=1 m=1
M11 EAO net2 VDD VDD pch l=0.15 w=1 nf=1 m=1
M12 net4 net3 VDD VDD pch l=0.15 w=1 nf=1 m=1
M13 net6 VB2 VDD VDD pch l=0.15 w=1 nf=1 m=1
M14 VX EAO net6 VDD pch l=0.15 w=1 nf=1 m=1
M15 VX VX VSS VSS nch l=0.15 w=1 nf=1 m=1
M16 GATE VX VSS VSS nch l=0.15 w=1 nf=1 m=1
M17 net7 EAO IB VSS nch l=0.15 w=1 nf=1 m=1
M18 VDD net6 GATE VSS nch l=0.15 w=1 nf=1 m=1
M19 net7 net7 VDD VDD pch l=0.15 w=1 nf=1 m=1
M2 net3 net3 VDD VDD pch l=0.15 w=1 nf=1 m=1
M20 GATE net7 VDD VDD pch l=0.15 w=1 nf=1 m=1
M21 VSS IB GATE VDD pch l=0.15 w=1 nf=1 m=1
M22 VB1 net0 VSS VSS nch l=0.15 w=1 nf=1 m=1
M23 net0 net0 VSS VSS nch l=0.15 w=1 nf=1 m=1
M24 net5 net0 VSS VSS nch l=0.15 w=1 nf=1 m=1
M25 net0 net5 VDD VDD pch l=0.15 w=1 nf=1 m=1
M3 net2 VREF VX VSS nch l=0.15 w=1 nf=1 m=1
M4 net3 FB VX VSS nch l=0.15 w=1 nf=1 m=1
M5 net4 net4 VSS VSS nch l=0.15 w=1 nf=1 m=1
M6 EAO net4 VSS VSS nch l=0.15 w=1 nf=1 m=1
M7 VX VB3 VSS VSS nch l=0.15 w=1 nf=1 m=1
M8 VB3 VB3 VSS VSS nch l=0.15 w=1 nf=1 m=1
M9 VB3 VB1 VDD VDD pch l=0.15 w=1 nf=1 m=1
MNP VIN GATE VOUT VSS nch l=0.15 w=1 nf=1 m=1
R1 FB VSS 1k
R2 VOUT FB 1k
R3 VDD net0 1k
R4 VDD net5 1k
R5 net1 VSS 1k
RL VOUT VSS 1k
.ends dut
