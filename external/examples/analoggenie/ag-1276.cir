* official Analog Canvas netlist; PDK X cards rewritten by convert.py
.model nch nmos
.model pch pmos

.subckt EA1 VDD VSS VFP1 VREF VCTRL VX3
MN1 net2 VFP1 net1 VSS nch l=0.15 w=1 nf=1 m=1
MN10 net0 VB2 VSS VSS nch l=0.15 w=1 nf=1 m=1
MN11 VB2 VB2 VSS VSS nch l=0.15 w=1 nf=1 m=1
MN2 VX3 VREF net1 VSS nch l=0.15 w=1 nf=1 m=1
MN3 VD VD VSS VSS nch l=0.15 w=1 nf=1 m=1
MN4 net1 VBN VSS VSS nch l=0.15 w=1 nf=1 m=1
MN5 VCTRL VD VSS VSS nch l=0.15 w=1 nf=1 m=1
MN8 VB1 VBN VSS VSS nch l=0.15 w=1 nf=1 m=1
MN9 VBN VBN VSS VSS nch l=0.15 w=1 nf=1 m=1
MP1 net2 net2 VDD VDD pch l=0.15 w=1 nf=1 m=1
MP10 VBN net0 VDD VDD pch l=0.15 w=1 nf=1 m=1
MP11 net0 net0 VDD VDD pch l=0.15 w=1 nf=1 m=1
MP12 VB2 net0 VDD VDD pch l=0.15 w=1 nf=1 m=1
MP2 VX3 VX3 VDD VDD pch l=0.15 w=1 nf=1 m=1
MP3 VCTRL VX3 VDD VDD pch l=0.15 w=1 nf=1 m=1
MP8 VD net2 VDD VDD pch l=0.15 w=1 nf=1 m=1
MP9 VB1 VB1 VDD VDD pch l=0.15 w=1 nf=1 m=1
.ends EA1

.subckt dut VDD VSS VIN VP VS5 VS1 VS2 VS4 VS3 VB3 VREF
.model DIODE D(IS=1e-14 N=1)
CFLY VX1 VX2 1p
CO VP VN 1p
COP VP VSS 1p
D1 VN VX2 DIODE
L1 VX1 VX3 1n
M1 VX1 VS1 VIN VDD pch l=0.15 w=1 nf=1 m=1
M2 VX2 VS2 VIN VDD pch l=0.15 w=1 nf=1 m=1
M3 VP VS3 VX3 VDD pch l=0.15 w=1 nf=1 m=1
M4 VX3 VS4 VSS VSS nch l=0.15 w=1 nf=1 m=1
M5 net2 VS5 VIN VDD pch l=0.15 w=1 nf=1 m=1
MN12 net1 VB3 VSS VSS nch l=0.15 w=1 nf=1 m=1
MN6 net1 net1 VSS VSS nch l=0.15 w=1 nf=1 m=1
MN7 net0 net1 VSS VSS nch l=0.15 w=1 nf=1 m=1
MP4 net0 net0 net2 VDD pch l=0.15 w=1 nf=1 m=1
MP5 VX1 net0 net2 VDD pch l=0.15 w=1 nf=1 m=1
MP6 net1 VCTRL net2 VDD pch l=0.15 w=1 nf=1 m=1
R1 VP VFP1 1k
R2 VFP1 VSS 1k
X1 VDD VSS VFP1 VREF VCTRL VX3 EA1
.ends dut
