* official Analog Canvas netlist; PDK X cards rewritten by convert.py
.model nch nmos
.model pch pmos

.subckt EA VDD VSS VFP1 VREF VX3 VCTRL VX2
MN1 net4 VFP1 net0 VSS nch l=0.15 w=1 nf=1 m=1
MN2 VX3 VREF net0 VSS nch l=0.15 w=1 nf=1 m=1
MN3 net3 net3 VSS VSS nch l=0.15 w=1 nf=1 m=1
MN4 net0 VBN VSS VSS nch l=0.15 w=1 nf=1 m=1
MN5 net5 net5 VSS VSS nch l=0.15 w=1 nf=1 m=1
MN6 VCTRL net5 VSS VSS nch l=0.15 w=1 nf=1 m=1
MN7 net2 net3 VX2 VSS nch l=0.15 w=1 nf=1 m=1
MN8 VBN VBN VSS VSS nch l=0.15 w=1 nf=1 m=1
MN9 net1 VBN VSS VSS nch l=0.15 w=1 nf=1 m=1
MP1 net4 net4 VDD VDD pch l=0.15 w=1 nf=1 m=1
MP2 VX3 VX3 VDD VDD pch l=0.15 w=1 nf=1 m=1
MP3 net5 net4 VDD VDD pch l=0.15 w=1 nf=1 m=1
MP4 VCTRL VX3 VDD VDD pch l=0.15 w=1 nf=1 m=1
MP5 net3 net2 VDD VDD pch l=0.15 w=1 nf=1 m=1
MP6 net2 net2 VDD VDD pch l=0.15 w=1 nf=1 m=1
MP7 VBN net2 VDD VDD pch l=0.15 w=1 nf=1 m=1
MP8 net1 net1 VDD VDD pch l=0.15 w=1 nf=1 m=1
RBIAS VX2 VSS 1k
.ends EA

.subckt ISR VSS VS IOUT VCTRL VB3
MN10 net1 net1 VSS VSS nch l=0.15 w=1 nf=1 m=1
MN11 net1 VB3 VSS VSS nch l=0.15 w=1 nf=1 m=1
MN12 net0 net1 VSS VSS nch l=0.15 w=1 nf=1 m=1
MP10 net0 net0 VS VS pch l=0.15 w=1 nf=1 m=1
MP11 IOUT net0 VS VS pch l=0.15 w=1 nf=1 m=1
MP9 net1 VCTRL VS VS pch l=0.15 w=1 nf=1 m=1
.ends ISR

.subckt dut VDD VSS VIN VP VCONT1 VCONT2 VCONT3 VCONT4 VCONT5 VB3 VREF
.model DIODE D(IS=1e-14 N=1)
CFLY VX1 VX2 1p
CO VP VN 1p
COP VP VSS 1p
D1 VN VX2 DIODE
L1 VX1 VX3 1n
M1 VX1 VCONT2 VIN VIN pch l=0.15 w=1 nf=1 m=1
M2 VX2 VCONT3 VIN VIN pch l=0.15 w=1 nf=1 m=1
M3 VX3 VCONT4 VSS VSS nch l=0.15 w=1 nf=1 m=1
M4 VX3 VCONT5 VP VP pch l=0.15 w=1 nf=1 m=1
M5 net0 VCONT1 VIN VIN pch l=0.15 w=1 nf=1 m=1
R1 VP VFP1 1k
R2 VFP1 VSS 1k
X1 VSS net0 VX1 VCTRL VB3 ISR
X2 VDD VSS VFP1 VREF VX3 VCTRL VX2 EA
.ends dut
