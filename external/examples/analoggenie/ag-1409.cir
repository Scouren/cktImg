* official Analog Canvas netlist; PDK X cards rewritten by convert.py
.model nch nmos
.model pch pmos

.subckt dut VDD VSS VSTO VCONT1 VCONT2 VCONT3 VOUT VB1
CL VOUT VSS 1p
CSTO VSTO VSS 1p
LRX net1 VX 1n
M1 net0 net0 VDD VDD pch l=0.15 w=1 nf=1 m=1
M10 VB1 net2 VDD VDD pch l=0.15 w=1 nf=1 m=1
M11 net2 net2 VDD VDD pch l=0.15 w=1 nf=1 m=1
M12 VB2 net2 VDD VDD pch l=0.15 w=1 nf=1 m=1
M13 net2 VB1 VSS VSS nch l=0.15 w=1 nf=1 m=1
M14 net4 VB1 VSS VSS nch l=0.15 w=1 nf=1 m=1
M15 VB2 VB2 VSS VSS nch l=0.15 w=1 nf=1 m=1
M2 net3 net0 VDD VDD pch l=0.15 w=1 nf=1 m=1
M3 net3 net3 VSS VSS nch l=0.15 w=1 nf=1 m=1
M4 VG net3 VSS VSS nch l=0.15 w=1 nf=1 m=1
M5 net0 VX net5 VSS nch l=0.15 w=1 nf=1 m=1
M6 VG VG net5 VSS nch l=0.15 w=1 nf=1 m=1
M7 VG VG VDD VDD pch l=0.15 w=1 nf=1 m=1
M8 VG VG VDD VDD pch l=0.15 w=1 nf=1 m=1
M9 net5 VB2 VSS VSS nch l=0.15 w=1 nf=1 m=1
MN1 net1 VCONT2 VSS VSS nch l=0.15 w=1 nf=1 m=1
MN2 VX VCONT3 VSS VSS nch l=0.15 w=1 nf=1 m=1
MP2 VX VG VOUT VDD pch l=0.15 w=1 nf=1 m=1
MP3 net1 VCONT1 VSTO VDD pch l=0.15 w=1 nf=1 m=1
R1 VB1 net4 1k
.ends dut
