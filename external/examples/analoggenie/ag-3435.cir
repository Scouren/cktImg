* official Analog Canvas netlist; PDK X cards rewritten by convert.py
.model nch nmos
.model pch pmos

.subckt dut VDD VSS vci phi1 phi2 vco
C1 net10 net7 1p
C2 net9 vco 1p
M1 vci phi1 net10 VSS nch l=0.15 w=1 nf=1 m=1
M10 net4 net0 VSS VSS nch l=0.15 w=1 nf=1 m=1
M11 net6 net0 VSS VSS nch l=0.15 w=1 nf=1 m=1
M12 VB2 VB2 VDD VDD pch l=0.15 w=1 nf=1 m=1
M13 VB2 net3 VSS VSS nch l=0.15 w=1 nf=1 m=1
M14 net3 VB1 VDD VDD pch l=0.15 w=1 nf=1 m=1
M15 net3 net3 VSS VSS nch l=0.15 w=1 nf=1 m=1
M16 VB1 VB1 VDD VDD pch l=0.15 w=1 nf=1 m=1
M17 VB1 net11 VSS VSS nch l=0.15 w=1 nf=1 m=1
M18 net1 VB1 VDD VDD pch l=0.15 w=1 nf=1 m=1
M19 net1 net1 net11 VSS nch l=0.15 w=1 nf=1 m=1
M2 net10 phi2 VSS VSS nch l=0.15 w=1 nf=1 m=1
M20 net11 net1 net5 VSS nch l=0.15 w=1 nf=1 m=1
M21 net5 net2 net3 VSS nch l=0.15 w=1 nf=1 m=1
M22 net2 VB1 VDD VDD pch l=0.15 w=1 nf=1 m=1
M23 net2 net2 net5 VSS nch l=0.15 w=1 nf=1 m=1
M3 net7 phi1 VSS VSS nch l=0.15 w=1 nf=1 m=1
M4 net7 phi2 net9 VSS nch l=0.15 w=1 nf=1 m=1
M5 vco net9 net8 VDD pch l=0.15 w=1 nf=1 m=1
M6 net0 VSS net8 VDD pch l=0.15 w=1 nf=1 m=1
M7 net8 VB2 VDD VDD pch l=0.15 w=1 nf=1 m=1
M8 vco VB3 net4 VSS nch l=0.15 w=1 nf=1 m=1
M9 net0 VB3 net6 VSS nch l=0.15 w=1 nf=1 m=1
.ends dut
