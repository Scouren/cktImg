* official Analog Canvas netlist; PDK X cards rewritten by convert.py
.model nch nmos
.model pch pmos

.subckt bias VDD VSS VB6
M22 VB6 VB7 VDD VDD pch l=0.15 w=1 nf=1 m=1
M23 VB6 VB6 net1 VSS nch l=0.15 w=1 nf=1 m=1
M24 net1 VB6 VSS VSS nch l=0.15 w=1 nf=1 m=1
M25 net3 VB7 VDD VDD pch l=0.15 w=1 nf=1 m=1
M26 net3 net3 net4 VSS nch l=0.15 w=1 nf=1 m=1
M27 net4 net3 net0 VSS nch l=0.15 w=1 nf=1 m=1
M28 VB7 VB7 VDD VDD pch l=0.15 w=1 nf=1 m=1
M29 VB7 net4 VSS VSS nch l=0.15 w=1 nf=1 m=1
M30 net2 VB7 VDD VDD pch l=0.15 w=1 nf=1 m=1
M31 net2 net2 net0 VSS nch l=0.15 w=1 nf=1 m=1
M32 net0 net2 net5 VSS nch l=0.15 w=1 nf=1 m=1
M33 net5 VB7 VDD VDD pch l=0.15 w=1 nf=1 m=1
M34 net5 net5 VSS VSS nch l=0.15 w=1 nf=1 m=1
.ends bias

.subckt dut VDD VSS VREF VB1 VB5 IBUF VIN VOUT
CL VOUT net4 1p
M10 EAO VB3 VY VDD pch l=0.15 w=1 nf=1 m=1
M11 net2 VX VDD VDD pch l=0.15 w=1 nf=1 m=1
M12 VY VX VDD VDD pch l=0.15 w=1 nf=1 m=1
M13 net1 VB5 VDD VDD pch l=0.15 w=1 nf=1 m=1
M14 VX EAO net1 VDD pch l=0.15 w=1 nf=1 m=1
M15 VX VX VSS VSS nch l=0.15 w=1 nf=1 m=1
M16 GATE VX VSS VSS nch l=0.15 w=1 nf=1 m=1
M17 VDD net1 GATE VSS nch l=0.15 w=1 nf=1 m=1
M18 VY EAO IBUF VSS nch l=0.15 w=1 nf=1 m=1
M19 VY VY VDD VDD pch l=0.15 w=1 nf=1 m=1
M2 net5 VB1 VDD VDD pch l=0.15 w=1 nf=1 m=1
M20 GATE VY VDD VDD pch l=0.15 w=1 nf=1 m=1
M21 VSS IBUF GATE VDD pch l=0.15 w=1 nf=1 m=1
M3 net3 VREF net5 VDD pch l=0.15 w=1 nf=1 m=1
M4 net0 FB net5 VDD pch l=0.15 w=1 nf=1 m=1
M5 net3 VB2 VSS VSS nch l=0.15 w=1 nf=1 m=1
M6 net0 VB2 VSS VSS nch l=0.15 w=1 nf=1 m=1
M7 VX VB6 net3 VSS nch l=0.15 w=1 nf=1 m=1
M8 EAO VB6 net0 VSS nch l=0.15 w=1 nf=1 m=1
M9 VX VB3 net2 VDD pch l=0.15 w=1 nf=1 m=1
MNP VIN GATE VOUT VSS nch l=0.15 w=1 nf=1 m=1
R1 FB VSS 1k
R2 VOUT FB 1k
R3 net4 VSS 1k
RL VOUT VSS 1k
X1 VDD VSS VB6 bias
.ends dut
