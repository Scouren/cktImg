* official Analog Canvas netlist; PDK X cards rewritten by convert.py
.model nch nmos
.model pch pmos

.subckt dut VDD VSS Vin Vout Vb2 Vb1
M1 Vout Vb1 net0 VSS nch l=0.15 w=1 nf=1 m=1
M2 Vout Vb2 VDD VDD pch l=0.15 w=1 nf=1 m=1
RS Vin net0 1k
.ends dut
