* official Analog Canvas netlist; PDK X cards rewritten by convert.py
.model nch nmos
.model pch pmos

.subckt dut VDD VSS VB1 VREF IBUF VB2 VIN VOUT
CL VOUT net6 1p
M1 net3 net3 VDD VDD pch l=0.15 w=1 nf=1 m=1
M13 net4 VB2 VDD VDD pch l=0.15 w=1 nf=1 m=1
M14 VX EAO net4 VDD pch l=0.15 w=1 nf=1 m=1
M15 VX VX VSS VSS nch l=0.15 w=1 nf=1 m=1
M16 GATE VX VSS VSS nch l=0.15 w=1 nf=1 m=1
M17 VDD net4 GATE VSS nch l=0.15 w=1 nf=1 m=1
M18 net0 EAO IBUF IBUF nch l=0.15 w=1 nf=1 m=1
M19 net0 net0 VDD VDD pch l=0.15 w=1 nf=1 m=1
M2 net2 net2 VDD VDD pch l=0.15 w=1 nf=1 m=1
M20 GATE net0 VDD VDD pch l=0.15 w=1 nf=1 m=1
M21 VSS IBUF GATE VSS pch l=0.15 w=1 nf=1 m=1
M22 net5 net7 VDD VDD pch l=0.15 w=1 nf=1 m=1
M23 net7 net7 VDD VDD pch l=0.15 w=1 nf=1 m=1
M24 VBN net7 VDD VDD pch l=0.15 w=1 nf=1 m=1
M25 net7 net5 VB1 VSS nch l=0.15 w=1 nf=1 m=1
M26 net5 VB1 VSS VSS nch l=0.15 w=1 nf=1 m=1
M27 VBN VBN VSS VSS nch l=0.15 w=1 nf=1 m=1
M3 net2 VREF VX VSS nch l=0.15 w=1 nf=1 m=1
M4 net3 FB VX VSS nch l=0.15 w=1 nf=1 m=1
M5 net1 net1 VSS VSS nch l=0.15 w=1 nf=1 m=1
M6 EAO net1 VSS VSS nch l=0.15 w=1 nf=1 m=1
M7 net1 net3 VDD VDD pch l=0.15 w=1 nf=1 m=1
M8 EAO net2 VDD VDD pch l=0.15 w=1 nf=1 m=1
M9 VX VBN VSS VSS nch l=0.15 w=1 nf=1 m=1
MNP VIN GATE VOUT VOUT nch l=0.15 w=1 nf=1 m=1
R1 FB VSS 1k
R2 VOUT FB 1k
R3 VB1 VSS 1k
R4 net6 VSS 1k
RL VOUT VSS 1k
.ends dut
