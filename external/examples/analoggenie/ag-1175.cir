* official Analog Canvas netlist; PDK X cards rewritten by convert.py
.model nch nmos
.model pch pmos

.subckt dut VDD VSS V- V+ Vc Vb
C1 Vc V- 1p
C2 Vc V+ 1p
L1 net1 V- 1n
L2 V+ net1 1n
M1 V- V+ VDD VDD pch l=0.15 w=1 nf=1 m=1
M2 V+ V- VDD VDD pch l=0.15 w=1 nf=1 m=1
M3 V+ V- net0 VSS nch l=0.15 w=1 nf=1 m=1
M4 V- V+ net0 VSS nch l=0.15 w=1 nf=1 m=1
M5 net0 Vb VSS VSS nch l=0.15 w=1 nf=1 m=1
.ends dut
