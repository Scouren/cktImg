* official Analog Canvas netlist; PDK X cards rewritten by convert.py
.model nch nmos
.model pch pmos

.subckt dut VDD VSS VCONT1 VIN VCONT2 VCONT3 VCONT5 VP VREF
.model DIODE D(IS=1e-14 N=1)
CFLY VX1 VX2 1p
CO VP VN 1p
COP VP VSS 1p
D1 VN VX2 DIODE
L1 VX1 VX3 1n
M1 net7 VCONT1 VIN VDD pch l=0.15 w=1 nf=1 m=1
M2 VX1 VCONT2 VIN VDD pch l=0.15 w=1 nf=1 m=1
M3 VX2 VCONT3 VIN VDD pch l=0.15 w=1 nf=1 m=1
M4 VX3 VCONT4 VSS VSS nch l=0.15 w=1 nf=1 m=1
M5 VP VCONT5 VX3 VDD pch l=0.15 w=1 nf=1 m=1
MN1 net0 VFP1 net3 VSS nch l=0.15 w=1 nf=1 m=1
MN2 VCTRL VREF net3 VSS nch l=0.15 w=1 nf=1 m=1
MN3 net5 net5 VSS VSS nch l=0.15 w=1 nf=1 m=1
MN4 net3 net5 VSS VSS nch l=0.15 w=1 nf=1 m=1
MN5 net4 VB3 VSS VSS nch l=0.15 w=1 nf=1 m=1
MN6 net8 net4 VSS VSS nch l=0.15 w=1 nf=1 m=1
MN7 net4 net4 VSS VSS nch l=0.15 w=1 nf=1 m=1
MN8 net2 net6 VSS VSS nch l=0.15 w=1 nf=1 m=1
MN9 net1 net6 VSS VSS nch l=0.15 w=1 nf=1 m=1
MP1 net0 net0 VDD VDD pch l=0.15 w=1 nf=1 m=1
MP2 VCTRL net0 VDD VDD pch l=0.15 w=1 nf=1 m=1
MP3 net4 VCTRL net7 VDD pch l=0.15 w=1 nf=1 m=1
MP4 net8 net8 net7 VDD pch l=0.15 w=1 nf=1 m=1
MP5 VX1 net8 net7 VDD pch l=0.15 w=1 nf=1 m=1
MP6 net5 net2 VDD VDD pch l=0.15 w=1 nf=1 m=1
MP7 net2 net2 VDD VDD pch l=0.15 w=1 nf=1 m=1
MP8 net6 net2 VDD VDD pch l=0.15 w=1 nf=1 m=1
R1 VP VFP1 1k
R2 VFP1 VSS 1k
RBIAS net6 net1 1k
.ends dut
