* official Analog Canvas netlist; PDK X cards rewritten by convert.py
.model qnpn npn

.subckt dut VDD VSS IO
IB1 VDD net2 DC 1m
IB2 net3 VSS DC 1m
Ii net4 VSS DC 1m
Q1 net2 net4 VSS VSS qnpn m=1
Q2 VDD net2 net0 VSS qnpn m=1
Q3 VDD net2 net1 VSS qnpn m=1
Q4 net1 net1 net3 VSS qnpn m=1
Q5 net0 net0 net4 VSS qnpn m=1
Q6 IO net3 VSS VSS qnpn m=1
.ends dut
