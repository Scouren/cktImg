* official Analog Canvas netlist; PDK X cards rewritten by convert.py
.model nch nmos
.model pch pmos

.subckt bias VDD VSS VIN VBN
MB1 VBP1 VBP1 VIN VDD pch l=0.15 w=1 nf=1 m=1
MB10 net2 net1 VSS VSS nch l=0.15 w=1 nf=1 m=1
MB2 VBP1 VBN VSS VSS nch l=0.15 w=1 nf=1 m=1
MB3 VBN VBN VSS VSS nch l=0.15 w=1 nf=1 m=1
MB4 VBN net0 VIN VDD pch l=0.15 w=1 nf=1 m=1
MB5 net0 net0 VIN VDD pch l=0.15 w=1 nf=1 m=1
MB6 net0 net1 VSS VSS nch l=0.15 w=1 nf=1 m=1
MB7 VBP2 VBP2 VIN VDD pch l=0.15 w=1 nf=1 m=1
MB8 net2 VBP2 VIN VDD pch l=0.15 w=1 nf=1 m=1
MB9 VBP2 net2 net1 VSS nch l=0.15 w=1 nf=1 m=1
RB net1 VSS 1k
.ends bias

.subckt dut VDD VSS VIN VOUT VREF VB1 VB2 VB4
CF1 VOUT VFB 1p
Cm1 net2 VOUT 1p
Cm2 net2 net3 1p
M11 net6 VBN VSS VSS nch l=0.15 w=1 nf=1 m=1
M12 VY VFB net6 VSS nch l=0.15 w=1 nf=1 m=1
M13 VX VREF net6 VSS nch l=0.15 w=1 nf=1 m=1
M14 VX VX VIN VDD pch l=0.15 w=1 nf=1 m=1
M15 VY VY VIN VDD pch l=0.15 w=1 nf=1 m=1
M16 VX VB1 VIN VDD pch l=0.15 w=1 nf=1 m=1
M17 VX net2 VSS VSS nch l=0.15 w=1 nf=1 m=1
M18 VX VX VSS VSS nch l=0.15 w=1 nf=1 m=1
M19 net1 VX VIN VDD pch l=0.15 w=1 nf=1 m=1
M20 net2 VY VIN VDD pch l=0.15 w=1 nf=1 m=1
M21 net0 net2 VSS VSS nch l=0.15 w=1 nf=1 m=1
M22 net4 VX VSS VSS nch l=0.15 w=1 nf=1 m=1
M23 net0 net0 VIN VDD pch l=0.15 w=1 nf=1 m=1
M24 net4 net0 VIN VDD pch l=0.15 w=1 nf=1 m=1
M25 net1 net1 VSS VSS nch l=0.15 w=1 nf=1 m=1
M26 net2 net1 VSS VSS nch l=0.15 w=1 nf=1 m=1
MD1 net3 net2 VSS VSS nch l=0.15 w=1 nf=1 m=1
MD2 net7 VB2 VSS VSS nch l=0.15 w=1 nf=1 m=1
MD3 net5 net3 net7 VSS nch l=0.15 w=1 nf=1 m=1
MD4 VY VB4 net7 VSS nch l=0.15 w=1 nf=1 m=1
MD5 net3 VY VIN VDD pch l=0.15 w=1 nf=1 m=1
MD6 VY VY VIN VDD pch l=0.15 w=1 nf=1 m=1
MD7 net5 net5 VIN VDD pch l=0.15 w=1 nf=1 m=1
MPT VOUT net4 VIN VDD pch l=0.15 w=1 nf=1 m=1
RF1 VOUT VFB 1k
RF2 VFB VSS 1k
X1 VDD VSS VIN VBN bias
.ends dut
