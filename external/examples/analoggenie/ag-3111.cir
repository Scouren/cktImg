* official Analog Canvas netlist; PDK X cards rewritten by convert.py
.model nch nmos
.model pch pmos

.subckt opamp VDD VSS INN INP OUT
M10 VB4 VB4 VDD VDD pch l=0.15 w=1 nf=1 m=1
M11 net2 VB4 VDD VDD pch l=0.15 w=1 nf=1 m=1
M12 net4 VB4 VDD VDD pch l=0.15 w=1 nf=1 m=1
M13 VB2 VB4 VDD VDD pch l=0.15 w=1 nf=1 m=1
M14 VB3 VB4 VDD VDD pch l=0.15 w=1 nf=1 m=1
M15 VB4 net1 VSS VSS nch l=0.15 w=1 nf=1 m=1
M16 net2 net2 net1 VSS nch l=0.15 w=1 nf=1 m=1
M17 net1 net2 net0 VSS nch l=0.15 w=1 nf=1 m=1
M18 net4 net4 net0 VSS nch l=0.15 w=1 nf=1 m=1
M19 net0 net4 VB2 VSS nch l=0.15 w=1 nf=1 m=1
M20 VB2 VB2 VSS VSS nch l=0.15 w=1 nf=1 m=1
M21 VB3 VB3 net7 VSS nch l=0.15 w=1 nf=1 m=1
M22 net7 VB3 VSS VSS nch l=0.15 w=1 nf=1 m=1
M3 INN VB1 VDD VDD pch l=0.15 w=1 nf=1 m=1
M4 net3 INP INN VDD pch l=0.15 w=1 nf=1 m=1
M5 OUT INN INN VDD pch l=0.15 w=1 nf=1 m=1
M6 net3 VB3 net6 VSS nch l=0.15 w=1 nf=1 m=1
M7 OUT VB3 net5 VSS nch l=0.15 w=1 nf=1 m=1
M8 net6 net3 VSS VSS nch l=0.15 w=1 nf=1 m=1
M9 net5 net3 VSS VSS nch l=0.15 w=1 nf=1 m=1
.ends opamp

.subckt dut VDD VSS vci phi1 phi2 vco
C1 vcx VSS 1p
C2 net0 vco 1p
M1 vci phi1 vcx VSS nch l=0.15 w=1 nf=1 m=1
M2 vcx phi2 net0 VSS nch l=0.15 w=1 nf=1 m=1
X1 VDD VSS net0 VSS vco opamp
.ends dut
