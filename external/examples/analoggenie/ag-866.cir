* official Analog Canvas netlist; PDK X cards rewritten by convert.py
.model qnpn npn

.subckt dut VCC VSS IOUT
Q1 net0 net0 VSS VSS qnpn m=1
Q2 net0 net0 VSS VSS qnpn m=1
Q3 IOUT net0 VSS VSS qnpn m=1
Q4 IOUT net0 VSS VSS qnpn m=1
Q5 IOUT net0 VSS VSS qnpn m=1
R VCC net0 10kΩ
.ends dut
