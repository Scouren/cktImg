* official Analog Canvas netlist; PDK X cards rewritten by convert.py
.model nch nmos
.model pch pmos

.subckt EA1 VDD VSS INN INP VX3 OUT
M1 net2 net2 VDD VDD pch l=0.15 w=1 nf=1 m=1
M10 net1 net1 VSS VSS nch l=0.15 w=1 nf=1 m=1
M11 net5 net1 VSS VSS nch l=0.15 w=1 nf=1 m=1
M12 net4 net1 VSS VSS nch l=0.15 w=1 nf=1 m=1
M13 net4 net4 VDD VDD pch l=0.15 w=1 nf=1 m=1
M14 VBN net4 VDD VDD pch l=0.15 w=1 nf=1 m=1
M15 VBN VBN VSS VSS nch l=0.15 w=1 nf=1 m=1
M16 VB1 VB1 VDD VDD pch l=0.15 w=1 nf=1 m=1
M17 VB1 VBN VSS VSS nch l=0.15 w=1 nf=1 m=1
M2 VX3 VX3 VDD VDD pch l=0.15 w=1 nf=1 m=1
M3 net2 INN net0 VSS nch l=0.15 w=1 nf=1 m=1
M4 VX3 INP net0 VSS nch l=0.15 w=1 nf=1 m=1
M5 net0 VBN VSS VSS nch l=0.15 w=1 nf=1 m=1
M6 net3 net2 VDD VDD pch l=0.15 w=1 nf=1 m=1
M7 OUT VX3 VDD VDD pch l=0.15 w=1 nf=1 m=1
M8 net3 net3 VSS VSS nch l=0.15 w=1 nf=1 m=1
M9 OUT net3 VSS VSS nch l=0.15 w=1 nf=1 m=1
R1 VDD net5 1k
R2 net5 net1 1k
RF VDD net1 1k
.ends EA1

.subckt dut VDD VSS VIN VP VREF VB2 VCONT1 VCONT2 VCONT3 VCONT4 VCONT5
.model DIODE D(IS=1e-14 N=1)
CFLY net2 net6 1p
CO VP net4 1p
COP VP VSS 1p
D1 net4 net6 DIODE
L1 net2 VX3 1n
M1 net2 VCONT2 VIN VDD pch l=0.15 w=1 nf=1 m=1
M10 net3 net1 net0 VDD pch l=0.15 w=1 nf=1 m=1
M11 net3 VB2 VSS VSS nch l=0.15 w=1 nf=1 m=1
M2 net6 VCONT3 VIN VDD pch l=0.15 w=1 nf=1 m=1
M3 VX3 VCONT5 VP VDD pch l=0.15 w=1 nf=1 m=1
M4 VX3 VCONT4 VSS VSS nch l=0.15 w=1 nf=1 m=1
M5 net0 VCONT1 VIN VDD pch l=0.15 w=1 nf=1 m=1
M6 net2 net5 net0 VDD pch l=0.15 w=1 nf=1 m=1
M7 net5 net5 net0 VDD pch l=0.15 w=1 nf=1 m=1
M8 net5 net3 VSS VSS nch l=0.15 w=1 nf=1 m=1
M9 net3 net3 VSS VSS nch l=0.15 w=1 nf=1 m=1
R1 VP VFP1 1k
R2 VFP1 VSS 1k
X1 VDD VSS VFP1 VREF VX3 net1 EA1
.ends dut
