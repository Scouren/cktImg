* official Analog Canvas netlist; PDK X cards rewritten by convert.py
.model nch nmos
.model pch pmos

.subckt dut VDD VSS Vref VIN VOUT VB2 VB1
CL VOUT VX 1p
M1 net3 Vref net4 VSS nch l=0.15 w=1 nf=1 m=1
M10 VB4 VB4 VDD VDD pch l=0.15 w=1 nf=1 m=1
M11 VB2 VB4 VDD VDD pch l=0.15 w=1 nf=1 m=1
M12 net2 VB4 VDD VDD pch l=0.15 w=1 nf=1 m=1
M13 VB3 VB4 VDD VDD pch l=0.15 w=1 nf=1 m=1
M14 VB4 VB2 VB1 VSS nch l=0.15 w=1 nf=1 m=1
M15 VB2 VB1 VSS VSS nch l=0.15 w=1 nf=1 m=1
M16 VB1 net2 VSS VSS nch l=0.15 w=1 nf=1 m=1
M17 net2 net2 VSS VSS nch l=0.15 w=1 nf=1 m=1
M18 VB3 VB3 VSS VSS nch l=0.15 w=1 nf=1 m=1
M2 VX FB net4 VSS nch l=0.15 w=1 nf=1 m=1
M3 net3 net3 VDD VDD pch l=0.15 w=1 nf=1 m=1
M4 VX VX VDD VDD pch l=0.15 w=1 nf=1 m=1
M5 net0 net3 VDD VDD pch l=0.15 w=1 nf=1 m=1
M6 net1 VX VDD VDD pch l=0.15 w=1 nf=1 m=1
M7 net0 net1 VSS VSS nch l=0.15 w=1 nf=1 m=1
M8 net1 net1 VSS VSS nch l=0.15 w=1 nf=1 m=1
M9 net4 VB3 VSS VSS nch l=0.15 w=1 nf=1 m=1
MNP VIN net0 VOUT VOUT nch l=0.15 w=1 nf=1 m=1
R1 VOUT FB 1k
R2 FB VSS 1k
R3 VX VSS 1k
.ends dut
