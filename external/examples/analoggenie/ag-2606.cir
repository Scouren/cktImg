* official Analog Canvas netlist; PDK X cards rewritten by convert.py
.model nch nmos
.model pch pmos

.subckt opamp VDD VSS OUT INN INP
M10 net2 net3 VDD VDD pch l=0.15 w=1 nf=1 m=1
M11 OUT INN VDD VDD pch l=0.15 w=1 nf=1 m=1
M12 net5 VX VSS VSS nch l=0.15 w=1 nf=1 m=1
M13 net2 net2 VSS VSS nch l=0.15 w=1 nf=1 m=1
M14 VX net1 VDD VDD pch l=0.15 w=1 nf=1 m=1
M15 net1 net1 VDD VDD pch l=0.15 w=1 nf=1 m=1
M16 net4 net0 VDD VDD pch l=0.15 w=1 nf=1 m=1
M17 net0 net0 VDD VDD pch l=0.15 w=1 nf=1 m=1
M18 VX VX VSS VSS nch l=0.15 w=1 nf=1 m=1
M19 net1 net4 VSS VSS nch l=0.15 w=1 nf=1 m=1
M20 net4 net4 VSS VSS nch l=0.15 w=1 nf=1 m=1
M21 net0 net4 VSS VSS nch l=0.15 w=1 nf=1 m=1
M22 OUT net2 VSS VSS nch l=0.15 w=1 nf=1 m=1
M6 net3 INN net5 VSS nch l=0.15 w=1 nf=1 m=1
M7 INN INN VDD VDD pch l=0.15 w=1 nf=1 m=1
M8 net3 net3 VDD VDD pch l=0.15 w=1 nf=1 m=1
M9 INN INP net5 VSS nch l=0.15 w=1 nf=1 m=1
.ends opamp

.subckt dut VDD VSS biasp biascas biasn Vref Vout
C1 Vset VSS 1p
C2 n3 Vout 1p
M1 Vout n3 VDD VDD pch l=0.15 w=1 nf=1 m=1
M2 n1 Vset Vout VDD pch l=0.15 w=1 nf=1 m=1
M3 n1 biasn VSS VSS nch l=0.15 w=1 nf=1 m=1
M4 n3 biasp VDD VDD pch l=0.15 w=1 nf=1 m=1
M5 n3 biascas n1 VSS nch l=0.15 w=1 nf=1 m=1
R1 fb VSS 1k
R2 Vout fb 1k
X1 VDD VSS Vset fb Vref opamp
.ends dut
