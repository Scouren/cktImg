* official Analog Canvas netlist; PDK X cards rewritten by convert.py
.model nch nmos
.model pch pmos

.subckt dut VDD VSS VB2 VREF VB1 VOUT VIN VB4 VB6 VB5 VB3
CF1 VOUT VFB 1p
Cm1 VOUT V1 1p
Cm2 V1 V4 1p
M11 net9 VB2 VIN VDD pch l=0.15 w=1 nf=1 m=1
M12 net10 VFB net9 VDD pch l=0.15 w=1 nf=1 m=1
M13 V2 VREF net9 VDD pch l=0.15 w=1 nf=1 m=1
M14 V3 net10 VSS VSS nch l=0.15 w=1 nf=1 m=1
M15 net8 V2 VSS VSS nch l=0.15 w=1 nf=1 m=1
M16 V2 VB4 VIN VDD pch l=0.15 w=1 nf=1 m=1
M17 V2 V2 VSS VSS nch l=0.15 w=1 nf=1 m=1
M18 V2 V1 VSS VSS nch l=0.15 w=1 nf=1 m=1
M21 net13 V1 VSS VSS nch l=0.15 w=1 nf=1 m=1
M22 net2 V2 VSS VSS nch l=0.15 w=1 nf=1 m=1
M23 net13 net13 VIN VDD pch l=0.15 w=1 nf=1 m=1
M24 net2 net13 VIN VDD pch l=0.15 w=1 nf=1 m=1
M25 net10 VBN V3 VSS nch l=0.15 w=1 nf=1 m=1
M26 V2 VBN net8 VSS nch l=0.15 w=1 nf=1 m=1
M27 net5 V2 VSS VSS nch l=0.15 w=1 nf=1 m=1
M28 V1 VBN net5 VSS nch l=0.15 w=1 nf=1 m=1
M29 net0 net10 VSS VSS nch l=0.15 w=1 nf=1 m=1
M30 VX VBN net0 VSS nch l=0.15 w=1 nf=1 m=1
M31 net7 VX VIN VDD pch l=0.15 w=1 nf=1 m=1
M32 VX VB1 net7 VDD pch l=0.15 w=1 nf=1 m=1
M33 net3 VX VIN VDD pch l=0.15 w=1 nf=1 m=1
M34 V1 VB1 net3 VDD pch l=0.15 w=1 nf=1 m=1
M35 VBN VBP VIN VDD pch l=0.15 w=1 nf=1 m=1
M36 VBN VBN net12 VSS nch l=0.15 w=1 nf=1 m=1
M37 net12 VBN VSS VSS nch l=0.15 w=1 nf=1 m=1
M38 VBP VBP VIN VDD pch l=0.15 w=1 nf=1 m=1
M39 VBP VB3 net11 VSS nch l=0.15 w=1 nf=1 m=1
M40 net11 net1 VSS VSS nch l=0.15 w=1 nf=1 m=1
M41 net1 net1 VSS VSS nch l=0.15 w=1 nf=1 m=1
M42 net1 VBP VIN VDD pch l=0.15 w=1 nf=1 m=1
M43 VB3 VBP VIN VDD pch l=0.15 w=1 nf=1 m=1
M44 VB3 VB3 VSS VSS nch l=0.15 w=1 nf=1 m=1
MD1 V4 V1 VSS VSS nch l=0.15 w=1 nf=1 m=1
MD2 net4 VB5 VSS VSS nch l=0.15 w=1 nf=1 m=1
MD3 V3 V4 net4 VSS nch l=0.15 w=1 nf=1 m=1
MD4 net6 VB6 net4 VSS nch l=0.15 w=1 nf=1 m=1
MD5 V4 net6 VIN VDD pch l=0.15 w=1 nf=1 m=1
MD6 net6 net6 VIN VDD pch l=0.15 w=1 nf=1 m=1
MD7 V3 V3 VIN VDD pch l=0.15 w=1 nf=1 m=1
MPT VOUT net2 VIN VDD pch l=0.15 w=1 nf=1 m=1
RF1 VOUT VFB 1k
RF2 VFB VSS 1k
.ends dut
