* official Analog Canvas netlist; PDK X cards rewritten by convert.py
.model nch nmos

.subckt dut VDD VSS VIN1 VOUT1
M1 net0 VIN1 net1 VSS nch l=0.15 w=1 nf=1 m=1
M2 VOUT1 net0 VSS VSS nch l=0.15 w=1 nf=1 m=1
R1 VOUT1 net1 1k
R2 net1 VSS 1k
RD1 VDD net0 1k
RD2 VDD VOUT1 1k
.ends dut
