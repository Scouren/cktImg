* official Analog Canvas netlist; PDK X cards rewritten by convert.py
.model nch nmos
.model pch pmos

.subckt bias VDD VSS VBN
M1 net0 net0 VDD VDD pch l=0.15 w=1 nf=1 m=1
M2 VBN net0 VDD VDD pch l=0.15 w=1 nf=1 m=1
M23 net1 net0 VDD VDD pch l=0.15 w=1 nf=1 m=1
M24 VB2 net0 VDD VDD pch l=0.15 w=1 nf=1 m=1
M25 net0 VB2 VB1 VSS nch l=0.15 w=1 nf=1 m=1
M26 VB1 net1 VSS VSS nch l=0.15 w=1 nf=1 m=1
M27 net1 net1 VSS VSS nch l=0.15 w=1 nf=1 m=1
M28 VB2 VB1 VSS VSS nch l=0.15 w=1 nf=1 m=1
M29 VBN VBN VSS VSS nch l=0.15 w=1 nf=1 m=1
.ends bias

.subckt dut VDD VSS VB4 IBUF VIN VOUT
CL VOUT net5 1p
M10 net1 net1 VDD VDD pch l=0.15 w=1 nf=1 m=1
M11 net0 net2 VDD VDD pch l=0.15 w=1 nf=1 m=1
M12 EAO net1 VDD VDD pch l=0.15 w=1 nf=1 m=1
M13 net3 VB4 VDD VDD pch l=0.15 w=1 nf=1 m=1
M14 VX EAO net3 VDD pch l=0.15 w=1 nf=1 m=1
M15 VX VX VSS VSS nch l=0.15 w=1 nf=1 m=1
M16 GATE VX VSS VSS nch l=0.15 w=1 nf=1 m=1
M17 VDD net3 GATE VSS nch l=0.15 w=1 nf=1 m=1
M18 net4 EAO IBUF VSS nch l=0.15 w=1 nf=1 m=1
M19 net4 net4 VDD VDD pch l=0.15 w=1 nf=1 m=1
M20 GATE net4 VDD VDD pch l=0.15 w=1 nf=1 m=1
M21 VSS IBUF GATE VDD pch l=0.15 w=1 nf=1 m=1
M3 net1 VREF VX VSS nch l=0.15 w=1 nf=1 m=1
M4 net2 FB VX VSS nch l=0.15 w=1 nf=1 m=1
M6 VX VBN VSS VSS nch l=0.15 w=1 nf=1 m=1
M7 net0 net0 VSS VSS nch l=0.15 w=1 nf=1 m=1
M8 EAO net0 VSS VSS nch l=0.15 w=1 nf=1 m=1
M9 net2 net2 VDD VDD pch l=0.15 w=1 nf=1 m=1
MNP VIN GATE VOUT VSS nch l=0.15 w=1 nf=1 m=1
R1 FB VSS 1k
R2 VOUT FB 1k
RESR net5 VSS 1k
RL VOUT VSS 1k
X1 VDD VSS VBN bias
.ends dut
