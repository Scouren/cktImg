* official Analog Canvas netlist; PDK X cards rewritten by convert.py
.model nch nmos
.model pch pmos

.subckt icm_opamp_vdd_vss VDD VSS VIP VIN VOUT params: gain=1e6
Blin nlin 0 V={gain*(V(VIP)-V(VIN))}
Bcore VOUT 0 V={0.5*(V(VDD)+(0.5*(V(VSS)+V(nlin)+sqrt((V(nlin)-V(VSS))*(V(nlin)-V(VSS))+(1e-4*(V(VDD)-V(VSS)))*(1e-4*(V(VDD)-V(VSS)))+1e-12)))-sqrt((V(VDD)-(0.5*(V(VSS)+V(nlin)+sqrt((V(nlin)-V(VSS))*(V(nlin)-V(VSS))+(1e-4*(V(VDD)-V(VSS)))*(1e-4*(V(VDD)-V(VSS)))+1e-12))))*(V(VDD)-(0.5*(V(VSS)+V(nlin)+sqrt((V(nlin)-V(VSS))*(V(nlin)-V(VSS))+(1e-4*(V(VDD)-V(VSS)))*(1e-4*(V(VDD)-V(VSS)))+1e-12))))+(1e-4*(V(VDD)-V(VSS)))*(1e-4*(V(VDD)-V(VSS)))+1e-12))}
.ends icm_opamp_vdd_vss

.subckt dut VDD VSS GND BIAS V1 Vi Vo
M1 VDD net2 Vo VSS nch l=0.15 w=1 nf=1 m=1
M11 Vo net4 VDD VDD pch l=0.15 w=1 nf=1 m=1
M12 Vo net0 VSS VSS nch l=0.15 w=1 nf=1 m=1
M2 VSS net1 Vo VDD pch l=0.15 w=1 nf=1 m=1
M3 net2 BIAS VDD VDD pch l=0.15 w=1 nf=1 m=1
M4 net2 net2 V1 VSS nch l=0.15 w=1 nf=1 m=1
M5 net1 net1 V1 VDD pch l=0.15 w=1 nf=1 m=1
M6 net1 Vi VSS VSS nch l=0.15 w=1 nf=1 m=1
RL Vo GND 1k
VOS1 V1 net3 DC 1
VOS2 net5 V1 DC 1
X1 VDD VSS Vo net3 net4 icm_opamp_vdd_vss gain=1e6
X2 VDD VSS Vo net5 net0 icm_opamp_vdd_vss gain=1e6
.ends dut
