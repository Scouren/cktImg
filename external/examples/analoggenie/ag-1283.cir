* official Analog Canvas netlist; PDK X cards rewritten by convert.py
.model nch nmos
.model pch pmos

.subckt dut VDD VSS VIN VCONT1 VCONT2 VCONT3 VCONT4 VCONT5 VP VREF VB3 VB1
.model DIODE D(IS=1e-14 N=1)
CFLY VX1 VX2 1p
CO VP VN 1p
COP VP VSS 1p
D1 VN VX2 DIODE
L1 VX1 VX3 1n
M1 VS VCONT1 VIN VIN pch l=0.15 w=1 nf=1 m=1
M2 VX1 VCONT2 VIN VIN pch l=0.15 w=1 nf=1 m=1
M3 VX2 VCONT3 VIN VIN pch l=0.15 w=1 nf=1 m=1
M4 VX3 VCONT4 VSS VSS nch l=0.15 w=1 nf=1 m=1
M5 VX3 VCONT5 VP VP pch l=0.15 w=1 nf=1 m=1
MB1 VB1 VB1 VDD VDD pch l=0.15 w=1 nf=1 m=1
MB10 VS VS VSS VSS nch l=0.15 w=1 nf=1 m=1
MB11 VX2 VS VSS VSS nch l=0.15 w=1 nf=1 m=1
MB2 VB1 VBN VSS VSS nch l=0.15 w=1 nf=1 m=1
MB3 VBN VBP VDD VDD pch l=0.15 w=1 nf=1 m=1
MB4 VBN VBN VSS VSS nch l=0.15 w=1 nf=1 m=1
MB5 VBP VBP VDD VDD pch l=0.15 w=1 nf=1 m=1
MB6 VBP VB2 VX2 VSS nch l=0.15 w=1 nf=1 m=1
MB7 VB2 VB2 VSS VSS nch l=0.15 w=1 nf=1 m=1
MB8 VB2 VBP VDD VDD pch l=0.15 w=1 nf=1 m=1
MB9 VS VBP VDD VDD pch l=0.15 w=1 nf=1 m=1
MN1 net3 VFP1 net0 VSS nch l=0.15 w=1 nf=1 m=1
MN2 VX3 VREF net0 VSS nch l=0.15 w=1 nf=1 m=1
MN3 net0 VBN VSS VSS nch l=0.15 w=1 nf=1 m=1
MN4 net2 net2 VSS VSS nch l=0.15 w=1 nf=1 m=1
MN5 VCTRL net2 VSS VSS nch l=0.15 w=1 nf=1 m=1
MN6 net4 net4 VSS VSS nch l=0.15 w=1 nf=1 m=1
MN7 net1 net4 VSS VSS nch l=0.15 w=1 nf=1 m=1
MN8 net4 VB3 VSS VSS nch l=0.15 w=1 nf=1 m=1
MP1 net2 net3 VDD VDD pch l=0.15 w=1 nf=1 m=1
MP2 net3 net3 VDD VDD pch l=0.15 w=1 nf=1 m=1
MP3 VX3 VX3 VDD VDD pch l=0.15 w=1 nf=1 m=1
MP4 VCTRL VX3 VDD VDD pch l=0.15 w=1 nf=1 m=1
MP5 net4 VCTRL VS VS pch l=0.15 w=1 nf=1 m=1
MP6 net1 net1 VS VS pch l=0.15 w=1 nf=1 m=1
MP7 VX1 net1 VS VS pch l=0.15 w=1 nf=1 m=1
R1 VP VFP1 1k
R2 VFP1 VSS 1k
.ends dut
