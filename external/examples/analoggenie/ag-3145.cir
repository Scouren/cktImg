* official Analog Canvas netlist; PDK X cards rewritten by convert.py
.model nch nmos
.model pch pmos

.subckt dut VDD VSS vci phi1 phi2 vco
C1 vcx VSS 1p
C2 VX vco 1p
M1 vci phi1 vcx VSS nch l=0.15 w=1 nf=1 m=1
M10 vco net3 VDD VDD pch l=0.15 w=1 nf=1 m=1
M11 vco net2 VSS VSS nch l=0.15 w=1 nf=1 m=1
M12 VB3 net0 VDD VDD pch l=0.15 w=1 nf=1 m=1
M13 VB3 VB3 VSS VSS nch l=0.15 w=1 nf=1 m=1
M14 net0 net0 VDD VDD pch l=0.15 w=1 nf=1 m=1
M15 net0 VB2 VSS VSS nch l=0.15 w=1 nf=1 m=1
M16 VB2 net0 VDD VDD pch l=0.15 w=1 nf=1 m=1
M17 VB2 VB2 VSS VSS nch l=0.15 w=1 nf=1 m=1
M18 VB1 VB1 VDD VDD pch l=0.15 w=1 nf=1 m=1
M19 VB1 VB3 VSS VSS nch l=0.15 w=1 nf=1 m=1
M2 vcx phi2 VX VSS nch l=0.15 w=1 nf=1 m=1
M3 VX net1 VDD VDD pch l=0.15 w=1 nf=1 m=1
M4 net3 net1 VDD VDD pch l=0.15 w=1 nf=1 m=1
M5 VX VX net4 VSS nch l=0.15 w=1 nf=1 m=1
M6 net3 VSS net4 VSS nch l=0.15 w=1 nf=1 m=1
M7 net4 VB3 VSS VSS nch l=0.15 w=1 nf=1 m=1
M8 net2 VX VDD VDD pch l=0.15 w=1 nf=1 m=1
M9 net2 net2 VSS VSS nch l=0.15 w=1 nf=1 m=1
.ends dut
