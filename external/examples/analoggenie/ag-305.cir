* official Analog Canvas netlist; PDK X cards rewritten by convert.py
.model nch nmos
.model pch pmos

.subckt dut VDD VSS Vout1 Vout2 VoutCM Vb4 Vb3 Vb2 Vb1
M1 net3 Vb4 VDD VDD pch l=0.15 w=1 nf=1 m=1
M2 net2 Vb4 VDD VDD pch l=0.15 w=1 nf=1 m=1
M3 Vout1 Vb3 net3 VDD pch l=0.15 w=1 nf=1 m=1
M4 Vout2 Vb3 net2 VDD pch l=0.15 w=1 nf=1 m=1
M5 Vout1 Vb2 net1 VSS nch l=0.15 w=1 nf=1 m=1
M6 Vout2 Vb2 net0 VSS nch l=0.15 w=1 nf=1 m=1
M7 net1 Vb1 VSS VSS nch l=0.15 w=1 nf=1 m=1
M8 net0 Vb1 VSS VSS nch l=0.15 w=1 nf=1 m=1
R1 Vout1 VoutCM 1k
R2 VoutCM Vout2 1k
.ends dut
