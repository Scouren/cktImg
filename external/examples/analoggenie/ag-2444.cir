* official Analog Canvas netlist; PDK X cards rewritten by convert.py
.model nch nmos
.model pch pmos

.subckt AEA VDD VSS VREF VBN OUT
M10 net1 VREF net2 VSS nch l=0.15 w=1 nf=1 m=1
M11 net0 OUT net2 VSS nch l=0.15 w=1 nf=1 m=1
M12 net2 VBN VSS VSS nch l=0.15 w=1 nf=1 m=1
M4 net1 net1 VDD VDD pch l=0.15 w=1 nf=1 m=1
M5 OUT net1 VDD VDD pch l=0.15 w=1 nf=1 m=1
M6 OUT net0 VDD VDD pch l=0.15 w=1 nf=1 m=1
M7 net0 net0 VDD VDD pch l=0.15 w=1 nf=1 m=1
M8 OUT OUT VSS VSS nch l=0.15 w=1 nf=1 m=1
M9 OUT OUT VSS VSS nch l=0.15 w=1 nf=1 m=1
.ends AEA

.subckt Bias_Circuit VDD VSS VBN
M13 net0 net0 VSS VSS nch l=0.15 w=1 nf=1 m=1
M14 net2 net0 VSS VSS nch l=0.15 w=1 nf=1 m=1
M15 net1 net0 VSS VSS nch l=0.15 w=1 nf=1 m=1
M16 net1 net1 VDD VDD pch l=0.15 w=1 nf=1 m=1
M17 VBN net1 VDD VDD pch l=0.15 w=1 nf=1 m=1
M18 VBN VBN VSS VSS nch l=0.15 w=1 nf=1 m=1
M19 net3 VBN VSS VSS nch l=0.15 w=1 nf=1 m=1
M20 net3 net3 VDD VDD pch l=0.15 w=1 nf=1 m=1
R1 VDD net0 1k
R2 VDD net2 1k
R3 net0 net2 1k
.ends Bias_Circuit

.subckt dut VDD VSS VIN VREF VOUT VERR
M1 net1 net2 VIN VDD pch l=0.15 w=1 nf=1 m=1
M2 net0 net0 net1 VDD pch l=0.15 w=1 nf=1 m=1
M3 net0 nb VSS VSS nch l=0.15 w=1 nf=1 m=1
MBIAS VERR nb VSS VSS nch l=0.15 w=1 nf=1 m=1
MCHG net5 pb VIN VDD pch l=0.15 w=1 nf=1 m=1
MCTRL VERR net0 VOUT VDD pch l=0.15 w=1 nf=1 m=1
MGEN net4 net4 VSS VSS nch l=0.15 w=1 nf=1 m=1
MINJ VERR net4 VSS VSS nch l=0.15 w=1 nf=1 m=1
MRES VOUT VERR VIN VDD pch l=0.15 w=1 nf=1 m=1
MSEN net4 net2 net5 VDD pch l=0.15 w=1 nf=1 m=1
X1 VDD VSS net3 Bias_Circuit
X2 VDD VSS VREF net3 net2 AEA
.ends dut
