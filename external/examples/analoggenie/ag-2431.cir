* official Analog Canvas netlist; PDK X cards rewritten by convert.py
.model nch nmos
.model pch pmos

.subckt bias VDD VSS NB
M19 NB net5 VDD VDD pch l=0.15 w=1 nf=1 m=1
M20 net5 net5 VDD VDD pch l=0.15 w=1 nf=1 m=1
M21 net4 VB2 VDD VDD pch l=0.15 w=1 nf=1 m=1
M22 net2 VB2 VDD VDD pch l=0.15 w=1 nf=1 m=1
M23 net1 VB2 VDD VDD pch l=0.15 w=1 nf=1 m=1
M24 VB2 VB2 VDD VDD pch l=0.15 w=1 nf=1 m=1
M25 NB NB VSS VSS nch l=0.15 w=1 nf=1 m=1
M26 net5 net4 VSS VSS nch l=0.15 w=1 nf=1 m=1
M27 net2 net2 net3 VSS nch l=0.15 w=1 nf=1 m=1
M28 net3 net2 net4 VSS nch l=0.15 w=1 nf=1 m=1
M29 net4 net4 VSS VSS nch l=0.15 w=1 nf=1 m=1
M30 net1 net1 net0 VSS nch l=0.15 w=1 nf=1 m=1
M31 net0 net1 net3 VSS nch l=0.15 w=1 nf=1 m=1
M32 VB2 net0 VSS VSS nch l=0.15 w=1 nf=1 m=1
.ends bias

.subckt ea VDD VSS VREF NB OUT
M10 net2 net2 VDD VDD pch l=0.15 w=1 nf=1 m=1
M11 OUT net2 VDD VDD pch l=0.15 w=1 nf=1 m=1
M12 OUT net0 VDD VDD pch l=0.15 w=1 nf=1 m=1
M13 net0 net0 VDD VDD pch l=0.15 w=1 nf=1 m=1
M14 OUT OUT VSS VSS nch l=0.15 w=1 nf=1 m=1
M15 OUT OUT VSS VSS nch l=0.15 w=1 nf=1 m=1
M16 net2 VREF net1 VSS nch l=0.15 w=1 nf=1 m=1
M17 net0 OUT net1 VSS nch l=0.15 w=1 nf=1 m=1
M18 net1 NB VSS VSS nch l=0.15 w=1 nf=1 m=1
.ends ea

.subckt dut VDD VSS VIN VREF pb nb VOUT VERR
M0 net5 net3 VIN VDD pch l=0.15 w=1 nf=1 m=1
M1 net2 net2 net5 VDD pch l=0.15 w=1 nf=1 m=1
M2 net2 nb VSS VSS nch l=0.15 w=1 nf=1 m=1
M3 net1 pb VIN VDD pch l=0.15 w=1 nf=1 m=1
M4 net4 net3 net1 VDD pch l=0.15 w=1 nf=1 m=1
M5 net4 net4 VSS VSS nch l=0.15 w=1 nf=1 m=1
M6 VOUT VERR VIN VDD pch l=0.15 w=1 nf=1 m=1
M7 VERR net2 VOUT VDD pch l=0.15 w=1 nf=1 m=1
M8 VERR nb VSS VSS nch l=0.15 w=1 nf=1 m=1
M9 VERR net4 VSS VSS nch l=0.15 w=1 nf=1 m=1
X1 VDD VSS VREF net0 net3 ea
X2 VDD VSS net0 bias
.ends dut
