* official Analog Canvas netlist; PDK X cards rewritten by convert.py
.model pch pmos
.model qnpn npn

.subckt Translinear O1 O2 C1 C2 I1 I2
.ends Translinear

.subckt dut VDD VSS GND Vin+ Vin- vo- vo+ Vc1 Vc2
C1 vo- GND 1p
C2 vo+ GND 1p
M1 net2 Vin+ VDD VDD pch l=0.15 w=1 nf=1 m=1
M2 vo- Vin+ VDD VDD pch l=0.15 w=1 nf=1 m=1
M3 vo+ Vin- VDD VDD pch l=0.15 w=1 nf=1 m=1
M4 net3 Vin- VDD VDD pch l=0.15 w=1 nf=1 m=1
Q5 net2 net2 VSS VSS qnpn m=1
Q6 net1 net2 VSS VSS qnpn m=1
Q7 net0 net3 VSS VSS qnpn m=1
Q8 net3 net3 VSS VSS qnpn m=1
X1 vo- vo+ Vc1 Vc2 net1 net0 Translinear
.ends dut
