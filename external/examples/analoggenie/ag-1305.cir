* official Analog Canvas netlist; PDK X cards rewritten by convert.py
.model nch nmos
.model pch pmos

.subckt dut VDD VSS VIN VP VS5 VS1 VS2 VS4 VS3 VB2 VREF VB1
.model DIODE D(IS=1e-14 N=1)
CFLY VX1 VX2 1p
CO VP VN 1p
COP VP VSS 1p
D1 VN VX2 DIODE
L1 VX1 VX3 1n
M1 VX1 VS1 VIN VDD pch l=0.15 w=1 nf=1 m=1
M2 VX2 VS2 VIN VDD pch l=0.15 w=1 nf=1 m=1
M3 VP VS3 VX3 VDD pch l=0.15 w=1 nf=1 m=1
M4 VX3 VS4 VSS VSS nch l=0.15 w=1 nf=1 m=1
M5 net2 VS5 VIN VDD pch l=0.15 w=1 nf=1 m=1
MN1 VA VA VSS VSS nch l=0.15 w=1 nf=1 m=1
MN10 net4 net4 VSS VSS nch l=0.15 w=1 nf=1 m=1
MN11 net3 net4 VSS VSS nch l=0.15 w=1 nf=1 m=1
MN12 net4 VB2 VSS VSS nch l=0.15 w=1 nf=1 m=1
MN2 VX2 VX2 VSS VSS nch l=0.15 w=1 nf=1 m=1
MN3 VEA VA VSS VSS nch l=0.15 w=1 nf=1 m=1
MN4 net0 VX2 VSS VSS nch l=0.15 w=1 nf=1 m=1
MN5 VBP VB1 VSS VSS nch l=0.15 w=1 nf=1 m=1
MN6 VB1 VB1 VSS VSS nch l=0.15 w=1 nf=1 m=1
MN7 net5 net1 VSS VSS nch l=0.15 w=1 nf=1 m=1
MN8 net1 net1 VSS VSS nch l=0.15 w=1 nf=1 m=1
MN9 VA net1 VSS VSS nch l=0.15 w=1 nf=1 m=1
MP1 VA VFP1 net6 VDD pch l=0.15 w=1 nf=1 m=1
MP10 VA VA VDD VDD pch l=0.15 w=1 nf=1 m=1
MP11 net4 VEA net2 VDD pch l=0.15 w=1 nf=1 m=1
MP12 net3 net3 net2 VDD pch l=0.15 w=1 nf=1 m=1
MP13 VX1 net3 net2 VDD pch l=0.15 w=1 nf=1 m=1
MP2 VX2 VREF net6 VDD pch l=0.15 w=1 nf=1 m=1
MP3 net6 VBP VDD VDD pch l=0.15 w=1 nf=1 m=1
MP4 net0 net0 VDD VDD pch l=0.15 w=1 nf=1 m=1
MP5 VEA net0 VDD VDD pch l=0.15 w=1 nf=1 m=1
MP6 VBP VBP VDD VDD pch l=0.15 w=1 nf=1 m=1
MP7 VB1 net5 VDD VDD pch l=0.15 w=1 nf=1 m=1
MP8 net5 net5 VDD VDD pch l=0.15 w=1 nf=1 m=1
MP9 net1 VA VDD VDD pch l=0.15 w=1 nf=1 m=1
R1 VP VFP1 1k
R2 VFP1 VSS 1k
RBIAS VDD net1 1k
.ends dut
