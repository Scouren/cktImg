* official Analog Canvas netlist; PDK X cards rewritten by convert.py
.model nch nmos
.model pch pmos

.subckt dut VDD VSS vin+ vin- vout
VB1 net5 net0 DC 1
I net4 net9 DC 1m
M1 net6 vin+ net0 VSS nch l=0.15 w=1 nf=1 m=1
M10 net9 net9 VSS VSS nch l=0.15 w=1 nf=1 m=1
M11 net4 net4 net1 VDD pch l=0.15 w=1 nf=1 m=1
M12 net1 net1 VDD VDD pch l=0.15 w=1 nf=1 m=1
M2 net7 vin- net0 VSS nch l=0.15 w=1 nf=1 m=1
M3 net8 net5 net6 VSS nch l=0.15 w=1 nf=1 m=1
M4 vout net5 net7 VSS nch l=0.15 w=1 nf=1 m=1
M5 net8 net4 net2 VDD pch l=0.15 w=1 nf=1 m=1
M6 vout net4 net3 VDD pch l=0.15 w=1 nf=1 m=1
M7 net2 net1 VDD VDD pch l=0.15 w=1 nf=1 m=1
M8 net3 net1 VDD VDD pch l=0.15 w=1 nf=1 m=1
M9 net0 net9 VSS VSS nch l=0.15 w=1 nf=1 m=1
.ends dut
