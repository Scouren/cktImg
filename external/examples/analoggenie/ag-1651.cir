* official Analog Canvas netlist; PDK X cards rewritten by convert.py
.model nch nmos
.model pch pmos
.model qpnp pnp

.subckt opamp VDD VSS INN INP OUT Z VB1 VB2
M0 net0 VB4 net1 VSS nch l=0.15 w=1 nf=1 m=1
M1 OUT VB4 Z VSS nch l=0.15 w=1 nf=1 m=1
M10 net4 net2 VSS VSS nch l=0.15 w=1 nf=1 m=1
M11 net1 VP VSS VSS nch l=0.15 w=1 nf=1 m=1
M12 Z net2 VSS VSS nch l=0.15 w=1 nf=1 m=1
M13 net3 net0 VDD VDD pch l=0.15 w=1 nf=1 m=1
M14 net9 net0 VDD VDD pch l=0.15 w=1 nf=1 m=1
M15 net10 net7 VDD VDD pch l=0.15 w=1 nf=1 m=1
M16 net7 net7 VDD VDD pch l=0.15 w=1 nf=1 m=1
M17 VB4 net7 VDD VDD pch l=0.15 w=1 nf=1 m=1
M18 net5 net10 VSS VSS nch l=0.15 w=1 nf=1 m=1
M19 net7 net10 VSS VSS nch l=0.15 w=1 nf=1 m=1
M2 net0 VB1 net3 VDD pch l=0.15 w=1 nf=1 m=1
M20 VB4 VB4 net8 VSS nch l=0.15 w=1 nf=1 m=1
M21 net8 VB4 VSS VSS nch l=0.15 w=1 nf=1 m=1
M3 OUT VB1 net9 VDD pch l=0.15 w=1 nf=1 m=1
M4 INN VP VSS VSS nch l=0.15 w=1 nf=1 m=1
M5 net6 VB2 VDD VDD pch l=0.15 w=1 nf=1 m=1
M6 VP INP net6 VDD pch l=0.15 w=1 nf=1 m=1
M7 net2 INN net6 VDD pch l=0.15 w=1 nf=1 m=1
M8 VP VB4 INN VSS nch l=0.15 w=1 nf=1 m=1
M9 net2 VB4 net4 VSS nch l=0.15 w=1 nf=1 m=1
R4 net10 net5 1k
.ends opamp

.subckt dut VDD VSS Vout VB1 VB2
Q1 VSS VSS Z qpnp m=1
Q2 Z Z net2 qpnp m=1
Q3 VSS VSS net0 qpnp m=1
Q4 net0 net0 net1 qpnp m=1
R1 Vout net2 1k
R2 Vout net3 1k
R3 net3 net1 1k
X1 VDD VSS net3 net2 Vout Z VB1 VB2 opamp
.ends dut
