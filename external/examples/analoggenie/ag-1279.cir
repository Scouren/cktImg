* official Analog Canvas netlist; PDK X cards rewritten by convert.py
.model nch nmos
.model pch pmos

.subckt EA VDD VSS INN INP OUT VX3
MN1 net1 INN net2 VSS nch l=0.15 w=1 nf=1 m=1
MN2 VX3 INP net2 VSS nch l=0.15 w=1 nf=1 m=1
MN3 net0 net0 VSS VSS nch l=0.15 w=1 nf=1 m=1
MN4 OUT net0 VSS VSS nch l=0.15 w=1 nf=1 m=1
MN5 net2 VBN VSS VSS nch l=0.15 w=1 nf=1 m=1
MN6 VBN VBN VSS VSS nch l=0.15 w=1 nf=1 m=1
MN7 VB1 VBN VSS VSS nch l=0.15 w=1 nf=1 m=1
MP1 net0 net1 VDD VDD pch l=0.15 w=1 nf=1 m=1
MP2 net1 net1 VDD VDD pch l=0.15 w=1 nf=1 m=1
MP3 VX3 VX3 VDD VDD pch l=0.15 w=1 nf=1 m=1
MP4 OUT VX3 VDD VDD pch l=0.15 w=1 nf=1 m=1
MP5 VBN net3 VDD VDD pch l=0.15 w=1 nf=1 m=1
MP6 net3 net3 net4 VDD pch l=0.15 w=1 nf=1 m=1
MP7 VB1 VB1 VDD VDD pch l=0.15 w=1 nf=1 m=1
RB1 VDD net4 1k
RB2 net3 VSS 1k
.ends EA

.subckt dut VDD VSS VCONT1 VB2 VCONT2 VCONT4 VCONT5 VP VCONT3 VIN VREF
.model DIODE D(IS=1e-14 N=1)
CFLY VX1 VX2 1p
CO VP VN 1p
COP VP VSS 1p
D1 VN VX2 DIODE
L1 VX1 VX3 1n
M1 VX1 VCONT2 VIN VDD pch l=0.15 w=1 nf=1 m=1
M2 VX2 VCONT3 VIN VDD pch l=0.15 w=1 nf=1 m=1
M3 VP VCONT5 VX3 VDD pch l=0.15 w=1 nf=1 m=1
M4 VX3 VCONT4 VSS VSS nch l=0.15 w=1 nf=1 m=1
M5 net2 VCONT1 VIN VDD pch l=0.15 w=1 nf=1 m=1
MN6 net0 net1 VSS VSS nch l=0.15 w=1 nf=1 m=1
MN7 net1 net1 VSS VSS nch l=0.15 w=1 nf=1 m=1
MN8 net1 VB2 VSS VSS nch l=0.15 w=1 nf=1 m=1
MP4 net0 net0 net2 VDD pch l=0.15 w=1 nf=1 m=1
MP5 VX1 net0 net2 VDD pch l=0.15 w=1 nf=1 m=1
MP6 net1 VCTRL net2 VDD pch l=0.15 w=1 nf=1 m=1
R1 VP VFP1 1k
R2 VFP1 VSS 1k
X1 VDD VSS VFP1 VREF VCTRL VX3 EA
.ends dut
