* official Analog Canvas netlist; PDK X cards rewritten by convert.py
.model nch nmos
.model pch pmos

.subckt opamp VDD VSS IN OUT
M1 VX net1 VDD VDD pch l=0.15 w=1 nf=1 m=1
M10 VB1 VB1 VDD VDD pch l=0.15 w=1 nf=1 m=1
M11 VB1 VB3 VSS VSS nch l=0.15 w=1 nf=1 m=1
M12 VB3 net0 VDD VDD pch l=0.15 w=1 nf=1 m=1
M13 VB3 VB3 VSS VSS nch l=0.15 w=1 nf=1 m=1
M14 net0 net0 VDD VDD pch l=0.15 w=1 nf=1 m=1
M15 net0 VB2 VSS VSS nch l=0.15 w=1 nf=1 m=1
M16 VB2 net0 VDD VDD pch l=0.15 w=1 nf=1 m=1
M17 VB2 VB2 VSS VSS nch l=0.15 w=1 nf=1 m=1
M2 net1 net1 VDD VDD pch l=0.15 w=1 nf=1 m=1
M3 OUT OUT VDD VDD pch l=0.15 w=1 nf=1 m=1
M4 OUT OUT VDD VDD pch l=0.15 w=1 nf=1 m=1
M5 VX VX VSS VSS nch l=0.15 w=1 nf=1 m=1
M6 net1 IN net2 VSS nch l=0.15 w=1 nf=1 m=1
M7 OUT OUT net2 VSS nch l=0.15 w=1 nf=1 m=1
M8 OUT VX VSS VSS nch l=0.15 w=1 nf=1 m=1
M9 net2 VB3 VSS VSS nch l=0.15 w=1 nf=1 m=1
.ends opamp

.subckt dut VDD VSS VSTO VCONT1 VCONT2 VCONT3 VOUT
CL VOUT VSS 1p
CSTO VSTO VSS 1p
LRX net2 net0 1n
MN1 net2 VCONT2 VSS VSS nch l=0.15 w=1 nf=1 m=1
MN2 net0 VCONT3 VSS VSS nch l=0.15 w=1 nf=1 m=1
MP2 net0 net1 VOUT VDD pch l=0.15 w=1 nf=1 m=1
MP3 net2 VCONT1 VSTO VDD pch l=0.15 w=1 nf=1 m=1
X1 VDD VSS net0 net1 opamp
.ends dut
