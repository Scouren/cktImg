* official Analog Canvas netlist; PDK X cards rewritten by convert.py
.model pch pmos
.model qpnp pnp

.subckt icm_opamp_vdd_vss VDD VSS VIP VIN VOUT params: gain=1e6
Blin nlin 0 V={gain*(V(VIP)-V(VIN))}
Bcore VOUT 0 V={0.5*(V(VDD)+(0.5*(V(VSS)+V(nlin)+sqrt((V(nlin)-V(VSS))*(V(nlin)-V(VSS))+(1e-4*(V(VDD)-V(VSS)))*(1e-4*(V(VDD)-V(VSS)))+1e-12)))-sqrt((V(VDD)-(0.5*(V(VSS)+V(nlin)+sqrt((V(nlin)-V(VSS))*(V(nlin)-V(VSS))+(1e-4*(V(VDD)-V(VSS)))*(1e-4*(V(VDD)-V(VSS)))+1e-12))))*(V(VDD)-(0.5*(V(VSS)+V(nlin)+sqrt((V(nlin)-V(VSS))*(V(nlin)-V(VSS))+(1e-4*(V(VDD)-V(VSS)))*(1e-4*(V(VDD)-V(VSS)))+1e-12))))+(1e-4*(V(VDD)-V(VSS)))*(1e-4*(V(VDD)-V(VSS)))+1e-12))}
.ends icm_opamp_vdd_vss

.subckt dut VDD VSS VREF
M1 net0 net5 VDD VDD pch l=0.15 w=1 nf=1 m=1
M2 net2 net5 VDD VDD pch l=0.15 w=1 nf=1 m=1
M3 net3 net5 VDD VDD pch l=0.15 w=1 nf=1 m=1
M4 net6 net5 VDD VDD pch l=0.15 w=1 nf=1 m=1
M5 VREF net5 VDD VDD pch l=0.15 w=1 nf=1 m=1
Q1a VSS VSS net3 qpnp m=1
Q1b VSS net3 net4 qpnp m=1
Q2a VSS VSS net0 qpnp m=1
Q2b VSS net0 net2 qpnp m=1
Q3 VSS VSS net1 qpnp m=1
R1 net6 net4 1k
R2 VREF net1 1k
X1 VDD VSS net2 net6 net5 icm_opamp_vdd_vss gain=1e6
.ends dut
