* official Analog Canvas netlist; PDK X cards rewritten by convert.py
.model pch pmos

.subckt dut VDD VSS vo
Ibias net2 VSS DC 1m
M1 net3 net1 VDD VDD pch l=0.15 w=1 nf=1 m=1
M2 net0 net1 VDD VDD pch l=0.15 w=1 nf=1 m=1
M3 net1 net2 net3 VDD pch l=0.15 w=1 nf=1 m=1
M4 vo net2 net0 VDD pch l=0.15 w=1 nf=1 m=1
R net1 net2 1k
.ends dut
