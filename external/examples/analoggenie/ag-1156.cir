* official Analog Canvas netlist; PDK X cards rewritten by convert.py
.model nch nmos
.model pch pmos

.subckt dut VDD33 VDD27 VSS Vtune
.model DIODE D(IS=1e-14 N=1)
C1 net5 net7 1p
C2 net6 net4 1p
D1 Vtune net2 DIODE
D2 Vtune net3 DIODE
IBIAS net0 VSS DC 1m
L1 net2 net1 1n
L2 net1 net3 1n
L3 net5 VSS 1n
L4 net6 VSS 1n
M1 net2 net3 VSS VSS nch l=0.15 w=1 nf=1 m=1
M2 net3 net2 VSS VSS nch l=0.15 w=1 nf=1 m=1
M3 net5 net2 VDD33 VDD33 pch l=0.15 w=1 nf=1 m=1
M4 net6 net3 VDD33 VDD33 pch l=0.15 w=1 nf=1 m=1
M5 net1 net0 VDD27 VDD33 pch l=0.15 w=1 nf=1 m=1
M6 net0 net0 VDD27 VDD33 pch l=0.15 w=1 nf=1 m=1
R1 net7 VSS 1k
R2 net4 VSS 50Ω
.ends dut
