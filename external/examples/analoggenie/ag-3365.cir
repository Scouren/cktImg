* official Analog Canvas netlist; PDK X cards rewritten by convert.py
.model nch nmos
.model pch pmos

.subckt opamp VDD VSS INN INP OUT
M10 OUT INP net0 VSS nch l=0.15 w=1 nf=1 m=1
M11 net0 VBN VSS VSS nch l=0.15 w=1 nf=1 m=1
M12 VBN VBP VDD VDD pch l=0.15 w=1 nf=1 m=1
M13 VB2 VBP VDD VDD pch l=0.15 w=1 nf=1 m=1
M14 VBP VBP VDD VDD pch l=0.15 w=1 nf=1 m=1
M15 net3 VBP VDD VDD pch l=0.15 w=1 nf=1 m=1
M16 VBN VBN VSS VSS nch l=0.15 w=1 nf=1 m=1
M17 VB2 VB1 VSS VSS nch l=0.15 w=1 nf=1 m=1
M18 VBP VB2 VB1 VSS nch l=0.15 w=1 nf=1 m=1
M19 VB1 net3 VSS VSS nch l=0.15 w=1 nf=1 m=1
M20 net3 net3 VSS VSS nch l=0.15 w=1 nf=1 m=1
M5 net1 net2 VDD VDD pch l=0.15 w=1 nf=1 m=1
M6 net4 net2 VDD VDD pch l=0.15 w=1 nf=1 m=1
M7 net2 VB3 net1 VDD pch l=0.15 w=1 nf=1 m=1
M8 OUT VB3 net4 VDD pch l=0.15 w=1 nf=1 m=1
M9 net2 INN net0 VSS nch l=0.15 w=1 nf=1 m=1
.ends opamp

.subckt dut VDD VSS vci phi1 phi2 vco
C1 net1 net0 1p
C2 net2 vco 1p
M1 vci phi1 net1 VSS nch l=0.15 w=1 nf=1 m=1
M2 net1 phi2 VSS VSS nch l=0.15 w=1 nf=1 m=1
M3 net0 phi1 VSS VSS nch l=0.15 w=1 nf=1 m=1
M4 net0 phi2 net2 VSS nch l=0.15 w=1 nf=1 m=1
X1 VDD VSS net2 VSS vco opamp
.ends dut
