* official Analog Canvas netlist; PDK X cards rewritten by convert.py
.model nch nmos
.model pch pmos

.subckt comparator VDD VSS INN OUT
M1 net6 VB1 VDD VDD pch l=0.15 w=1 nf=1 m=1
M10 net2 VB2 VSS VSS nch l=0.15 w=1 nf=1 m=1
M11 VY VB2 VSS VSS nch l=0.15 w=1 nf=1 m=1
M12 VB5 VX VDD VDD pch l=0.15 w=1 nf=1 m=1
M13 VB5 VB5 net4 VSS nch l=0.15 w=1 nf=1 m=1
M14 net4 VB5 VSS VSS nch l=0.15 w=1 nf=1 m=1
M15 VX VX VDD VDD pch l=0.15 w=1 nf=1 m=1
M16 VX VB4 VSS VSS nch l=0.15 w=1 nf=1 m=1
M17 VB4 VX VDD VDD pch l=0.15 w=1 nf=1 m=1
M18 net3 VB4 VSS VSS nch l=0.15 w=1 nf=1 m=1
M2 net2 INN net6 VDD pch l=0.15 w=1 nf=1 m=1
M3 VY OUT net6 VDD pch l=0.15 w=1 nf=1 m=1
M4 net5 net0 VDD VDD pch l=0.15 w=1 nf=1 m=1
M5 net1 net0 VDD VDD pch l=0.15 w=1 nf=1 m=1
M6 OUT VB3 net5 VDD pch l=0.15 w=1 nf=1 m=1
M7 net0 VB3 net1 VDD pch l=0.15 w=1 nf=1 m=1
M8 OUT VB5 net2 VSS nch l=0.15 w=1 nf=1 m=1
M9 net0 VB5 VY VSS nch l=0.15 w=1 nf=1 m=1
R1 VB4 net3 1k
.ends comparator

.subckt dut VDD VSS VSTO VCONT1 VCONT2 VCONT3 VOUT
CL VOUT VSS 1p
CSTO VSTO VSS 1p
LRX net2 net0 1n
MN1 net2 VCONT2 VSS VSS nch l=0.15 w=1 nf=1 m=1
MN2 net0 VCONT3 VSS VSS nch l=0.15 w=1 nf=1 m=1
MP2 net0 net1 VOUT VDD pch l=0.15 w=1 nf=1 m=1
MP3 net2 VCONT1 VSTO VDD pch l=0.15 w=1 nf=1 m=1
X1 VDD VSS net0 net1 comparator
.ends dut
