* official Analog Canvas netlist; PDK X cards rewritten by convert.py
.model nch nmos
.model pch pmos

.subckt dut VDD VSS VINP VINN VO
CC net2 VO 1p
IBIAS net1 VSS DC 1m
M1 net0 VINP net3 VDD pch l=0.15 w=1 nf=1 m=1
M2 net2 VINN net3 VDD pch l=0.15 w=1 nf=1 m=1
M3 net0 net0 VSS VSS nch l=0.15 w=1 nf=1 m=1
M4 net2 net0 VSS VSS nch l=0.15 w=1 nf=1 m=1
M5 net3 net1 VDD VDD pch l=0.15 w=1 nf=1 m=1
M6 VO net2 VSS VSS nch l=0.15 w=1 nf=1 m=1
M7 VO net1 VDD VDD pch l=0.15 w=1 nf=1 m=1
M8 net1 net1 VDD VDD pch l=0.15 w=1 nf=1 m=1
.ends dut
