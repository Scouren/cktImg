* official Analog Canvas netlist; PDK X cards rewritten by convert.py
.model nch nmos
.model pch pmos

.subckt dut VDD VSS VB3 Vref VIN VOUT
CL VOUT net10 1p
M1 net4 Vref VX VSS nch l=0.15 w=1 nf=1 m=1
M10 net7 net6 VSS VSS nch l=0.15 w=1 nf=1 m=1
M11 VX net8 VSS VSS nch l=0.15 w=1 nf=1 m=1
M12 VB4 VB4 VDD VDD pch l=0.15 w=1 nf=1 m=1
M13 VB4 net1 VSS VSS nch l=0.15 w=1 nf=1 m=1
M14 net5 VB4 VDD VDD pch l=0.15 w=1 nf=1 m=1
M15 net5 net5 net1 VSS nch l=0.15 w=1 nf=1 m=1
M16 net1 net5 net0 VSS nch l=0.15 w=1 nf=1 m=1
M17 net2 VB4 VDD VDD pch l=0.15 w=1 nf=1 m=1
M18 net2 net2 net0 VSS nch l=0.15 w=1 nf=1 m=1
M19 net0 net2 VB3 VSS nch l=0.15 w=1 nf=1 m=1
M2 net9 FB VX VSS nch l=0.15 w=1 nf=1 m=1
M20 VB3 VB4 VDD VDD pch l=0.15 w=1 nf=1 m=1
M21 VB3 VB3 VSS VSS nch l=0.15 w=1 nf=1 m=1
M22 VB5 VB4 VDD VDD pch l=0.15 w=1 nf=1 m=1
M23 VB5 VB5 net8 VSS nch l=0.15 w=1 nf=1 m=1
M24 net8 net8 VSS VSS nch l=0.15 w=1 nf=1 m=1
M3 net4 VB1 VDD VDD pch l=0.15 w=1 nf=1 m=1
M4 net9 VB1 VDD VDD pch l=0.15 w=1 nf=1 m=1
M5 VX VB2 net4 VDD pch l=0.15 w=1 nf=1 m=1
M6 net6 VB2 net9 VDD pch l=0.15 w=1 nf=1 m=1
M7 VX VB5 net3 VSS nch l=0.15 w=1 nf=1 m=1
M8 net6 VB5 net7 VSS nch l=0.15 w=1 nf=1 m=1
M9 net3 net6 VSS VSS nch l=0.15 w=1 nf=1 m=1
MNP VIN VX VOUT VSS nch l=0.15 w=1 nf=1 m=1
R1 VOUT FB 1k
R2 FB VSS 1k
R3 net10 VSS 1k
.ends dut
