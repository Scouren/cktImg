* official Analog Canvas netlist; PDK X cards rewritten by convert.py
.model nch nmos
.model pch pmos

.subckt comp VDD VSS IN OUT
M10 OUT OUT net2 VSS nch l=0.15 w=1 nf=1 m=1
M11 net2 VBN VSS VSS nch l=0.15 w=1 nf=1 m=1
M12 VX VX VSS VSS nch l=0.15 w=1 nf=1 m=1
M13 OUT VX VSS VSS nch l=0.15 w=1 nf=1 m=1
M14 net0 VBP VDD VDD pch l=0.15 w=1 nf=1 m=1
M15 VBP VBP VDD VDD pch l=0.15 w=1 nf=1 m=1
M16 VB2 VBP VDD VDD pch l=0.15 w=1 nf=1 m=1
M17 VBN VBP VDD VDD pch l=0.15 w=1 nf=1 m=1
M18 VB1 VB1 VDD VDD pch l=0.15 w=1 nf=1 m=1
M19 net0 net0 VSS VSS nch l=0.15 w=1 nf=1 m=1
M20 net1 net0 VSS VSS nch l=0.15 w=1 nf=1 m=1
M21 VBP VB2 net1 VSS nch l=0.15 w=1 nf=1 m=1
M22 VB2 VB2 VSS VSS nch l=0.15 w=1 nf=1 m=1
M23 VBN VBN VSS VSS nch l=0.15 w=1 nf=1 m=1
M24 VB1 VBN VSS VSS nch l=0.15 w=1 nf=1 m=1
M5 VX net3 VDD VDD pch l=0.15 w=1 nf=1 m=1
M6 net3 net3 VDD VDD pch l=0.15 w=1 nf=1 m=1
M7 OUT OUT VDD VDD pch l=0.15 w=1 nf=1 m=1
M8 OUT OUT VDD VDD pch l=0.15 w=1 nf=1 m=1
M9 net3 IN net2 VSS nch l=0.15 w=1 nf=1 m=1
.ends comp

.subckt dut VDD VSS VSTO VCONT1 VCONT2 VCONT3 VOUT
CL VOUT VSS 1p
CSTO VSTO VSS 1p
LRX net1 net2 1n
MN1 net1 VCONT2 VSS VSS nch l=0.15 w=1 nf=1 m=1
MN2 net2 VCONT3 VSS VSS nch l=0.15 w=1 nf=1 m=1
MP2 net2 net0 VOUT VDD pch l=0.15 w=1 nf=1 m=1
MP3 net1 VCONT1 VSTO VDD pch l=0.15 w=1 nf=1 m=1
X1 VDD VSS net2 net0 comp
.ends dut
