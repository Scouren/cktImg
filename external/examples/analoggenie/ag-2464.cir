* official Analog Canvas netlist; PDK X cards rewritten by convert.py
.model nch nmos
.model pch pmos

.subckt dut VIN VSS VREF VB2 VB4 VOUT VB1 VB3
CF1 VOUT VFB 1p
Cm1 net12 VOUT 1p
Cm2 net12 net15 1p
M11 net7 VB1 VIN VIN pch l=0.15 w=1 nf=1 m=1
M12 net11 VFB net7 net5 pch l=0.15 w=1 nf=1 m=1
M13 VX VREF net7 net5 pch l=0.15 w=1 nf=1 m=1
M14 VY net11 VSS VSS nch l=0.15 w=1 nf=1 m=1
M15 net9 VX VSS VSS nch l=0.15 w=1 nf=1 m=1
M16 VX VB3 VIN VIN pch l=0.15 w=1 nf=1 m=1
M17 VX VX VSS VSS nch l=0.15 w=1 nf=1 m=1
M18 VX net12 VSS VSS nch l=0.15 w=1 nf=1 m=1
M21 net6 net12 VSS VSS nch l=0.15 w=1 nf=1 m=1
M22 net3 VX VSS VSS nch l=0.15 w=1 nf=1 m=1
M23 net6 net6 VIN VIN pch l=0.15 w=1 nf=1 m=1
M24 net3 net6 VIN VIN pch l=0.15 w=1 nf=1 m=1
M25 net11 VB7 VY VSS nch l=0.15 w=1 nf=1 m=1
M26 VX VB7 net9 VSS nch l=0.15 w=1 nf=1 m=1
M27 net4 net11 VSS VSS nch l=0.15 w=1 nf=1 m=1
M28 net8 VB7 net4 VSS nch l=0.15 w=1 nf=1 m=1
M29 net2 VX VSS VSS nch l=0.15 w=1 nf=1 m=1
M30 net12 VB7 net2 VSS nch l=0.15 w=1 nf=1 m=1
M31 net14 net8 VIN VIN pch l=0.15 w=1 nf=1 m=1
M32 net17 net8 VIN VIN pch l=0.15 w=1 nf=1 m=1
M33 net12 VB5 net14 VIN pch l=0.15 w=1 nf=1 m=1
M34 net8 VB5 net17 VIN pch l=0.15 w=1 nf=1 m=1
M35 net10 VB7 VSS VSS nch l=0.15 w=1 nf=1 m=1
M36 VB7 VB7 net10 VSS nch l=0.15 w=1 nf=1 m=1
M37 VB7 net0 VIN VIN pch l=0.15 w=1 nf=1 m=1
M38 net0 net0 VIN VIN pch l=0.15 w=1 nf=1 m=1
M39 net1 net0 VIN VIN pch l=0.15 w=1 nf=1 m=1
M40 net1 VB6 VSS VSS nch l=0.15 w=1 nf=1 m=1
M41 net0 net1 VB6 VSS nch l=0.15 w=1 nf=1 m=1
MD1 net15 net12 VSS VSS nch l=0.15 w=1 nf=1 m=1
MD2 net13 VB2 VSS VSS nch l=0.15 w=1 nf=1 m=1
MD3 VY net15 net13 VSS nch l=0.15 w=1 nf=1 m=1
MD4 net16 VB4 net13 VSS nch l=0.15 w=1 nf=1 m=1
MD5 net15 net16 VIN VIN pch l=0.15 w=1 nf=1 m=1
MD6 net16 net16 VIN VIN pch l=0.15 w=1 nf=1 m=1
MD7 VY VY VIN VIN pch l=0.15 w=1 nf=1 m=1
MPT VOUT net3 VIN VIN pch l=0.15 w=1 nf=1 m=1
RB VB6 VSS 1k
RF1 VOUT VFB 1k
RF2 VFB VSS 1k
.ends dut
