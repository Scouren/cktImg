* official Analog Canvas netlist; PDK X cards rewritten by convert.py
.model nch nmos

.subckt dut VDD VSS vout- vout+ Vb vin+ vin-
CL1 VSS vout- 1p
CL2 VSS vout+ 1p
Ibias net4 VSS DC 1m
M1 net2 net0 net4 VSS nch l=0.15 w=1 nf=1 m=1
M2 net1 net3 net4 VSS nch l=0.15 w=1 nf=1 m=1
M3 vout- Vb net2 VSS nch l=0.15 w=1 nf=1 m=1
M4 vout+ Vb net1 VSS nch l=0.15 w=1 nf=1 m=1
RD1 VDD vout- 1k
RD2 VDD vout+ 1k
RS1 vin+ net0 1k
RS2 vin- net3 1k
.ends dut
