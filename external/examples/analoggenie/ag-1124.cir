* official Analog Canvas netlist; PDK X cards rewritten by convert.py
.model nch nmos
.model pch pmos

.subckt dut VDD VSS Vctrl a b c d
.model DIODE D(IS=1e-14 N=1)
Cb1 net3 c 1p
Cb2 net2 d 1p
Cb3 net0 b 1p
Cb4 net1 a 1p
Cg X Y 1p
D1 Vctrl a DIODE
D2 Vctrl b DIODE
D3 Vctrl c DIODE
D4 Vctrl d DIODE
L1 b a 1n
L2 d c 1n
M10 b a Y net2 nch l=0.15 w=1 nf=1 m=1
M11 c d Y net0 nch l=0.15 w=1 nf=1 m=1
M12 d c Y net1 nch l=0.15 w=1 nf=1 m=1
M13 a b X VDD pch l=0.15 w=1 nf=1 m=1
M14 b a X VDD pch l=0.15 w=1 nf=1 m=1
M15 c d X VDD pch l=0.15 w=1 nf=1 m=1
M16 d c X VDD pch l=0.15 w=1 nf=1 m=1
M9 a b Y net3 nch l=0.15 w=1 nf=1 m=1
R1 Y VSS 1k
R2 VDD X 1k
Rb1 net3 VSS 1k
Rb2 net2 VSS 1k
Rb3 net0 VSS 1k
Rb4 net1 VSS 1k
.ends dut
