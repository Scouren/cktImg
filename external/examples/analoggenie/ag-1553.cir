* official Analog Canvas netlist; PDK X cards rewritten by convert.py
.model nch nmos
.model pch pmos
.model qpnp pnp

.subckt opamp VDD VSS INN INP OUT VB1 VB2
M1 net6 INN net1 VSS nch l=0.15 w=1 nf=1 m=1
M10 VN1 VB1 net2 VDD pch l=0.15 w=1 nf=1 m=1
M11 OUT VB1 net5 VDD pch l=0.15 w=1 nf=1 m=1
M12 VN1 VB3 net8 VSS nch l=0.15 w=1 nf=1 m=1
M13 OUT VB3 net9 VSS nch l=0.15 w=1 nf=1 m=1
M14 net8 VN1 VSS VSS nch l=0.15 w=1 nf=1 m=1
M15 net9 VN1 VSS VSS nch l=0.15 w=1 nf=1 m=1
M16 net0 net0 VDD VDD pch l=0.15 w=1 nf=1 m=1
M17 VB3 net0 VDD VDD pch l=0.15 w=1 nf=1 m=1
M18 VB3 VB3 net7 VSS nch l=0.15 w=1 nf=1 m=1
M19 net7 VB3 VSS VSS nch l=0.15 w=1 nf=1 m=1
M2 net4 INP net1 VSS nch l=0.15 w=1 nf=1 m=1
M3 net1 VB2 VSS VSS nch l=0.15 w=1 nf=1 m=1
M4 net3 net6 VDD VDD pch l=0.15 w=1 nf=1 m=1
M5 net10 net4 VDD VDD pch l=0.15 w=1 nf=1 m=1
M6 net6 VB1 net3 VDD pch l=0.15 w=1 nf=1 m=1
M7 net4 VB1 net10 VDD pch l=0.15 w=1 nf=1 m=1
M8 net2 net6 VDD VDD pch l=0.15 w=1 nf=1 m=1
M9 net5 net4 VDD VDD pch l=0.15 w=1 nf=1 m=1
R4 net0 VSS 1k
.ends opamp

.subckt dut VDD VSS Vout VB1 VB2
Q1 VSS VSS X qpnp m=1
Q2 VSS VSS net0 qpnp m=1
R1 Vout X 1k
R2 Vout Y 1k
R3 Y net0 1k
X1 VDD VSS Y X Vout VB1 VB2 opamp
.ends dut
