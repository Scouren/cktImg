* official Analog Canvas netlist; PDK X cards rewritten by convert.py
.model nch nmos
.model pch pmos

.subckt dut VDD VSS Vin VLO VLO_bar D1 D2 D3 Voutp Voutn
I1 VDD net0 DC 5mA
M1 A VLO Vin VSS nch l=0.15 w=5 nf=1 m=1
M2 B VLO_bar Vin VSS nch l=0.15 w=5 nf=1 m=1
M3 Voutn A net0 net0 pch l=1.2 w=100 nf=1 m=1
M4 Voutp B net0 net0 pch l=1.2 w=100 nf=1 m=1
MG1 A D1 B VSS nch l=0.15 w=0.15 nf=1 m=1
MG2 A D2 B VSS nch l=0.15 w=0.2 nf=1 m=1
MG3 A D3 B VSS nch l=0.15 w=0.5 nf=1 m=1
R1 Voutn VSS 200Ω
R2 Voutp VSS 200Ω
.ends dut
