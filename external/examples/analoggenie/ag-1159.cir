* official Analog Canvas netlist; PDK X cards rewritten by convert.py
.model nch nmos

.subckt dut VDD VSS Vcont Vin1 Vin2 Vb
C1A net2 net3 1p
C1B net0 net1 1p
C2 net3 net1 1p
CVAR1 net2 Vcont 1p
CVAR2 net0 Vcont 1p
L1A VDD net2 1n
L1B VDD net0 1n
M0 net4 Vb VSS VSS nch l=0.15 w=1 nf=1 m=1
M1 net3 net1 net4 VSS nch l=0.15 w=1 nf=1 m=1
M2 net1 net3 net4 VSS nch l=0.15 w=1 nf=1 m=1
M3 net2 Vin1 net3 VSS nch l=0.15 w=1 nf=1 m=1
M4 net0 Vin2 net1 VSS nch l=0.15 w=1 nf=1 m=1
.ends dut
