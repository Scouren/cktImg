* official Analog Canvas netlist; PDK X cards rewritten by convert.py
.model nch nmos

.subckt dut VDD VSS
IREF VDD N DC 1m
M1 X N VSS VSS nch l=0.15 w=1 nf=1 m=1
M2 N N VSS VSS nch l=0.15 w=1 nf=1 m=1
M3 N X VSS VSS nch l=0.15 w=1 nf=1 m=1
VX X VSS DC 1
.ends dut
