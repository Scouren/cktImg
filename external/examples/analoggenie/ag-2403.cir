* official Analog Canvas netlist; PDK X cards rewritten by convert.py
.model nch nmos
.model pch pmos

.subckt dut VDD VSS VB1 VREF VB2 VB3 VIN VOUT VERR pb nb
M1 VX1 VEA VIN VDD pch l=0.15 w=1 nf=1 m=1
M10 VX4 VB2 VX3 VDD pch l=0.15 w=1 nf=1 m=1
M11 VEA VB6 VX2 VSS nch l=0.15 w=1 nf=1 m=1
M12 VX4 VB6 VX1 VSS nch l=0.15 w=1 nf=1 m=1
M13 VX2 VB7 VSS VSS nch l=0.15 w=1 nf=1 m=1
M14 VX1 VB7 VSS VSS nch l=0.15 w=1 nf=1 m=1
M15 VB7 VB7 VSS VSS nch l=0.15 w=1 nf=1 m=1
M16 VB6 VB8 VDD VDD pch l=0.15 w=1 nf=1 m=1
M17 VB6 VB6 VB7 VSS nch l=0.15 w=1 nf=1 m=1
M18 VB8 VB8 VDD VDD pch l=0.15 w=1 nf=1 m=1
M19 VB8 net1 VSS VSS nch l=0.15 w=1 nf=1 m=1
M2 VCTRL VCTRL VX1 VDD pch l=0.15 w=1 nf=1 m=1
M20 net3 VB8 VDD VDD pch l=0.15 w=1 nf=1 m=1
M21 net3 net3 net1 VSS nch l=0.15 w=1 nf=1 m=1
M22 net1 net3 net2 VSS nch l=0.15 w=1 nf=1 m=1
M23 net0 VB8 VDD VDD pch l=0.15 w=1 nf=1 m=1
M24 net0 net0 net2 VSS nch l=0.15 w=1 nf=1 m=1
M25 net2 net0 VB3 VSS nch l=0.15 w=1 nf=1 m=1
M26 VB3 VB8 VDD VDD pch l=0.15 w=1 nf=1 m=1
M27 VB3 VB3 VSS VSS nch l=0.15 w=1 nf=1 m=1
M3 VCTRL nb VSS VSS nch l=0.15 w=1 nf=1 m=1
M4 VCTRL VB1 VDD VDD pch l=0.15 w=1 nf=1 m=1
M5 net4 VX4 VDD VDD pch l=0.15 w=1 nf=1 m=1
M6 VX3 VX4 VDD VDD pch l=0.15 w=1 nf=1 m=1
M7 VX1 VREF VCTRL VDD pch l=0.15 w=1 nf=1 m=1
M8 VX2 VEA VCTRL VDD pch l=0.15 w=1 nf=1 m=1
M9 VEA VB2 net4 VDD pch l=0.15 w=1 nf=1 m=1
MBIAS VERR nb VSS VSS nch l=0.15 w=1 nf=1 m=1
MCHG VX2 pb VIN VDD pch l=0.15 w=1 nf=1 m=1
MCTRL VERR VCTRL VOUT VDD pch l=0.15 w=1 nf=1 m=1
MGEN VX3 VX3 VSS VSS nch l=0.15 w=1 nf=1 m=1
MINJ VERR VX3 VSS VSS nch l=0.15 w=1 nf=1 m=1
MRES VOUT VERR VIN VDD pch l=0.15 w=1 nf=1 m=1
MSEN VX3 VEA VX2 VDD pch l=0.15 w=1 nf=1 m=1
.ends dut
