* official Analog Canvas netlist; PDK X cards rewritten by convert.py
.model nch nmos

.subckt dut VDD VSS Vin1 Vin2 Vcont1 Vcont2 Vout1 Vout2
IT net1 VSS DC 1m
M1 Vout1 Vin1 P VSS nch l=0.15 w=1 nf=1 m=1
M2 Vout2 Vin2 P VSS nch l=0.15 w=1 nf=1 m=1
M3 Vout1 Vout2 net0 VSS nch l=0.15 w=1 nf=1 m=1
M4 Vout2 Vout1 net0 VSS nch l=0.15 w=1 nf=1 m=1
M5 P Vcont1 net1 VSS nch l=0.15 w=1 nf=1 m=1
M6 net0 Vcont2 net1 VSS nch l=0.15 w=1 nf=1 m=1
R1 VDD Vout1 1k
R2 VDD Vout2 1k
.ends dut
