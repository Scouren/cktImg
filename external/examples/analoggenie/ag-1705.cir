* official Analog Canvas netlist; PDK X cards rewritten by convert.py
.model nch nmos
.model pch pmos
.model qpnp pnp

.subckt A1 VDD VSS OUT INP INN
M1 net3 INP net5 VSS nch l=0.15 w=1 nf=1 m=1
M10 VX VX VSS VSS nch l=0.15 w=1 nf=1 m=1
M11 VB2 net1 VDD VDD pch l=0.15 w=1 nf=1 m=1
M12 net1 net1 VDD VDD pch l=0.15 w=1 nf=1 m=1
M13 net1 net2 VSS VSS nch l=0.15 w=1 nf=1 m=1
M14 net2 net2 VSS VSS nch l=0.15 w=1 nf=1 m=1
M15 net2 net4 VDD VDD pch l=0.15 w=1 nf=1 m=1
M16 net4 net2 VSS VSS nch l=0.15 w=1 nf=1 m=1
M2 net0 INN net5 VSS nch l=0.15 w=1 nf=1 m=1
M3 net5 VB2 VSS VSS nch l=0.15 w=1 nf=1 m=1
M4 VB2 VB2 VSS VSS nch l=0.15 w=1 nf=1 m=1
M5 net3 net3 VDD VDD pch l=0.15 w=1 nf=1 m=1
M6 OUT net3 VDD VDD pch l=0.15 w=1 nf=1 m=1
M7 net0 net0 VDD VDD pch l=0.15 w=1 nf=1 m=1
M8 VX net0 VDD VDD pch l=0.15 w=1 nf=1 m=1
M9 OUT VX VSS VSS nch l=0.15 w=1 nf=1 m=1
R4 VDD net2 1k
R5 VDD net4 1k
.ends A1

.subckt dut VDD VSS Vout
Q1 VSS VSS net1 qpnp m=1
Q2 net1 net1 X qpnp m=1
Q3 VSS VSS net0 qpnp m=1
Q4 net0 net0 net2 qpnp m=1
R1 Vout X 1k
R2 Vout Y 1k
R3 Y net2 1k
X1 VDD VSS Vout X Y A1
.ends dut
