* official Analog Canvas netlist; PDK X cards rewritten by convert.py
.model nch nmos

.subckt dut VDD VSS Iin Vb Vout
I1 Vout VSS DC 1m
M1 net0 Vb Iin VSS nch l=0.15 w=1 nf=1 m=1
M2 VDD net0 Vout VSS nch l=0.15 w=1 nf=1 m=1
RD VDD net0 1k
.ends dut
