* official Analog Canvas netlist; PDK X cards rewritten by convert.py
.model nch nmos
.model pch pmos

.subckt dut VDD VSS VCONT1 VCONT2 VCONT3 VIN VCONT4 VCONT5 VP VB3 VB2 VREF
.model DIODE D(IS=1e-14 N=1)
CFLY VX1 VX2 1p
CO VP VN 1p
COP VP VSS 1p
D1 VN VX2 DIODE
L1 VX1 VX3 1n
M1 VX1 VCONT2 VIN VDD pch l=0.15 w=1 nf=1 m=1
M2 VX2 VCONT3 VIN VDD pch l=0.15 w=1 nf=1 m=1
M3 VP VCONT5 VX3 VDD pch l=0.15 w=1 nf=1 m=1
M4 VX3 VCONT4 VSS VSS nch l=0.15 w=1 nf=1 m=1
M5 VIN VCONT1 net1 VDD pch l=0.15 w=1 nf=1 m=1
MN1 net7 VX VSS VSS nch l=0.15 w=1 nf=1 m=1
MN10 VX VB4 VX1 VSS nch l=0.15 w=1 nf=1 m=1
MN11 VY VB4 net10 VSS nch l=0.15 w=1 nf=1 m=1
MN12 VB4 VB4 net6 VSS nch l=0.15 w=1 nf=1 m=1
MN13 net6 VB4 VSS VSS nch l=0.15 w=1 nf=1 m=1
MN2 net11 VY VSS VSS nch l=0.15 w=1 nf=1 m=1
MN3 VX1 VX VSS VSS nch l=0.15 w=1 nf=1 m=1
MN4 net10 VY VSS VSS nch l=0.15 w=1 nf=1 m=1
MN5 VCTRL VB4 net7 VSS nch l=0.15 w=1 nf=1 m=1
MN6 net3 net5 VSS VSS nch l=0.15 w=1 nf=1 m=1
MN7 net5 net5 VSS VSS nch l=0.15 w=1 nf=1 m=1
MN8 net5 VB3 VSS VSS nch l=0.15 w=1 nf=1 m=1
MN9 net4 VB4 net11 VSS nch l=0.15 w=1 nf=1 m=1
MP1 net8 net4 VDD VDD pch l=0.15 w=1 nf=1 m=1
MP10 VY VREF net2 VDD pch l=0.15 w=1 nf=1 m=1
MP11 net0 net0 VDD VDD pch l=0.15 w=1 nf=1 m=1
MP12 VB4 net0 VDD VDD pch l=0.15 w=1 nf=1 m=1
MP2 net9 net4 VDD VDD pch l=0.15 w=1 nf=1 m=1
MP3 VCTRL VB1 net8 VDD pch l=0.15 w=1 nf=1 m=1
MP4 net3 net3 net1 VDD pch l=0.15 w=1 nf=1 m=1
MP5 VX1 net3 net1 VDD pch l=0.15 w=1 nf=1 m=1
MP6 net5 VCTRL net1 VDD pch l=0.15 w=1 nf=1 m=1
MP7 net4 VB1 net9 VDD pch l=0.15 w=1 nf=1 m=1
MP8 net2 VB2 VDD VDD pch l=0.15 w=1 nf=1 m=1
MP9 VX VFP1 net2 VDD pch l=0.15 w=1 nf=1 m=1
R1 VP VFP1 1k
R2 VFP1 VSS 1k
RBIAS net0 VSS 1k
.ends dut
