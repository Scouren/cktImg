* official Analog Canvas netlist; PDK X cards rewritten by convert.py
.model nch nmos
.model pch pmos
.model qnpn npn

.subckt dut VDD VSS Vout VB1
M1 net0 net0 VDD VDD pch l=0.15 w=1 nf=1 m=1
M10 VB1 net3 VDD VDD pch l=0.15 w=1 nf=1 m=1
M11 net3 net3 VDD VDD pch l=0.15 w=1 nf=1 m=1
M12 VB2 net3 VDD VDD pch l=0.15 w=1 nf=1 m=1
M13 VB1 VB1 VSS VSS nch l=0.15 w=1 nf=1 m=1
M14 net3 VB1 VSS VSS nch l=0.15 w=1 nf=1 m=1
M15 VB2 VB2 VSS VSS nch l=0.15 w=1 nf=1 m=1
M2 net2 net2 VDD VDD pch l=0.15 w=1 nf=1 m=1
M3 net0 X net1 VSS nch l=0.15 w=1 nf=1 m=1
M4 net2 Y net1 VSS nch l=0.15 w=1 nf=1 m=1
M5 net1 VB2 VSS VSS nch l=0.15 w=1 nf=1 m=1
M6 Vout net0 VDD VDD pch l=0.15 w=1 nf=1 m=1
M7 Z net2 VDD VDD pch l=0.15 w=1 nf=1 m=1
M8 Vout Z VSS VSS nch l=0.15 w=1 nf=1 m=1
M9 Z Z VSS VSS nch l=0.15 w=1 nf=1 m=1
Q1 X X VSS VSS qnpn m=1
Q2 Z Z VSS VSS qnpn m=1
R1 Vout X 1k
R2 Vout Y 1k
R3 Y Z 1k
.ends dut
