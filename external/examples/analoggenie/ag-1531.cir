* official Analog Canvas netlist; PDK X cards rewritten by convert.py
.model nch nmos
.model pch pmos
.model qnpn npn

.subckt opamp VDD VSS INN INP OUT N
M1 net5 INN net7 VSS nch l=0.15 w=1 nf=1 m=1
M10 VB2 VB2 VDD VDD pch l=0.15 w=1 nf=1 m=1
M11 VB2 net6 VSS VSS nch l=0.15 w=1 nf=1 m=1
M12 net2 VB2 VDD VDD pch l=0.15 w=1 nf=1 m=1
M13 net2 net2 net6 VSS nch l=0.15 w=1 nf=1 m=1
M14 net6 net2 net1 VSS nch l=0.15 w=1 nf=1 m=1
M15 net3 VB2 VDD VDD pch l=0.15 w=1 nf=1 m=1
M16 net3 net3 net1 VSS nch l=0.15 w=1 nf=1 m=1
M17 net1 net3 net4 VSS nch l=0.15 w=1 nf=1 m=1
M18 net4 VB2 VDD VDD pch l=0.15 w=1 nf=1 m=1
M19 net4 net4 VSS VSS nch l=0.15 w=1 nf=1 m=1
M2 net0 INP net7 VSS nch l=0.15 w=1 nf=1 m=1
M20 VB1 VB1 VDD VDD pch l=0.15 w=1 nf=1 m=1
M21 VB1 net4 VSS VSS nch l=0.15 w=1 nf=1 m=1
M22 VB3 VB1 VDD VDD pch l=0.15 w=1 nf=1 m=1
M23 VB3 VB3 VSS VSS nch l=0.15 w=1 nf=1 m=1
M3 net7 VB3 VSS VSS nch l=0.15 w=1 nf=1 m=1
M4 net5 net5 VDD VDD pch l=0.15 w=1 nf=1 m=1
M5 net0 net0 VDD VDD pch l=0.15 w=1 nf=1 m=1
M6 N net5 VDD VDD pch l=0.15 w=1 nf=1 m=1
M7 OUT net0 VDD VDD pch l=0.15 w=1 nf=1 m=1
M8 N N VSS VSS nch l=0.15 w=1 nf=1 m=1
M9 OUT N VSS VSS nch l=0.15 w=1 nf=1 m=1
.ends opamp

.subckt dut VSS Vout
Q1 net0 net0 VSS VSS qnpn m=1
Q2 net2 net2 VSS VSS qnpn m=1
R1 Vout net0 1k
R2 Vout net1 1k
R3 net1 net2 1k
X1 VDD VSS net1 net0 Vout net2 opamp
.ends dut
