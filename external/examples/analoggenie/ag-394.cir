* official Analog Canvas netlist; PDK X cards rewritten by convert.py
.model nch nmos

.subckt dut VSS Vin Vout CK CK_bar
C1 net0 VSS 1p
C2 Vout VSS 1p
M1 Vin CK net0 VSS nch l=0.15 w=1 nf=1 m=1
M2 net0 CK_bar Vout VSS nch l=0.15 w=1 nf=1 m=1
.ends dut
