* official Analog Canvas netlist; PDK X cards rewritten by convert.py
.model nch nmos
.model pch pmos

.subckt dut VDD VSS VINP VINN VREF VB1 VB2 VB3 VB4 VOUT1 VOUT2
I1 VDD net2 DC 1m
M1 net4 VINP net0 VSS nch l=0.15 w=1 nf=1 m=1
M10 net5 VB4 VSS VSS nch l=0.15 w=1 nf=1 m=1
M11 net7 VB4 VSS VSS nch l=0.15 w=1 nf=1 m=1
M12 VOUT1 VB3 net5 VSS nch l=0.15 w=1 nf=1 m=1
M13 VOUT2 VB3 net7 VSS nch l=0.15 w=1 nf=1 m=1
M15 net2 net2 net3 VSS nch l=0.15 w=1 nf=1 m=1
M16 net3 VREF VSS VSS nch l=0.15 w=1 nf=1 m=1
M2 net6 VINN net0 VSS nch l=0.15 w=1 nf=1 m=1
M3 net6 VB1 VDD VDD pch l=0.15 w=1 nf=1 m=1
M4 net4 VB1 VDD VDD pch l=0.15 w=1 nf=1 m=1
M5 VOUT2 VB2 net6 VDD pch l=0.15 w=1 nf=1 m=1
M6 VOUT1 VB2 net4 VDD pch l=0.15 w=1 nf=1 m=1
M7 net1 VOUT2 VSS VSS nch l=0.15 w=1 nf=1 m=1
M8 net1 VOUT1 VSS VSS nch l=0.15 w=1 nf=1 m=1
M9 net0 net2 net1 VSS nch l=0.15 w=1 nf=1 m=1
.ends dut
