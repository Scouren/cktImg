* official Analog Canvas netlist; PDK X cards rewritten by convert.py
.model nch nmos
.model pch pmos

.subckt dut VDD VSS vci phi1 phi2 vco
C1 vcx VSS 1p
C2 net2 vco 1p
M1 vci phi1 vcx VSS nch l=0.15 w=1 nf=1 m=1
M10 net1 VB1 VDD VDD pch l=0.15 w=1 nf=1 m=1
M11 net1 net1 VSS VSS nch l=0.15 w=1 nf=1 m=1
M12 net4 VB1 VDD VDD pch l=0.15 w=1 nf=1 m=1
M13 net4 net4 net5 VSS nch l=0.15 w=1 nf=1 m=1
M14 net5 net4 net1 VSS nch l=0.15 w=1 nf=1 m=1
M15 net0 VB1 VDD VDD pch l=0.15 w=1 nf=1 m=1
M16 net0 net0 net3 VSS nch l=0.15 w=1 nf=1 m=1
M17 net3 net0 net5 VSS nch l=0.15 w=1 nf=1 m=1
M18 VB1 VB1 VDD VDD pch l=0.15 w=1 nf=1 m=1
M19 VB1 net3 VSS VSS nch l=0.15 w=1 nf=1 m=1
M2 vcx phi2 net2 VSS nch l=0.15 w=1 nf=1 m=1
M3 net2 VSS net6 VDD pch l=0.15 w=1 nf=1 m=1
M4 vco net2 net6 VDD pch l=0.15 w=1 nf=1 m=1
M5 net2 net2 VSS VSS nch l=0.15 w=1 nf=1 m=1
M6 vco net2 VSS VSS nch l=0.15 w=1 nf=1 m=1
M7 net6 VB2 VDD VDD pch l=0.15 w=1 nf=1 m=1
M8 VB2 VB2 VDD VDD pch l=0.15 w=1 nf=1 m=1
M9 VB2 net1 VSS VSS nch l=0.15 w=1 nf=1 m=1
.ends dut
