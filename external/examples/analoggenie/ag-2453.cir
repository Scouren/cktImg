* official Analog Canvas netlist; PDK X cards rewritten by convert.py
.model nch nmos
.model pch pmos

.subckt dut VDD VSS VREF VB2 VB3 VB5 VB4 VIN VOUT
CF1 VOUT VFB 1p
Cm1 VO1 VOUT 1p
Cm2 VO1 VX 1p
M1 net10 net8 VIN VDD pch l=0.15 w=1 nf=1 m=1
M10 VO1 VB1 VY VDD pch l=0.15 w=1 nf=1 m=1
M11 VX VB2 VSS VSS nch l=0.15 w=1 nf=1 m=1
M12 net3 VFB VX VSS nch l=0.15 w=1 nf=1 m=1
M13 net8 VREF VX VSS nch l=0.15 w=1 nf=1 m=1
M14 VO1 VBN net5 VSS nch l=0.15 w=1 nf=1 m=1
M15 net5 VN VSS VSS nch l=0.15 w=1 nf=1 m=1
M16 net0 net0 VIN VDD pch l=0.15 w=1 nf=1 m=1
M17 VBN net0 VIN VDD pch l=0.15 w=1 nf=1 m=1
M18 VBN VBN net7 VSS nch l=0.15 w=1 nf=1 m=1
M19 net7 VBN VSS VSS nch l=0.15 w=1 nf=1 m=1
M2 net8 VB1 net10 VDD pch l=0.15 w=1 nf=1 m=1
M21 VY VO1 VSS VSS nch l=0.15 w=1 nf=1 m=1
M22 VG net2 VSS VSS nch l=0.15 w=1 nf=1 m=1
M23 VY VY VIN VDD pch l=0.15 w=1 nf=1 m=1
M24 VG VY VIN VDD pch l=0.15 w=1 nf=1 m=1
M25 net2 VO1 VSS VSS nch l=0.15 w=1 nf=1 m=1
M26 net2 net2 VSS VSS nch l=0.15 w=1 nf=1 m=1
M27 net2 VB4 VIN VDD pch l=0.15 w=1 nf=1 m=1
M3 net9 net8 VIN VDD pch l=0.15 w=1 nf=1 m=1
M4 VN VB1 net9 VDD pch l=0.15 w=1 nf=1 m=1
M5 VN VBN net4 VSS nch l=0.15 w=1 nf=1 m=1
M6 net4 VN VSS VSS nch l=0.15 w=1 nf=1 m=1
M7 VG net3 VIN VDD pch l=0.15 w=1 nf=1 m=1
M8 net3 VB1 VG VDD pch l=0.15 w=1 nf=1 m=1
M9 VY net3 VIN VDD pch l=0.15 w=1 nf=1 m=1
MD1 VX VO1 VSS VSS nch l=0.15 w=1 nf=1 m=1
MD2 net6 VB5 VSS VSS nch l=0.15 w=1 nf=1 m=1
MD3 net11 VX net6 VSS nch l=0.15 w=1 nf=1 m=1
MD4 net1 VB3 net6 VSS nch l=0.15 w=1 nf=1 m=1
MD5 VX net1 VIN VDD pch l=0.15 w=1 nf=1 m=1
MD6 net11 net11 VIN VDD pch l=0.15 w=1 nf=1 m=1
MD7 net1 net1 VIN VDD pch l=0.15 w=1 nf=1 m=1
MPT VOUT VG VIN VDD pch l=0.15 w=1 nf=1 m=1
RB net0 VSS 1k
RF1 VOUT VFB 1k
RF2 VFB VSS 1k
.ends dut
