* official Analog Canvas netlist; PDK X cards rewritten by convert.py
.model nch nmos
.model pch pmos
.model qnpn npn

.subckt A1 VDD VSS INP INN VB2 VB1 VB4 OUT
M1 net6 VB2 VDD VDD pch l=0.15 w=1 nf=1 m=1
M10 net1 VB1 net0 VDD pch l=0.15 w=1 nf=1 m=1
M11 OUT VB1 net3 VDD pch l=0.15 w=1 nf=1 m=1
M12 net1 VB4 net4 VSS nch l=0.15 w=1 nf=1 m=1
M13 OUT VB4 net2 VSS nch l=0.15 w=1 nf=1 m=1
M14 net4 VM1 VSS VSS nch l=0.15 w=1 nf=1 m=1
M15 net2 VM2 VSS VSS nch l=0.15 w=1 nf=1 m=1
M2 VM1 INP net6 VDD pch l=0.15 w=1 nf=1 m=1
M3 VM2 INN net6 VDD pch l=0.15 w=1 nf=1 m=1
M4 VM1 VB4 net5 VSS nch l=0.15 w=1 nf=1 m=1
M5 VM2 VB4 net7 VSS nch l=0.15 w=1 nf=1 m=1
M6 net5 VM1 VSS VSS nch l=0.15 w=1 nf=1 m=1
M7 net7 VM2 VSS VSS nch l=0.15 w=1 nf=1 m=1
M8 net0 net1 VDD VDD pch l=0.15 w=1 nf=1 m=1
M9 net3 net1 VDD VDD pch l=0.15 w=1 nf=1 m=1
.ends A1

.subckt dut VDD VSS Vout VB1 VB2
M16 VB5 VB5 VDD VDD pch l=0.15 w=1 nf=1 m=1
M17 net1 VB5 VDD VDD pch l=0.15 w=1 nf=1 m=1
M18 net0 VB5 VDD VDD pch l=0.15 w=1 nf=1 m=1
M19 VB4 VB5 VDD VDD pch l=0.15 w=1 nf=1 m=1
M20 VB5 net0 net2 VSS nch l=0.15 w=1 nf=1 m=1
M21 net2 net1 VSS VSS nch l=0.15 w=1 nf=1 m=1
M22 net1 net1 VSS VSS nch l=0.15 w=1 nf=1 m=1
M23 net0 net0 VSS VSS nch l=0.15 w=1 nf=1 m=1
M24 VB4 VB4 VZ VSS nch l=0.15 w=1 nf=1 m=1
M25 VZ VB4 VSS VSS nch l=0.15 w=1 nf=1 m=1
Q1 X X VSS VSS qnpn m=1
Q2 VZ VZ VSS VSS qnpn m=1
R1 Vout X 1k
R2 Vout Y 1k
R3 Y VZ 1k
X1 VDD VSS X Y VB2 VB1 VB4 Vout A1
.ends dut
