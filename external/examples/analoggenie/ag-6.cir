* official Analog Canvas netlist; PDK X cards rewritten by convert.py
.model nch nmos

.subckt dut VDD VSS VOUT1
CP VOUT1 VSS 1p
I1 VOUT1 VSS DC 1m
M2 VDD VDD VOUT1 VSS nch l=0.15 w=1 nf=1 m=1
.ends dut
