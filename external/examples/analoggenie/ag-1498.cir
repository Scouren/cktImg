* official Analog Canvas netlist; PDK X cards rewritten by convert.py
.model nch nmos
.model pch pmos
.model qnpn npn

.subckt dut VDD VSS Vout
M1 net2 VG VDD VDD pch l=0.15 w=1 nf=1 m=1
M10 net6 VB5 VSS VSS nch l=0.15 w=1 nf=1 m=1
M11 net3 VB5 VSS VSS nch l=0.15 w=1 nf=1 m=1
M12 VB4 net0 VDD VDD pch l=0.15 w=1 nf=1 m=1
M13 net0 net0 VDD VDD pch l=0.15 w=1 nf=1 m=1
M14 net8 net0 VDD VDD pch l=0.15 w=1 nf=1 m=1
M15 VB4 VB4 VB5 VSS nch l=0.15 w=1 nf=1 m=1
M16 VB5 VB5 VSS VSS nch l=0.15 w=1 nf=1 m=1
M17 net0 net8 VSS VSS nch l=0.15 w=1 nf=1 m=1
M18 net1 net8 VSS VSS nch l=0.15 w=1 nf=1 m=1
M2 net5 VB1 VDD VDD pch l=0.15 w=1 nf=1 m=1
M3 net7 VG VDD VDD pch l=0.15 w=1 nf=1 m=1
M4 VG VB2 net2 VDD pch l=0.15 w=1 nf=1 m=1
M5 net6 X net5 VDD pch l=0.15 w=1 nf=1 m=1
M6 net3 Y net5 VDD pch l=0.15 w=1 nf=1 m=1
M7 Vout VB2 net7 VDD pch l=0.15 w=1 nf=1 m=1
M8 VG VB4 net6 VSS nch l=0.15 w=1 nf=1 m=1
M9 Vout VB4 net3 VSS nch l=0.15 w=1 nf=1 m=1
Q1 X X VSS VSS qnpn m=1
Q2 net4 net4 VSS VSS qnpn m=1
R1 Vout X 1k
R2 Vout Y 1k
R3 Y net4 1k
R4 net8 net1 1k
.ends dut
