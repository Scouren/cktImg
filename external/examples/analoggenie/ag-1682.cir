* official Analog Canvas netlist; PDK X cards rewritten by convert.py
.model nch nmos
.model pch pmos
.model qpnp pnp

.subckt dut VDD VSS Vout
M1 VZ X net5 VDD pch l=0.15 w=1 nf=1 m=1
M10 net1 VC VDD VDD pch l=0.15 w=1 nf=1 m=1
M11 X VC VDD VDD pch l=0.15 w=1 nf=1 m=1
M12 VB5 VB5 VSS VSS nch l=0.15 w=1 nf=1 m=1
M13 VB4 VB4 VB5 VSS nch l=0.15 w=1 nf=1 m=1
M14 VB4 net3 VDD VDD pch l=0.15 w=1 nf=1 m=1
M15 net3 net3 VDD VDD pch l=0.15 w=1 nf=1 m=1
M16 net2 net3 VDD VDD pch l=0.15 w=1 nf=1 m=1
M17 net2 net2 VSS VSS nch l=0.15 w=1 nf=1 m=1
M18 net3 net2 net6 VSS nch l=0.15 w=1 nf=1 m=1
M2 net4 Y net5 VDD pch l=0.15 w=1 nf=1 m=1
M3 net5 VB1 VDD VDD pch l=0.15 w=1 nf=1 m=1
M4 VZ VB5 VSS VSS nch l=0.15 w=1 nf=1 m=1
M5 net4 VB5 VSS VSS nch l=0.15 w=1 nf=1 m=1
M6 VC VB4 VZ VSS nch l=0.15 w=1 nf=1 m=1
M7 Vout VB4 net4 VSS nch l=0.15 w=1 nf=1 m=1
M8 VC VB2 net1 VDD pch l=0.15 w=1 nf=1 m=1
M9 Vout VB2 X VDD pch l=0.15 w=1 nf=1 m=1
Q1 VSS VSS VZ qpnp m=1
Q2 VZ VZ X qpnp m=1
Q3 VSS VSS net7 qpnp m=1
Q4 net7 net7 net0 qpnp m=1
R1 Vout X 1k
R2 Vout Y 1k
R3 Y net0 1k
R4 net6 VSS 1k
.ends dut
