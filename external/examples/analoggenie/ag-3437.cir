* official Analog Canvas netlist; PDK X cards rewritten by convert.py
.model nch nmos
.model pch pmos

.subckt opamp VDD VSS INN INP OUT
M1 net0 net2 VDD VDD pch l=0.15 w=1 nf=1 m=1
M10 net5 INP net12 VSS nch l=0.15 w=1 nf=1 m=1
M11 net12 VB2 VSS VSS nch l=0.15 w=1 nf=1 m=1
M12 net9 VB4 net3 VSS nch l=0.15 w=1 nf=1 m=1
M13 OUT VB4 net1 VSS nch l=0.15 w=1 nf=1 m=1
M14 net3 net9 VSS VSS nch l=0.15 w=1 nf=1 m=1
M15 VB3 net6 VDD VDD pch l=0.15 w=1 nf=1 m=1
M16 net6 net6 VDD VDD pch l=0.15 w=1 nf=1 m=1
M17 VB4 net6 VDD VDD pch l=0.15 w=1 nf=1 m=1
M18 net7 VB3 VSS VSS nch l=0.15 w=1 nf=1 m=1
M19 net6 VB3 VSS VSS nch l=0.15 w=1 nf=1 m=1
M2 net11 net2 VDD VDD pch l=0.15 w=1 nf=1 m=1
M20 VB4 VB4 net8 VSS nch l=0.15 w=1 nf=1 m=1
M21 net8 VB4 VSS VSS nch l=0.15 w=1 nf=1 m=1
M22 net1 net9 VSS VSS nch l=0.15 w=1 nf=1 m=1
M3 net4 net5 VDD VDD pch l=0.15 w=1 nf=1 m=1
M4 net10 net5 VDD VDD pch l=0.15 w=1 nf=1 m=1
M5 net9 VB1 net0 VDD pch l=0.15 w=1 nf=1 m=1
M6 net2 VB1 net11 VDD pch l=0.15 w=1 nf=1 m=1
M7 net5 VB1 net4 VDD pch l=0.15 w=1 nf=1 m=1
M8 OUT VB1 net10 VDD pch l=0.15 w=1 nf=1 m=1
M9 net2 INN net12 VSS nch l=0.15 w=1 nf=1 m=1
R1 VB3 net7 1k
.ends opamp

.subckt dut VDD VSS vin+ vin- Vout
C1 net3 Vout 1p
C2 Vout net1 1p
C3 net5 Vout 1p
C4 net4 net6 1p
C5 net2 VSS 1p
C6 net6 net0 1p
M1 vin+ phi2 net3 VSS nch l=0.15 w=1 nf=1 m=1
M10 VSS phi1a net2 VSS nch l=0.15 w=1 nf=1 m=1
M11 VSS phi1 net0 VSS nch l=0.15 w=1 nf=1 m=1
M12 net0 phi2 VSS VSS nch l=0.15 w=1 nf=1 m=1
M2 VSS phi1 net3 VSS nch l=0.15 w=1 nf=1 m=1
M3 VSS phi1a net5 VSS nch l=0.15 w=1 nf=1 m=1
M4 net5 phi2a Vout VSS nch l=0.15 w=1 nf=1 m=1
M5 net1 phi2 VSS VSS nch l=0.15 w=1 nf=1 m=1
M6 net1 phi1 Vout VSS nch l=0.15 w=1 nf=1 m=1
M7 vin- phi2 net4 VSS nch l=0.15 w=1 nf=1 m=1
M8 net4 phi1 VSS VSS nch l=0.15 w=1 nf=1 m=1
M9 net6 phi2a net2 VSS nch l=0.15 w=1 nf=1 m=1
X1 VDD VSS Vout net6 Vout opamp
.ends dut
