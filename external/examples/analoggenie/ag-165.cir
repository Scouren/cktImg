* official Analog Canvas netlist; PDK X cards rewritten by convert.py
.model nch nmos
.model pch pmos

.subckt dut VDD VSS Vin1 Vin2 Vout1 Vout2
CL1 Vout1 VSS 1p
CL2 Vout2 VSS 1p
ISS net0 VSS DC 1m
M1 net2 Vin1 net0 VSS nch l=0.15 w=1 nf=1 m=1
M2 net1 Vin2 net0 VSS nch l=0.15 w=1 nf=1 m=1
M3 net2 net2 VDD VDD pch l=0.15 w=1 nf=1 m=1
M4 net1 net1 VDD VDD pch l=0.15 w=1 nf=1 m=1
M5 Vout1 net2 VDD VDD pch l=0.15 w=1 nf=1 m=1
M6 Vout2 net1 VDD VDD pch l=0.15 w=1 nf=1 m=1
RD1 Vout1 VSS 1k
RD2 Vout2 VSS 1k
.ends dut
