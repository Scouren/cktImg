* official Analog Canvas netlist; PDK X cards rewritten by convert.py
.model nch nmos
.model pch pmos

.subckt dut VDD VSS vci phi1 phi2 vco VB1 VB2
C1 vcx VSS 1p
C2 net5 vco 1p
M1 vci phi1 vcx VSS nch l=0.15 w=1 nf=1 m=1
M10 VB1 VB3 VDD VDD pch l=0.15 w=1 nf=1 m=1
M11 VB1 VB1 VSS VSS nch l=0.15 w=1 nf=1 m=1
M12 VB3 VB3 VDD VDD pch l=0.15 w=1 nf=1 m=1
M13 VB3 net2 VSS VSS nch l=0.15 w=1 nf=1 m=1
M14 net2 net0 VDD VDD pch l=0.15 w=1 nf=1 m=1
M15 net2 net2 VSS VSS nch l=0.15 w=1 nf=1 m=1
M16 net0 net0 VDD VDD pch l=0.15 w=1 nf=1 m=1
M17 net0 VB2 VSS VSS nch l=0.15 w=1 nf=1 m=1
M18 VB2 net0 VDD VDD pch l=0.15 w=1 nf=1 m=1
M19 VB2 VB2 VSS VSS nch l=0.15 w=1 nf=1 m=1
M2 vcx phi2 net5 VSS nch l=0.15 w=1 nf=1 m=1
M3 vco net5 vcx VDD pch l=0.15 w=1 nf=1 m=1
M4 net3 VSS vcx VDD pch l=0.15 w=1 nf=1 m=1
M5 vcx VB3 VDD VDD pch l=0.15 w=1 nf=1 m=1
M6 vco VB4 net1 VSS nch l=0.15 w=1 nf=1 m=1
M7 net3 VB4 net4 VSS nch l=0.15 w=1 nf=1 m=1
M8 net1 net3 VSS VSS nch l=0.15 w=1 nf=1 m=1
M9 net4 net3 VSS VSS nch l=0.15 w=1 nf=1 m=1
.ends dut
