* official Analog Canvas netlist; PDK X cards rewritten by convert.py
.model nch nmos
.model pch pmos

.subckt dut VDD VSS vci phi1 phi2 vco
C1 net5 net3 1p
C2 net6 vco 1p
M1 vci phi1 net5 VSS nch l=0.15 w=1 nf=1 m=1
M10 net0 net2 VSS VSS nch l=0.15 w=1 nf=1 m=1
M11 net0 net0 VDD VDD pch l=0.15 w=1 nf=1 m=1
M12 vco net0 VDD VDD pch l=0.15 w=1 nf=1 m=1
M13 vco net4 VSS VSS nch l=0.15 w=1 nf=1 m=1
M14 VB1 VB1 VDD VDD pch l=0.15 w=1 nf=1 m=1
M15 net1 VB1 VDD VDD pch l=0.15 w=1 nf=1 m=1
M16 VB2 VB2 VDD VDD pch l=0.15 w=1 nf=1 m=1
M17 VB1 net1 VSS VSS nch l=0.15 w=1 nf=1 m=1
M18 net1 net1 VSS VSS nch l=0.15 w=1 nf=1 m=1
M19 VB2 net1 VSS VSS nch l=0.15 w=1 nf=1 m=1
M2 net5 phi2 VSS VSS nch l=0.15 w=1 nf=1 m=1
M3 net3 phi1 VSS VSS nch l=0.15 w=1 nf=1 m=1
M4 net3 phi2 net6 VSS nch l=0.15 w=1 nf=1 m=1
M5 net4 net6 net7 VDD pch l=0.15 w=1 nf=1 m=1
M6 net2 VSS net7 VDD pch l=0.15 w=1 nf=1 m=1
M7 net7 VB2 VDD VDD pch l=0.15 w=1 nf=1 m=1
M8 net4 net4 VSS VSS nch l=0.15 w=1 nf=1 m=1
M9 net2 net2 VSS VSS nch l=0.15 w=1 nf=1 m=1
.ends dut
