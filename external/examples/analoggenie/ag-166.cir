* official Analog Canvas netlist; PDK X cards rewritten by convert.py
.model nch nmos
.model pch pmos

.subckt dut VDD VSS Vin1 Vout1
CL Vout1 VSS 1p
M1 X Vin1 VSS VSS nch l=0.15 w=1 nf=1 m=1
M3 X X VDD VDD pch l=0.15 w=1 nf=1 m=1
M5 Vout1 X VDD VDD pch l=0.15 w=1 nf=1 m=1
RD Vout1 VSS 1k
.ends dut
