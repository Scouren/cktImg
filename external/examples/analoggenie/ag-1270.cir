* official Analog Canvas netlist; PDK X cards rewritten by convert.py
.model nch nmos
.model pch pmos

.subckt dut VDD VSS VIN VCONT1 VCONT2 VCONT3 VCONT4 VCONT5 VP VREF VB2 VB1 VB3
.model DIODE D(IS=1e-14 N=1)
CFLY VX1 VX2 1p
CO VP VN 1p
COP VP VSS 1p
D1 VN VX2 DIODE
L1 VX1 VX3 1n
M1 net7 VCONT1 VIN VDD pch l=0.15 w=1 nf=1 m=1
M2 VX1 VCONT2 VIN VDD pch l=0.15 w=1 nf=1 m=1
M3 VX2 VCONT3 VIN VDD pch l=0.15 w=1 nf=1 m=1
M4 VX3 VCONT4 VSS VSS nch l=0.15 w=1 nf=1 m=1
M5 VP VCONT5 VX3 VDD pch l=0.15 w=1 nf=1 m=1
MN1 net4 VFP1 net2 VSS nch l=0.15 w=1 nf=1 m=1
MN10 VB2 net3 VR VSS nch l=0.15 w=1 nf=1 m=1
MN11 net3 VR VSS VSS nch l=0.15 w=1 nf=1 m=1
MN12 net5 VR VSS VSS nch l=0.15 w=1 nf=1 m=1
MN13 VBN VBN VSS VSS nch l=0.15 w=1 nf=1 m=1
MN14 VB1 VBN VSS VSS nch l=0.15 w=1 nf=1 m=1
MN2 VX3 VREF net2 VSS nch l=0.15 w=1 nf=1 m=1
MN3 net2 VBN VSS VSS nch l=0.15 w=1 nf=1 m=1
MN4 net0 net0 VSS VSS nch l=0.15 w=1 nf=1 m=1
MN5 VEA net0 VSS VSS nch l=0.15 w=1 nf=1 m=1
MN7 net6 net6 VSS VSS nch l=0.15 w=1 nf=1 m=1
MN8 net1 net6 VSS VSS nch l=0.15 w=1 nf=1 m=1
MN9 net6 VB3 VSS VSS nch l=0.15 w=1 nf=1 m=1
MP1 net4 net4 VDD VDD pch l=0.15 w=1 nf=1 m=1
MP10 VB2 VB2 VDD VDD pch l=0.15 w=1 nf=1 m=1
MP11 net5 net5 VDD VDD pch l=0.15 w=1 nf=1 m=1
MP12 VBN net5 VDD VDD pch l=0.15 w=1 nf=1 m=1
MP13 VB1 VB1 VDD VDD pch l=0.15 w=1 nf=1 m=1
MP2 VX3 VX3 VDD VDD pch l=0.15 w=1 nf=1 m=1
MP3 net0 net4 VDD VDD pch l=0.15 w=1 nf=1 m=1
MP4 VEA VX3 VDD VDD pch l=0.15 w=1 nf=1 m=1
MP6 net6 VEA net7 VDD pch l=0.15 w=1 nf=1 m=1
MP7 net1 net1 net7 VDD pch l=0.15 w=1 nf=1 m=1
MP8 VX1 net1 net7 VDD pch l=0.15 w=1 nf=1 m=1
MP9 net3 VB2 VDD VDD pch l=0.15 w=1 nf=1 m=1
R1 VP VFP1 1k
R2 VFP1 VSS 1k
RBIAS VR VSS 1k
.ends dut
