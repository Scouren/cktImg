* official Analog Canvas netlist; PDK X cards rewritten by convert.py
.model nch nmos

.subckt dut VDD VSS Vb
CP VDD net1 1p
I1 net0 VSS DC 1m
LP VDD net1 1n
M1 VDD net1 net0 VSS nch l=0.15 w=1 nf=1 m=1
M2 net1 Vb net0 VSS nch l=0.15 w=1 nf=1 m=1
RP VDD net1 1k
.ends dut
