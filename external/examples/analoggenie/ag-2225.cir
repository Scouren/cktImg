* official Analog Canvas netlist; PDK X cards rewritten by convert.py
.model nch nmos
.model pch pmos

.subckt opamp VDD VSS INP INN OUT
M1 net0 VB1 VDD VDD pch l=0.15 w=1 nf=1 m=1
M10 net5 VBN VSS VSS nch l=0.15 w=1 nf=1 m=1
M11 net2 VBN VSS VSS nch l=0.15 w=1 nf=1 m=1
M12 VCN VP VDD VDD pch l=0.15 w=1 nf=1 m=1
M13 VCN VCN VBN VSS nch l=0.15 w=1 nf=1 m=1
M14 VBN VBN VSS VSS nch l=0.15 w=1 nf=1 m=1
M15 VP VP VDD VDD pch l=0.15 w=1 nf=1 m=1
M16 VP VB4 VB3 VSS nch l=0.15 w=1 nf=1 m=1
M17 VB3 net3 VSS VSS nch l=0.15 w=1 nf=1 m=1
M18 net3 VP VDD VDD pch l=0.15 w=1 nf=1 m=1
M19 net3 net3 VSS VSS nch l=0.15 w=1 nf=1 m=1
M2 net2 INP net0 VDD pch l=0.15 w=1 nf=1 m=1
M20 VB4 VP VDD VDD pch l=0.15 w=1 nf=1 m=1
M21 VB4 VB3 VSS VSS nch l=0.15 w=1 nf=1 m=1
M3 net5 INN net0 VDD pch l=0.15 w=1 nf=1 m=1
M4 net4 VX VDD VDD pch l=0.15 w=1 nf=1 m=1
M5 net1 VX VDD VDD pch l=0.15 w=1 nf=1 m=1
M6 OUT VB2 net4 VDD pch l=0.15 w=1 nf=1 m=1
M7 VX VB2 net1 VDD pch l=0.15 w=1 nf=1 m=1
M8 OUT VCN net5 VSS nch l=0.15 w=1 nf=1 m=1
M9 VX VCN net2 VSS nch l=0.15 w=1 nf=1 m=1
.ends opamp

.subckt dut VSS VIN Vref VOUT
CL VOUT net0 1p
MNP VIN net1 VOUT VSS nch l=0.15 w=1 nf=1 m=1
R1 VOUT FB 1k
R2 FB VSS 1k
R3 net0 VSS 1k
X1 VDD VSS Vref FB net1 opamp
.ends dut
