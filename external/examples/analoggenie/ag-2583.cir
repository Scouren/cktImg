* official Analog Canvas netlist; PDK X cards rewritten by convert.py
.model nch nmos
.model pch pmos

.subckt amp VDD VSS INP INN OUT VB1 VB3 n3 VB2
M10 n3 VB1 VDD VDD pch l=0.15 w=1 nf=1 m=1
M11 net1 INP n3 VDD pch l=0.15 w=1 nf=1 m=1
M12 net6 INN n3 VDD pch l=0.15 w=1 nf=1 m=1
M13 net7 VX VDD VDD pch l=0.15 w=1 nf=1 m=1
M14 OUT VB2 net7 VDD pch l=0.15 w=1 nf=1 m=1
M15 OUT VY net6 VSS nch l=0.15 w=1 nf=1 m=1
M16 net6 VZ VSS VSS nch l=0.15 w=1 nf=1 m=1
M17 VY VP VDD VDD pch l=0.15 w=1 nf=1 m=1
M18 VY VY VZ VSS nch l=0.15 w=1 nf=1 m=1
M19 VZ VZ VSS VSS nch l=0.15 w=1 nf=1 m=1
M20 VP VP VDD VDD pch l=0.15 w=1 nf=1 m=1
M21 VP net2 VSS VSS nch l=0.15 w=1 nf=1 m=1
M22 net0 VP VDD VDD pch l=0.15 w=1 nf=1 m=1
M23 net0 net0 net2 VSS nch l=0.15 w=1 nf=1 m=1
M24 net2 net0 net3 VSS nch l=0.15 w=1 nf=1 m=1
M25 net4 VP VDD VDD pch l=0.15 w=1 nf=1 m=1
M26 net4 net4 net3 VSS nch l=0.15 w=1 nf=1 m=1
M27 net3 net4 VB3 VSS nch l=0.15 w=1 nf=1 m=1
M28 VB3 VP VDD VDD pch l=0.15 w=1 nf=1 m=1
M29 VB3 VB3 VSS VSS nch l=0.15 w=1 nf=1 m=1
M6 net5 VX VDD VDD pch l=0.15 w=1 nf=1 m=1
M7 VX VB2 net5 VDD pch l=0.15 w=1 nf=1 m=1
M8 VX VY net1 VSS nch l=0.15 w=1 nf=1 m=1
M9 net1 VZ VSS VSS nch l=0.15 w=1 nf=1 m=1
.ends amp

.subckt dut VDD VSS biasp biascas biasn Vout Vref VB1 VB2 VB3
C1 Vset VSS 1p
C2 n3 Vout 1p
M1 Vout n3 VDD VDD pch l=0.15 w=1 nf=1 m=1
M2 n1 Vset Vout VDD pch l=0.15 w=1 nf=1 m=1
M3 n1 biasn VSS VSS nch l=0.15 w=1 nf=1 m=1
M4 n3 biasp VDD VDD pch l=0.15 w=1 nf=1 m=1
M5 n3 biascas n1 VSS nch l=0.15 w=1 nf=1 m=1
R1 fb VSS 1k
R2 Vout fb 1k
X1 VDD VSS Vref fb Vset VB1 VB3 n3 VB2 amp
.ends dut
