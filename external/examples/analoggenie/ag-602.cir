* official Analog Canvas netlist; PDK X cards rewritten by convert.py
.model nch nmos
.model pch pmos

* Ideal inverter: switches at V(VDD,VSS)/2; vt sets the step width, td the delay
.subckt inverter VDD VSS A Y params: vt=10m td=10p
BhA hA 0 V={0.5*(1+tanh((V(A,VSS)-0.5*V(VDD,VSS))/vt))}
Bf nfn VSS V={V(VDD,VSS)*(1-V(hA))}
Rd nfn ndl 1k
Cd ndl VSS {td/1000}
BY Y VSS V={V(ndl,VSS)}
.ends inverter

.subckt dut VDD VSS CK MC Output
M1 Q_bar net3 VSS VSS nch l=0.15 w=1 nf=1 m=1
M10 net6 Q_bar VDD VDD pch l=0.15 w=1 nf=1 m=1
M11 net5 MC VDD VDD pch l=0.15 w=1 nf=1 m=1
M12 net6 Output net5 VDD pch l=0.15 w=1 nf=1 m=1
M13 net6 CK net2 VSS nch l=0.15 w=1 nf=1 m=1
M14 net2 Q_bar net0 VSS nch l=0.15 w=1 nf=1 m=1
M15 net0 Output VSS VSS nch l=0.15 w=1 nf=1 m=1
M16 net0 MC VSS VSS nch l=0.15 w=1 nf=1 m=1
M17 net8 net6 VDD VDD pch l=0.15 w=1 nf=1 m=1
M18 net8 CK VSS VSS nch l=0.15 w=1 nf=1 m=1
M2 net4 net1 VDD VDD pch l=0.15 w=1 nf=1 m=1
M3 net4 CK net7 VSS nch l=0.15 w=1 nf=1 m=1
M4 net7 net1 VSS VSS nch l=0.15 w=1 nf=1 m=1
M5 net3 net4 VDD VDD pch l=0.15 w=1 nf=1 m=1
M6 Output CK VDD VDD pch l=0.15 w=1 nf=1 m=1
M7 Output net8 VSS VSS nch l=0.15 w=1 nf=1 m=1
M8 net3 CK VSS VSS nch l=0.15 w=1 nf=1 m=1
M9 Q_bar CK VDD VDD pch l=0.15 w=1 nf=1 m=1
X1 VDD VSS Output net1 inverter td=10p vt=10m
.ends dut
