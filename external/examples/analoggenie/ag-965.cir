* official Analog Canvas netlist; PDK X cards rewritten by convert.py
.model nch nmos
.model pch pmos

.subckt dut VDD VSS v3 v1 VBIAS v4 v2
C1 v3 VSS 1p
C2 net0 VSS 1p
C3 net1 VSS 1p
C4 v4 VSS 1p
M1 v3 v1 net2 VSS nch l=0.15 w=1 nf=1 m=1
M2 net1 v1 net2 VSS nch l=0.15 w=1 nf=1 m=1
M3 net0 v2 net2 VSS nch l=0.15 w=1 nf=1 m=1
M4 v4 v2 net2 VSS nch l=0.15 w=1 nf=1 m=1
M5 v3 net0 VDD VDD pch l=0.15 w=1 nf=1 m=1
M6 net0 net0 VDD VDD pch l=0.15 w=1 nf=1 m=1
M7 net1 net1 VDD VDD pch l=0.15 w=1 nf=1 m=1
M8 v4 net1 VDD VDD pch l=0.15 w=1 nf=1 m=1
M9 net2 VBIAS VSS VSS nch l=0.15 w=1 nf=1 m=1
.ends dut
