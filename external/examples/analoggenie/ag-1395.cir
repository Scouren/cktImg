* official Analog Canvas netlist; PDK X cards rewritten by convert.py
.model nch nmos
.model pch pmos

.subckt comparator VDD VSS VB1 VB2 INN OUT VB3
M10 net6 VB5 VSS VSS nch l=0.15 w=1 nf=1 m=1
M11 net5 VB1 VDD VDD pch l=0.15 w=1 nf=1 m=1
M12 net2 OUT net5 VDD pch l=0.15 w=1 nf=1 m=1
M13 net6 INN net5 VDD pch l=0.15 w=1 nf=1 m=1
M14 VB3 net1 VDD VDD pch l=0.15 w=1 nf=1 m=1
M15 net1 net1 VDD VDD pch l=0.15 w=1 nf=1 m=1
M16 VB4 net1 VDD VDD pch l=0.15 w=1 nf=1 m=1
M17 VB3 VB3 VSS VSS nch l=0.15 w=1 nf=1 m=1
M18 net1 VB3 net0 VSS nch l=0.15 w=1 nf=1 m=1
M19 VB4 VB4 VB5 VSS nch l=0.15 w=1 nf=1 m=1
M20 VB5 VB5 VSS VSS nch l=0.15 w=1 nf=1 m=1
M3 net7 net4 VDD VDD pch l=0.15 w=1 nf=1 m=1
M4 net3 net4 VDD VDD pch l=0.15 w=1 nf=1 m=1
M5 net4 VB2 net7 VDD pch l=0.15 w=1 nf=1 m=1
M6 OUT VB2 net3 VDD pch l=0.15 w=1 nf=1 m=1
M7 net4 VB4 net2 VSS nch l=0.15 w=1 nf=1 m=1
M8 OUT VB4 net6 VSS nch l=0.15 w=1 nf=1 m=1
M9 net2 VB5 VSS VSS nch l=0.15 w=1 nf=1 m=1
R1 net0 VSS 1k
.ends comparator

.subckt dut VDD VSS VSTO VCONT1 VCONT2 VCONT3 VOUT VB1 VB2 VB3
CL VOUT VSS 1p
CSTO VSTO VSS 1p
LRX net2 net1 1n
MN1 net2 VCONT2 VSS VSS nch l=0.15 w=1 nf=1 m=1
MN2 net1 VCONT3 VSS VSS nch l=0.15 w=1 nf=1 m=1
MP2 net1 net0 VOUT VDD pch l=0.15 w=1 nf=1 m=1
MP3 net2 VCONT1 VSTO VDD pch l=0.15 w=1 nf=1 m=1
X1 VDD VSS VB1 VB2 net1 net0 VB3 comparator
.ends dut
