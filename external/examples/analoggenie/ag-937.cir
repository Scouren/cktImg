* official Analog Canvas netlist; PDK X cards rewritten by convert.py
.model nch nmos
.model pch pmos

.subckt dut VDD VSS VREF
M1 VREF VREF VSS VSS nch l=0.15 w=1 nf=1 m=1
M2 VREF VREF VDD VDD pch l=0.15 w=1 nf=1 m=1
.ends dut
