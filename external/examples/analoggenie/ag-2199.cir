* official Analog Canvas netlist; PDK X cards rewritten by convert.py
.model nch nmos
.model pch pmos

.subckt Opamp VDD VSS INP INN OUT
M1 net4 VB1 VDD VDD pch l=0.15 w=1 nf=1 m=1
M10 net2 INN OUT VSS nch l=0.15 w=1 nf=1 m=1
M11 OUT VB5 VSS VSS nch l=0.15 w=1 nf=1 m=1
M12 VB3 net1 VDD VDD pch l=0.15 w=1 nf=1 m=1
M13 net1 net1 VDD VDD pch l=0.15 w=1 nf=1 m=1
M14 VB3 VB3 VSS VSS nch l=0.15 w=1 nf=1 m=1
M15 net1 VB3 VSS VSS nch l=0.15 w=1 nf=1 m=1
M16 VB4 net1 VDD VDD pch l=0.15 w=1 nf=1 m=1
M17 VB4 VB4 VB5 VSS nch l=0.15 w=1 nf=1 m=1
M18 VB5 VB5 VSS VSS nch l=0.15 w=1 nf=1 m=1
M2 net2 VB1 VDD VDD pch l=0.15 w=1 nf=1 m=1
M3 OUT VB2 net4 VDD pch l=0.15 w=1 nf=1 m=1
M4 net5 VB2 net2 VDD pch l=0.15 w=1 nf=1 m=1
M5 OUT VB4 net0 VSS nch l=0.15 w=1 nf=1 m=1
M6 net5 VB4 net3 VSS nch l=0.15 w=1 nf=1 m=1
M7 net0 net5 VSS VSS nch l=0.15 w=1 nf=1 m=1
M8 net3 net5 VSS VSS nch l=0.15 w=1 nf=1 m=1
M9 net4 INP OUT VSS nch l=0.15 w=1 nf=1 m=1
.ends Opamp

.subckt dut VDD VSS VIN VOUT Vref
CL VOUT net1 1p
MNP VIN net0 VOUT VSS nch l=0.15 w=1 nf=1 m=1
R1 VOUT FB 1k
R2 FB VSS 1k
RESR net1 VSS 1k
X1 VDD VSS Vref FB net0 Opamp
.ends dut
