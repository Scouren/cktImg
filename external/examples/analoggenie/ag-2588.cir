* official Analog Canvas netlist; PDK X cards rewritten by convert.py
.model nch nmos
.model pch pmos

.subckt AMP1 VDD VSS INP INN OUT n3 VB1 VB3 VB2
M10 net0 VX VDD VDD pch l=0.15 w=1 nf=1 m=1
M11 OUT VB3 net0 VDD pch l=0.15 w=1 nf=1 m=1
M12 OUT VC net3 VSS nch l=0.15 w=1 nf=1 m=1
M13 net3 VB2 VSS VSS nch l=0.15 w=1 nf=1 m=1
M14 n3 VB1 VDD VDD pch l=0.15 w=1 nf=1 m=1
M15 net4 INP n3 VDD pch l=0.15 w=1 nf=1 m=1
M16 net3 INN n3 VDD pch l=0.15 w=1 nf=1 m=1
M17 net2 net2 VDD VDD pch l=0.15 w=1 nf=1 m=1
M18 VC net2 VDD VDD pch l=0.15 w=1 nf=1 m=1
M19 VC VC net5 VSS nch l=0.15 w=1 nf=1 m=1
M20 net5 VC VSS VSS nch l=0.15 w=1 nf=1 m=1
M6 net1 VX VDD VDD pch l=0.15 w=1 nf=1 m=1
M7 VX VB3 net1 VDD pch l=0.15 w=1 nf=1 m=1
M8 VX VC net4 VSS nch l=0.15 w=1 nf=1 m=1
M9 net4 VB2 VSS VSS nch l=0.15 w=1 nf=1 m=1
R3 net2 VSS 1k
.ends AMP1

.subckt dut VDD VSS biasp biascas biasn Vout Vref VB1 VB2 VB3
C1 Vset VSS 1p
C2 n3 Vout 1p
M1 Vout n3 VDD VDD pch l=0.15 w=1 nf=1 m=1
M2 net0 Vset Vout VDD pch l=0.15 w=1 nf=1 m=1
M3 net0 biasn VSS VSS nch l=0.15 w=1 nf=1 m=1
M4 n3 biasp VDD VDD pch l=0.15 w=1 nf=1 m=1
M5 n3 biascas net0 VSS nch l=0.15 w=1 nf=1 m=1
R1 fb VSS 1k
R2 Vout fb 1k
X1 VDD VSS Vref fb Vset n3 VB1 VB3 VB2 AMP1
.ends dut
