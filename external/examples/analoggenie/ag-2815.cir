* official Analog Canvas netlist; PDK X cards rewritten by convert.py
.model nch nmos
.model pch pmos

.subckt opamp VDD VSS INN INP OUT
M10 VB2 VB2 VSS VSS nch l=0.15 w=1 nf=1 m=1
M11 VB2 net0 VDD VDD pch l=0.15 w=1 nf=1 m=1
M12 net0 net0 VDD VDD pch l=0.15 w=1 nf=1 m=1
M13 net0 VB1 VSS VSS nch l=0.15 w=1 nf=1 m=1
M14 VB1 net0 VDD VDD pch l=0.15 w=1 nf=1 m=1
M15 net3 VB1 VSS VSS nch l=0.15 w=1 nf=1 m=1
M3 net1 INN net2 VSS nch l=0.15 w=1 nf=1 m=1
M4 OUT INP net2 VSS nch l=0.15 w=1 nf=1 m=1
M5 net1 net1 VDD VDD pch l=0.15 w=1 nf=1 m=1
M6 net1 net1 VDD VDD pch l=0.15 w=1 nf=1 m=1
M7 OUT net1 VDD VDD pch l=0.15 w=1 nf=1 m=1
M8 net2 VB2 VSS VSS nch l=0.15 w=1 nf=1 m=1
M9 net1 VB2 VSS VSS nch l=0.15 w=1 nf=1 m=1
R1 VB1 net3 1k
.ends opamp

.subckt dut VDD VSS vci phi1 phi2 vco
C1 vcx VSS 1p
C2 net0 vco 1p
M1 vci phi1 vcx VSS nch l=0.15 w=1 nf=1 m=1
M2 vcx phi2 net0 VSS nch l=0.15 w=1 nf=1 m=1
X1 VDD VSS net0 VSS vco opamp
.ends dut
