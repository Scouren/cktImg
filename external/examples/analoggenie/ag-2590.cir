* official Analog Canvas netlist; PDK X cards rewritten by convert.py
.model nch nmos
.model pch pmos

.subckt dut VDD VSS biasp biascas biasn Vout Vref
C1 Vset VSS 1p
C2 n3 Vout 1p
M1 Vout n3 VDD VDD pch l=0.15 w=1 nf=1 m=1
M10 net8 net7 VDD VDD pch l=0.15 w=1 nf=1 m=1
M11 net7 VB3 net4 VDD pch l=0.15 w=1 nf=1 m=1
M12 Vset VB3 net8 VDD pch l=0.15 w=1 nf=1 m=1
M13 net7 VX net0 VSS nch l=0.15 w=1 nf=1 m=1
M14 Vset VX net5 VSS nch l=0.15 w=1 nf=1 m=1
M15 net0 net9 VSS VSS nch l=0.15 w=1 nf=1 m=1
M16 net5 net9 VSS VSS nch l=0.15 w=1 nf=1 m=1
M17 VX net2 VDD VDD pch l=0.15 w=1 nf=1 m=1
M18 VX VX net6 VSS nch l=0.15 w=1 nf=1 m=1
M19 net6 VX VSS VSS nch l=0.15 w=1 nf=1 m=1
M2 net3 Vset Vout VDD pch l=0.15 w=1 nf=1 m=1
M20 n3 net2 VDD VDD pch l=0.15 w=1 nf=1 m=1
M21 net2 net2 VDD VDD pch l=0.15 w=1 nf=1 m=1
M22 net2 n3 net1 VSS nch l=0.15 w=1 nf=1 m=1
M23 n3 net1 VSS VSS nch l=0.15 w=1 nf=1 m=1
M3 net3 biasn VSS VSS nch l=0.15 w=1 nf=1 m=1
M4 n3 biasp VDD VDD pch l=0.15 w=1 nf=1 m=1
M5 n3 biascas net3 VSS nch l=0.15 w=1 nf=1 m=1
M6 n3 VB1 VDD VDD pch l=0.15 w=1 nf=1 m=1
M7 net0 Vref n3 VDD pch l=0.15 w=1 nf=1 m=1
M8 net5 fb n3 VDD pch l=0.15 w=1 nf=1 m=1
M9 net4 net7 VDD VDD pch l=0.15 w=1 nf=1 m=1
R1 fb VSS 1k
R2 Vout fb 1k
R3 net1 VSS 1k
.ends dut
