* official Analog Canvas netlist; PDK X cards rewritten by convert.py
.model nch nmos
.model pch pmos
.model qpnp pnp

.subckt opamp VDD VSS INN INP OUT
M1 net0 INN net5 VSS nch l=0.15 w=1 nf=1 m=1
M10 VB4 VB2 VDD VDD pch l=0.15 w=1 nf=1 m=1
M11 VB2 VB2 VDD VDD pch l=0.15 w=1 nf=1 m=1
M12 net4 VB2 VDD VDD pch l=0.15 w=1 nf=1 m=1
M13 VB4 VB4 VSS VSS nch l=0.15 w=1 nf=1 m=1
M14 VB2 VB4 net6 VSS nch l=0.15 w=1 nf=1 m=1
M15 net6 net4 VSS VSS nch l=0.15 w=1 nf=1 m=1
M16 net4 net4 VSS VSS nch l=0.15 w=1 nf=1 m=1
M17 net1 net1 VDD VDD pch l=0.15 w=1 nf=1 m=1
M18 VB3 net1 VDD VDD pch l=0.15 w=1 nf=1 m=1
M19 VB1 VB1 VDD VDD pch l=0.15 w=1 nf=1 m=1
M2 net3 INP net5 VSS nch l=0.15 w=1 nf=1 m=1
M20 net1 VB4 VSS VSS nch l=0.15 w=1 nf=1 m=1
M21 VB3 VB3 VSS VSS nch l=0.15 w=1 nf=1 m=1
M22 VB1 VB3 VSS VSS nch l=0.15 w=1 nf=1 m=1
M3 net3 net3 VDD VDD pch l=0.15 w=1 nf=1 m=1
M4 net0 net0 VDD VDD pch l=0.15 w=1 nf=1 m=1
M5 OUT net3 VDD VDD pch l=0.15 w=1 nf=1 m=1
M6 net2 net0 VDD VDD pch l=0.15 w=1 nf=1 m=1
M7 net5 VB3 VSS VSS nch l=0.15 w=1 nf=1 m=1
M8 net2 net2 VSS VSS nch l=0.15 w=1 nf=1 m=1
M9 OUT net2 VSS VSS nch l=0.15 w=1 nf=1 m=1
.ends opamp

.subckt dut VDD VSS Vout
Q1 VSS VSS net0 qpnp m=1
Q2 net0 net0 net1 qpnp m=1
Q3 VSS VSS net3 qpnp m=1
Q4 net3 net3 net2 qpnp m=1
R1 Vout net1 1k
R2 Vout net4 1k
R3 net4 net2 1k
X1 VDD VSS net4 net1 Vout opamp
.ends dut
