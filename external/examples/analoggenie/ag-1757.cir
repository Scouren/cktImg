* official Analog Canvas netlist; PDK X cards rewritten by convert.py
.model nch nmos
.model pch pmos
.model qpnp pnp

.subckt dut VDD VSS Vout VB1 VB2
M1 X VG VDD VDD pch l=0.15 w=1 nf=1 m=1
M10 VZ VB6 net0 VSS nch l=0.15 w=1 nf=1 m=1
M11 net2 VZ VSS VSS nch l=0.15 w=1 nf=1 m=1
M12 net0 VZ VSS VSS nch l=0.15 w=1 nf=1 m=1
M13 net4 Y Y VSS nch l=0.15 w=1 nf=1 m=1
M14 net6 X Y VSS nch l=0.15 w=1 nf=1 m=1
M15 Y VB7 VSS VSS nch l=0.15 w=1 nf=1 m=1
M16 VB4 VB5 VDD VDD pch l=0.15 w=1 nf=1 m=1
M17 VB5 VB5 VDD VDD pch l=0.15 w=1 nf=1 m=1
M18 net5 VB5 VDD VDD pch l=0.15 w=1 nf=1 m=1
M19 VB6 VB5 VDD VDD pch l=0.15 w=1 nf=1 m=1
M2 Vout VG VDD VDD pch l=0.15 w=1 nf=1 m=1
M20 VB5 VB4 VB3 VSS nch l=0.15 w=1 nf=1 m=1
M21 VB4 VB3 VSS VSS nch l=0.15 w=1 nf=1 m=1
M22 VB3 net5 VSS VSS nch l=0.15 w=1 nf=1 m=1
M23 net5 net5 VSS VSS nch l=0.15 w=1 nf=1 m=1
M24 VB6 VB6 VB7 VSS nch l=0.15 w=1 nf=1 m=1
M25 VB7 VB7 VSS VSS nch l=0.15 w=1 nf=1 m=1
M3 net1 VG VDD VDD pch l=0.15 w=1 nf=1 m=1
M4 VZ VG VDD VDD pch l=0.15 w=1 nf=1 m=1
M5 net4 VB1 VDD VDD pch l=0.15 w=1 nf=1 m=1
M6 net6 VB1 VDD VDD pch l=0.15 w=1 nf=1 m=1
M7 VG VB2 net4 VDD pch l=0.15 w=1 nf=1 m=1
M8 VZ VB2 net6 VDD pch l=0.15 w=1 nf=1 m=1
M9 VG VB6 net2 VSS nch l=0.15 w=1 nf=1 m=1
Q1 VSS VSS net1 qpnp m=1
Q2 VSS net1 X qpnp m=1
Q3 VSS VSS VZ qpnp m=1
Q4 VSS VZ net3 qpnp m=1
R1 Y net3 1k
R2 Vout Y 1k
.ends dut
