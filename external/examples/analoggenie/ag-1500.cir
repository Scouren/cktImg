* official Analog Canvas netlist; PDK X cards rewritten by convert.py
.model nch nmos
.model pch pmos
.model qnpn npn

.subckt opamp VDD VSS VB1 INP INN OUT VB2
M1 net2 INP net6 VDD pch l=0.15 w=1 nf=1 m=1
M10 net5 VB4 VSS VSS nch l=0.15 w=1 nf=1 m=1
M11 net6 VB1 VDD VDD pch l=0.15 w=1 nf=1 m=1
M12 net3 net3 net1 VDD pch l=0.15 w=1 nf=1 m=1
M13 VB3 net3 VDD VDD pch l=0.15 w=1 nf=1 m=1
M14 VB3 VB3 VB4 VSS nch l=0.15 w=1 nf=1 m=1
M15 VB4 VB4 VSS VSS nch l=0.15 w=1 nf=1 m=1
M2 net5 INN net6 VDD pch l=0.15 w=1 nf=1 m=1
M3 net4 VX VDD VDD pch l=0.15 w=1 nf=1 m=1
M4 net0 VX VDD VDD pch l=0.15 w=1 nf=1 m=1
M5 VX VB2 net4 VDD pch l=0.15 w=1 nf=1 m=1
M6 OUT VB2 net0 VDD pch l=0.15 w=1 nf=1 m=1
M7 VX VB3 net2 VSS nch l=0.15 w=1 nf=1 m=1
M8 OUT VB3 net5 VSS nch l=0.15 w=1 nf=1 m=1
M9 net2 VB4 VSS VSS nch l=0.15 w=1 nf=1 m=1
R4 VDD net1 1k
R5 net3 VSS 1k
.ends opamp

.subckt dut VDD VSS Vout VB1 VB2
Q1 X X VSS VSS qnpn m=1
Q2 net0 net0 VSS VSS qnpn m=1
R1 Vout X 1k
R2 Vout Y 1k
R3 Y net0 1k
X1 VDD VSS VB1 X Y Vout VB2 opamp
.ends dut
