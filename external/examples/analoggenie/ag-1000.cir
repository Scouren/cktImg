* official Analog Canvas netlist; PDK X cards rewritten by convert.py
.model nch nmos
.model pch pmos

.subckt dut VDD VSS vin- vin+ vout GND phi1 phi2
.model ideal_switch SW(RON=1 ROFF=1e12 VT=0.5 VH=0)
C1 net6 net7 1p
C2 net7 net1 1p
IB net8 net3 DC 1m
M1 net4 net0 VSS VSS nch l=0.15 w=1 nf=1 m=1
M2 vout net3 net4 VSS nch l=0.15 w=1 nf=1 m=1
M3 vout net8 net2 VDD pch l=0.15 w=1 nf=1 m=1
M4 net2 net10 VDD VDD pch l=0.15 w=1 nf=1 m=1
M5 net9 net9 VSS VSS nch l=0.15 w=1 nf=1 m=1
M6 net3 net3 net9 VSS nch l=0.15 w=1 nf=1 m=1
M7 net8 net8 net5 VDD pch l=0.15 w=1 nf=1 m=1
M8 net5 net5 VDD VDD pch l=0.15 w=1 nf=1 m=1
S1 net5 net6 phi1 GND ideal_switch
S2 net6 net10 phi2 GND ideal_switch
S3 vin- net7 phi2 GND ideal_switch
S4 net7 vin+ phi1 GND ideal_switch
S5 net9 net1 phi1 GND ideal_switch
S6 net1 net0 phi2 GND ideal_switch
.ends dut
