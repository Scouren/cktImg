* official Analog Canvas netlist; PDK X cards rewritten by convert.py
.model nch nmos
.model pch pmos

.subckt dut VDD VSS VP VB1 VB3 VREF VB2 VB5 VB4 VS5 VS1 VS2 VIN VS4 VS3
.model DIODE D(IS=1e-14 N=1)
CFLY VX1 VX2 1p
CO VP VN 1p
COP VP VSS 1p
D1 VN VX2 DIODE
L1 VX1 VX3 1n
M1 VX1 VS1 VIN VDD pch l=0.15 w=1 nf=1 m=1
M2 VX2 VS2 VIN VDD pch l=0.15 w=1 nf=1 m=1
M3 VP VS3 VX3 VDD pch l=0.15 w=1 nf=1 m=1
M4 VX3 VS4 VSS VSS nch l=0.15 w=1 nf=1 m=1
M5 VSR VS5 VIN VDD pch l=0.15 w=1 nf=1 m=1
MN1 net3 VREF net6 VSS nch l=0.15 w=1 nf=1 m=1
MN10 net1 VB6 VDR3 VSS nch l=0.15 w=1 nf=1 m=1
MN11 net2 VB6 VSS VSS nch l=0.15 w=1 nf=1 m=1
MN12 VB6 VB6 net2 VSS nch l=0.15 w=1 nf=1 m=1
MN13 VB7 VB4 VSS VSS nch l=0.15 w=1 nf=1 m=1
MN14 net4 VB4 VSS VSS nch l=0.15 w=1 nf=1 m=1
MN2 net7 VFP1 net6 VSS nch l=0.15 w=1 nf=1 m=1
MN3 net6 VB2 VSS VSS nch l=0.15 w=1 nf=1 m=1
MN4 net5 net1 VSS VSS nch l=0.15 w=1 nf=1 m=1
MN5 VDR3 net1 VSS VSS nch l=0.15 w=1 nf=1 m=1
MN6 net0 VDR3 VSS VSS nch l=0.15 w=1 nf=1 m=1
MN7 VDR3 VDR3 VSS VSS nch l=0.15 w=1 nf=1 m=1
MN8 VDR3 VB5 VSS VSS nch l=0.15 w=1 nf=1 m=1
MN9 VCTRL VB6 net5 VSS nch l=0.15 w=1 nf=1 m=1
MP1 net3 VB1 VDD VDD pch l=0.15 w=1 nf=1 m=1
MP10 VB4 VB7 VDD VDD pch l=0.15 w=1 nf=1 m=1
MP2 net7 VB1 VDD VDD pch l=0.15 w=1 nf=1 m=1
MP3 VCTRL VB3 net3 VDD pch l=0.15 w=1 nf=1 m=1
MP4 net0 net0 VSR VDD pch l=0.15 w=1 nf=1 m=1
MP5 VX1 net0 VSR VDD pch l=0.15 w=1 nf=1 m=1
MP6 net1 VB3 net7 VDD pch l=0.15 w=1 nf=1 m=1
MP7 VDR3 VCTRL VSR VDD pch l=0.15 w=1 nf=1 m=1
MP8 VB6 VB7 VDD VDD pch l=0.15 w=1 nf=1 m=1
MP9 VB7 VB7 VDD VDD pch l=0.15 w=1 nf=1 m=1
R1 VP VFP1 1k
R2 VFP1 VSS 1k
RBIAS VB4 net4 1k
.ends dut
