* official Analog Canvas netlist; PDK X cards rewritten by convert.py
.model nch nmos
.model pch pmos
.model qpnp pnp

.subckt dut VDD VSS Vout VB1 VB2 VB3
M10 net9 VP VDD VDD pch l=0.15 w=1 nf=1 m=1
M11 Vout VB1 net9 VDD pch l=0.15 w=1 nf=1 m=1
M12 VP VB4 net8 VSS nch l=0.15 w=1 nf=1 m=1
M13 net6 VB4 Y VSS nch l=0.15 w=1 nf=1 m=1
M14 net4 VB4 net0 VSS nch l=0.15 w=1 nf=1 m=1
M15 Vout VB4 VZ VSS nch l=0.15 w=1 nf=1 m=1
M16 net8 net6 VSS VSS nch l=0.15 w=1 nf=1 m=1
M17 Y net6 VSS VSS nch l=0.15 w=1 nf=1 m=1
M18 net0 net4 VSS VSS nch l=0.15 w=1 nf=1 m=1
M19 VZ net4 VSS VSS nch l=0.15 w=1 nf=1 m=1
M20 VB3 net3 VDD VDD pch l=0.15 w=1 nf=1 m=1
M21 net3 net3 VDD VDD pch l=0.15 w=1 nf=1 m=1
M22 VB4 net3 VDD VDD pch l=0.15 w=1 nf=1 m=1
M23 VB3 VB3 VSS VSS nch l=0.15 w=1 nf=1 m=1
M24 net3 VB3 VSS VSS nch l=0.15 w=1 nf=1 m=1
M25 VB4 VB4 net7 VSS nch l=0.15 w=1 nf=1 m=1
M26 net7 VB4 VSS VSS nch l=0.15 w=1 nf=1 m=1
M5 net2 VP VDD VDD pch l=0.15 w=1 nf=1 m=1
M6 VP VB1 net2 VDD pch l=0.15 w=1 nf=1 m=1
M7 net5 VB2 VDD VDD pch l=0.15 w=1 nf=1 m=1
M8 net6 X net5 VDD pch l=0.15 w=1 nf=1 m=1
M9 net4 Y net5 VDD pch l=0.15 w=1 nf=1 m=1
Q1 VSS VSS VZ qpnp m=1
Q2 VZ VZ X qpnp m=1
Q3 VSS VSS net10 qpnp m=1
Q4 net10 net10 net1 qpnp m=1
R1 Vout X 1k
R2 Vout Y 1k
R3 Y net1 1k
.ends dut
