* official Analog Canvas netlist; PDK X cards rewritten by convert.py
.model nch nmos
.model pch pmos

.subckt dut VDD VSS Vin Vout Vb
L1 VDD net0 1n
L2 Vout VSS 1n
M1 net0 net1 VSS VSS nch l=0.15 w=1 nf=1 m=1
M2 Vout Vb net0 VDD pch l=0.15 w=1 nf=1 m=1
RS Vin net1 1k
.ends dut
