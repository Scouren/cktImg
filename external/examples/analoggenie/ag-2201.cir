* official Analog Canvas netlist; PDK X cards rewritten by convert.py
.model nch nmos
.model pch pmos

.subckt Opamp VDD VSS INP INN OUT
M1 net4 net4 VDD VDD pch l=0.15 w=1 nf=1 m=1
M10 net2 net0 VSS VSS nch l=0.15 w=1 nf=1 m=1
M11 net6 VB1 VDD VDD pch l=0.15 w=1 nf=1 m=1
M12 net0 VB2 net6 VDD pch l=0.15 w=1 nf=1 m=1
M13 net0 VB3 net1 VSS nch l=0.15 w=1 nf=1 m=1
M14 net1 net0 VSS VSS nch l=0.15 w=1 nf=1 m=1
M15 net6 INN OUT VSS nch l=0.15 w=1 nf=1 m=1
M2 VB3 net4 VDD VDD pch l=0.15 w=1 nf=1 m=1
M3 VB3 VB3 net3 VSS nch l=0.15 w=1 nf=1 m=1
M4 net3 net3 VSS VSS nch l=0.15 w=1 nf=1 m=1
M5 net5 INP OUT VSS nch l=0.15 w=1 nf=1 m=1
M6 OUT net3 VSS VSS nch l=0.15 w=1 nf=1 m=1
M7 net5 VB1 VDD VDD pch l=0.15 w=1 nf=1 m=1
M8 OUT VB2 net5 VDD pch l=0.15 w=1 nf=1 m=1
M9 OUT VB3 net2 VSS nch l=0.15 w=1 nf=1 m=1
RB net4 VSS 1k
.ends Opamp

.subckt dut VDD VSS Vref VIN VOUT
CL VOUT net0 1p
MNP VIN net1 VOUT VSS nch l=0.15 w=1 nf=1 m=1
R1 VOUT FB 1k
R2 FB VSS 1k
R3 net0 VSS 1k
X1 VDD VSS Vref FB net1 Opamp
.ends dut
