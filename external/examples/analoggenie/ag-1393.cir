* official Analog Canvas netlist; PDK X cards rewritten by convert.py
.model nch nmos
.model pch pmos

.subckt cmp VDD VSS VB1 VB2 INN OUT
M1 net6 net6 net5 VDD pch l=0.15 w=1 nf=1 m=1
M10 OUT VB3 net4 VSS nch l=0.15 w=1 nf=1 m=1
M11 net1 VB4 VSS VSS nch l=0.15 w=1 nf=1 m=1
M12 net4 VB4 VSS VSS nch l=0.15 w=1 nf=1 m=1
M13 net2 VB1 VDD VDD pch l=0.15 w=1 nf=1 m=1
M14 net1 OUT net2 VDD pch l=0.15 w=1 nf=1 m=1
M15 net4 INN net2 VDD pch l=0.15 w=1 nf=1 m=1
M2 VB3 net6 VDD VDD pch l=0.15 w=1 nf=1 m=1
M3 VB3 VB3 VB4 VSS nch l=0.15 w=1 nf=1 m=1
M4 VB4 VB4 VSS VSS nch l=0.15 w=1 nf=1 m=1
M5 net7 net0 VDD VDD pch l=0.15 w=1 nf=1 m=1
M6 net3 net0 VDD VDD pch l=0.15 w=1 nf=1 m=1
M7 net0 VB2 net7 VDD pch l=0.15 w=1 nf=1 m=1
M8 OUT VB2 net3 VDD pch l=0.15 w=1 nf=1 m=1
M9 net0 VB3 net1 VSS nch l=0.15 w=1 nf=1 m=1
R1 VDD net5 1k
R2 net6 VSS 1k
.ends cmp

.subckt dut VDD VSS VCONT1 VCONT2 VCONT3 VB1 VB2 VSTO VOUT
CL VOUT VSS 1p
CSTO VSTO VSS 1p
LRX net2 net0 1n
MN1 net2 VCONT2 VSS VSS nch l=0.15 w=1 nf=1 m=1
MN2 net0 VCONT3 VSS VSS nch l=0.15 w=1 nf=1 m=1
MP2 net0 net1 VOUT VDD pch l=0.15 w=1 nf=1 m=1
MP3 net2 VCONT1 VSTO VDD pch l=0.15 w=1 nf=1 m=1
X1 VDD VSS VB1 VB2 net0 net1 cmp
.ends dut
