* official Analog Canvas netlist; PDK X cards rewritten by convert.py
.model nch nmos
.model pch pmos

.subckt dut VDD VSS vci phi1 phi2 vco VB1
C1 net3 net5 1p
C2 net4 vco 1p
M1 vci phi1 net3 VSS nch l=0.15 w=1 nf=1 m=1
M10 VB2 VX VDD VDD pch l=0.15 w=1 nf=1 m=1
M11 VX VX VDD VDD pch l=0.15 w=1 nf=1 m=1
M12 net2 net0 VDD VDD pch l=0.15 w=1 nf=1 m=1
M13 net0 net0 VDD VDD pch l=0.15 w=1 nf=1 m=1
M14 VB1 net0 VDD VDD pch l=0.15 w=1 nf=1 m=1
M15 VB2 VB2 VSS VSS nch l=0.15 w=1 nf=1 m=1
M16 VX net2 VSS VSS nch l=0.15 w=1 nf=1 m=1
M17 net2 net2 VSS VSS nch l=0.15 w=1 nf=1 m=1
M18 net0 VB1 net6 VSS nch l=0.15 w=1 nf=1 m=1
M19 VB1 VB1 VSS VSS nch l=0.15 w=1 nf=1 m=1
M2 net3 phi2 VSS VSS nch l=0.15 w=1 nf=1 m=1
M3 net5 phi1 VSS VSS nch l=0.15 w=1 nf=1 m=1
M4 net5 phi2 net4 VSS nch l=0.15 w=1 nf=1 m=1
M5 VX net4 net1 VSS nch l=0.15 w=1 nf=1 m=1
M6 vco VSS net1 VSS nch l=0.15 w=1 nf=1 m=1
M7 net1 VB2 VSS VSS nch l=0.15 w=1 nf=1 m=1
M8 VX VX VDD VDD pch l=0.15 w=1 nf=1 m=1
M9 vco VX VDD VDD pch l=0.15 w=1 nf=1 m=1
R1 net6 VSS 1k
.ends dut
