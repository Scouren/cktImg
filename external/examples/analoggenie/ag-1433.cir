* official Analog Canvas netlist; PDK X cards rewritten by convert.py
.model nch nmos
.model pch pmos

.subckt comp VDD VSS INN VBN OUT
M1 net1 INN net0 VSS nch l=0.15 w=1 nf=1 m=1
M2 OUT OUT net0 VSS nch l=0.15 w=1 nf=1 m=1
M3 net0 VBN VSS VSS nch l=0.15 w=1 nf=1 m=1
M4 net1 net1 VDD VDD pch l=0.15 w=1 nf=1 m=1
M5 net2 net1 VDD VDD pch l=0.15 w=1 nf=1 m=1
M6 OUT OUT VDD VDD pch l=0.15 w=1 nf=1 m=1
M7 OUT OUT VDD VDD pch l=0.15 w=1 nf=1 m=1
M8 net2 net2 VSS VSS nch l=0.15 w=1 nf=1 m=1
M9 OUT net2 VSS VSS nch l=0.15 w=1 nf=1 m=1
.ends comp

.subckt dut VDD VSS VSTO VCONT1 VCONT2 VCONT3 VOUT VB2 VB1
CL VOUT VSS 1p
CSTO VSTO VSS 1p
LRX net4 net2 1n
M1 net1 net1 VDD VDD pch l=0.15 w=1 nf=1 m=1
M10 VB2 net5 net0 VSS nch l=0.15 w=1 nf=1 m=1
M2 VBN net1 VDD VDD pch l=0.15 w=1 nf=1 m=1
M3 net1 net0 VSS VSS nch l=0.15 w=1 nf=1 m=1
M4 VBN VBN VSS VSS nch l=0.15 w=1 nf=1 m=1
M5 VB1 VB1 VDD VDD pch l=0.15 w=1 nf=1 m=1
M6 VB1 VBN VSS VSS nch l=0.15 w=1 nf=1 m=1
M7 net5 VB2 VDD VDD pch l=0.15 w=1 nf=1 m=1
M8 VB2 VB2 VDD VDD pch l=0.15 w=1 nf=1 m=1
M9 net5 net0 VSS VSS nch l=0.15 w=1 nf=1 m=1
MN1 net4 VCONT2 VSS VSS nch l=0.15 w=1 nf=1 m=1
MN2 net2 VCONT3 VSS VSS nch l=0.15 w=1 nf=1 m=1
MP2 net2 net3 VOUT VDD pch l=0.15 w=1 nf=1 m=1
MP3 net4 VCONT1 VSTO VDD pch l=0.15 w=1 nf=1 m=1
R1 net0 VSS 1k
X1 VDD VSS net2 VBN net3 comp
.ends dut
