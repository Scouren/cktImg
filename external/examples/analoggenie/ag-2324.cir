* official Analog Canvas netlist; PDK X cards rewritten by convert.py
.model nch nmos
.model pch pmos

.subckt bias VDD VSS VBN
M22 VBN VP VDD VDD pch l=0.15 w=1 nf=1 m=1
M23 VBN VBN net1 VSS nch l=0.15 w=1 nf=1 m=1
M24 net1 VBN VSS VSS nch l=0.15 w=1 nf=1 m=1
M25 net0 VP VDD VDD pch l=0.15 w=1 nf=1 m=1
M26 net0 net0 VSS VSS nch l=0.15 w=1 nf=1 m=1
M27 VP VP VDD VDD pch l=0.15 w=1 nf=1 m=1
M28 VP VB5 VB4 VSS nch l=0.15 w=1 nf=1 m=1
M29 VB4 net0 VSS VSS nch l=0.15 w=1 nf=1 m=1
M30 VB5 VP VDD VDD pch l=0.15 w=1 nf=1 m=1
M31 VB5 VB4 VSS VSS nch l=0.15 w=1 nf=1 m=1
.ends bias

.subckt dut VDD VSS VB1 VREF VB6 IB1 VIN FB VOUT
CL VOUT net4 1p
M10 EAO VB3 VY VDD pch l=0.15 w=1 nf=1 m=1
M11 net5 VX VDD VDD pch l=0.15 w=1 nf=1 m=1
M12 VY VX VDD VDD pch l=0.15 w=1 nf=1 m=1
M13 net2 VB6 VDD VDD pch l=0.15 w=1 nf=1 m=1
M14 VX EAO net2 VDD pch l=0.15 w=1 nf=1 m=1
M15 VX VX VSS VSS nch l=0.15 w=1 nf=1 m=1
M16 GATE VX VSS VSS nch l=0.15 w=1 nf=1 m=1
M17 VDD net2 GATE VSS nch l=0.15 w=1 nf=1 m=1
M18 VY EAO IB1 VSS nch l=0.15 w=1 nf=1 m=1
M19 VY VY VDD VDD pch l=0.15 w=1 nf=1 m=1
M2 net0 VB1 VDD VDD pch l=0.15 w=1 nf=1 m=1
M20 GATE VY VDD VDD pch l=0.15 w=1 nf=1 m=1
M21 VSS IB1 GATE VDD pch l=0.15 w=1 nf=1 m=1
M3 net3 VREF net0 VDD pch l=0.15 w=1 nf=1 m=1
M4 net1 FB net0 VDD pch l=0.15 w=1 nf=1 m=1
M5 net3 VB2 VSS VSS nch l=0.15 w=1 nf=1 m=1
M6 net1 VB2 VSS VSS nch l=0.15 w=1 nf=1 m=1
M7 VX VBN net3 VSS nch l=0.15 w=1 nf=1 m=1
M8 EAO VBN net1 VSS nch l=0.15 w=1 nf=1 m=1
M9 VX VB3 net5 VDD pch l=0.15 w=1 nf=1 m=1
MNP VIN GATE VOUT VSS nch l=0.15 w=1 nf=1 m=1
R1 FB VSS 1k
R2 VOUT FB 1k
R3 net4 VSS 1k
RL VOUT VSS 1k
X1 VDD VSS VBN bias
.ends dut
