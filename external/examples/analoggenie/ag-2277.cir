* official Analog Canvas netlist; PDK X cards rewritten by convert.py
.model nch nmos
.model pch pmos

.subckt bias VDD VSS VB3 VB5
M1 VBP VBP VDD VDD pch l=0.15 w=1 nf=1 m=1
M10 VB3 VB3 VSS VSS nch l=0.15 w=1 nf=1 m=1
M11 VB5 VBP VDD VDD pch l=0.15 w=1 nf=1 m=1
M12 VB5 VB5 net1 VSS nch l=0.15 w=1 nf=1 m=1
M13 net1 VB5 VSS VSS nch l=0.15 w=1 nf=1 m=1
M2 VBP net4 VSS VSS nch l=0.15 w=1 nf=1 m=1
M3 net3 VBP VDD VDD pch l=0.15 w=1 nf=1 m=1
M4 net3 net3 net4 VSS nch l=0.15 w=1 nf=1 m=1
M5 net4 net3 net0 VSS nch l=0.15 w=1 nf=1 m=1
M6 net2 VBP VDD VDD pch l=0.15 w=1 nf=1 m=1
M7 net2 net2 net0 VSS nch l=0.15 w=1 nf=1 m=1
M8 net0 net2 VB3 VSS nch l=0.15 w=1 nf=1 m=1
M9 VB3 VBP VDD VDD pch l=0.15 w=1 nf=1 m=1
.ends bias

.subckt dut VDD VSS VB1 VB2 VREF VB4 IBUF VIN VOUT VB3
CL VOUT net5 1p
M1 net6 net1 VDD VDD pch l=0.15 w=1 nf=1 m=1
M10 EAO VB1 net2 VDD pch l=0.15 w=1 nf=1 m=1
M11 net8 net1 VDD VDD pch l=0.15 w=1 nf=1 m=1
M12 net2 net7 VDD VDD pch l=0.15 w=1 nf=1 m=1
M13 VX VB4 VDD VDD pch l=0.15 w=1 nf=1 m=1
M14 net3 EAO VX VDD pch l=0.15 w=1 nf=1 m=1
M15 net3 net3 VSS VSS nch l=0.15 w=1 nf=1 m=1
M16 GATE net3 VSS VSS nch l=0.15 w=1 nf=1 m=1
M17 VDD VX GATE VSS nch l=0.15 w=1 nf=1 m=1
M18 net0 EAO IBUF VSS nch l=0.15 w=1 nf=1 m=1
M19 net0 net0 VDD VDD pch l=0.15 w=1 nf=1 m=1
M2 VX VB2 VSS VSS nch l=0.15 w=1 nf=1 m=1
M20 GATE net0 VDD VDD pch l=0.15 w=1 nf=1 m=1
M21 VSS IBUF GATE VDD pch l=0.15 w=1 nf=1 m=1
M22 net4 net7 VDD VDD pch l=0.15 w=1 nf=1 m=1
M23 net1 VB1 net6 VDD pch l=0.15 w=1 nf=1 m=1
M24 net7 VB1 net4 VDD pch l=0.15 w=1 nf=1 m=1
M25 VIN GATE VOUT VSS nch l=0.15 w=1 nf=1 m=1
M3 net7 VREF VX VSS nch l=0.15 w=1 nf=1 m=1
M4 net1 FB VX VSS nch l=0.15 w=1 nf=1 m=1
M5 net11 net10 VSS VSS nch l=0.15 w=1 nf=1 m=1
M6 net9 net10 VSS VSS nch l=0.15 w=1 nf=1 m=1
M7 net10 VB5 net11 VSS nch l=0.15 w=1 nf=1 m=1
M8 EAO VB5 net9 VSS nch l=0.15 w=1 nf=1 m=1
M9 net10 VB1 net8 VDD pch l=0.15 w=1 nf=1 m=1
R1 FB VSS 1k
R2 VOUT FB 1k
R3 net5 VSS 1k
RL VOUT VSS 1k
X1 VDD VSS VB3 VB5 bias
.ends dut
