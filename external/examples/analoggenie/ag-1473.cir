* official Analog Canvas netlist; PDK X cards rewritten by convert.py
.model nch nmos
.model pch pmos
.model qnpn npn

.subckt opamp VDD VSS VB1 VB2 INP INN VBN OUT
M1 net1 VP VDD VDD pch l=0.15 w=1 nf=1 m=1
M10 net0 net3 VSS VSS nch l=0.15 w=1 nf=1 m=1
M11 net8 VP VDD VDD pch l=0.15 w=1 nf=1 m=1
M12 OUT VB1 net8 VDD pch l=0.15 w=1 nf=1 m=1
M13 OUT VBN net6 VSS nch l=0.15 w=1 nf=1 m=1
M14 net6 net3 VSS VSS nch l=0.15 w=1 nf=1 m=1
M15 net2 VB2 VDD VDD pch l=0.15 w=1 nf=1 m=1
M2 VP VB1 net1 VDD pch l=0.15 w=1 nf=1 m=1
M3 VP VBN net4 VSS nch l=0.15 w=1 nf=1 m=1
M4 net4 net7 VSS VSS nch l=0.15 w=1 nf=1 m=1
M5 net7 INP net2 VDD pch l=0.15 w=1 nf=1 m=1
M6 net7 VBN net5 VSS nch l=0.15 w=1 nf=1 m=1
M7 net5 net7 VSS VSS nch l=0.15 w=1 nf=1 m=1
M8 net3 INN net2 VDD pch l=0.15 w=1 nf=1 m=1
M9 net3 VBN net0 VSS nch l=0.15 w=1 nf=1 m=1
.ends opamp

.subckt dut VDD VSS Vout VB1 VB2
M16 net2 net2 net3 VDD pch l=0.15 w=1 nf=1 m=1
M17 VBN net2 VDD VDD pch l=0.15 w=1 nf=1 m=1
M18 VBN VBN Z VSS nch l=0.15 w=1 nf=1 m=1
M19 Z VBN VSS VSS nch l=0.15 w=1 nf=1 m=1
Q1 net0 net0 VSS VSS qnpn m=1
Q2 Z Z VSS VSS qnpn m=1
R1 Vout net0 1k
R2 Vout net1 1k
R3 net1 Z 1k
R4 VDD net3 1k
R5 net2 VSS 1k
X1 VDD VSS VB1 VB2 net0 net1 VBN Vout opamp
.ends dut
