* official Analog Canvas netlist; PDK X cards rewritten by convert.py
.model nch nmos

.subckt dut VDD VSS LO LO_bar VBBp VBBn X Y
M1 X LO VBBn VSS nch l=0.15 w=1 nf=1 m=1
M2 Y LO VBBp VSS nch l=0.15 w=1 nf=1 m=1
M3 X LO_bar VBBp VSS nch l=0.15 w=1 nf=1 m=1
M4 Y LO_bar VBBn VSS nch l=0.15 w=1 nf=1 m=1
.ends dut
