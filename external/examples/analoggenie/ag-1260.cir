* official Analog Canvas netlist; PDK X cards rewritten by convert.py
.model nch nmos
.model pch pmos

.subckt EA1 VDD VSS INN INP OUT VX3 VX2
MB1 VB1 VB1 VDD VDD pch l=0.15 w=1 nf=1 m=1
MB2 VB4 VB1 VDD VDD pch l=0.15 w=1 nf=1 m=1
MB3 VB1 VBN VSS VSS nch l=0.15 w=1 nf=1 m=1
MB4 VB4 VB4 VSS VSS nch l=0.15 w=1 nf=1 m=1
MB5 VB2 VB2 VDD VDD pch l=0.15 w=1 nf=1 m=1
MB6 VBN VB2 VDD VDD pch l=0.15 w=1 nf=1 m=1
MB7 VBN VBN VSS VSS nch l=0.15 w=1 nf=1 m=1
MB8 VB2 VBN VX2 VSS nch l=0.15 w=1 nf=1 m=1
MN1 net0 INN net1 VSS nch l=0.15 w=1 nf=1 m=1
MN2 VX3 INP net1 VSS nch l=0.15 w=1 nf=1 m=1
MN3 VG VG VSS VSS nch l=0.15 w=1 nf=1 m=1
MN4 net1 VB4 VSS VSS nch l=0.15 w=1 nf=1 m=1
MN5 OUT VG VSS VSS nch l=0.15 w=1 nf=1 m=1
MP1 net0 net0 VDD VDD pch l=0.15 w=1 nf=1 m=1
MP2 VX3 VX3 VDD VDD pch l=0.15 w=1 nf=1 m=1
MP3 OUT VX3 VDD VDD pch l=0.15 w=1 nf=1 m=1
MP7 VG net0 VDD VDD pch l=0.15 w=1 nf=1 m=1
RBIAS VX2 VSS 1k
.ends EA1

.subckt ISR VDD VSS VS VCTRL VB3 IOUT
MN6 net0 net1 VSS VSS nch l=0.15 w=1 nf=1 m=1
MN7 net1 net1 VSS VSS nch l=0.15 w=1 nf=1 m=1
MN8 net1 VB3 VSS VSS nch l=0.15 w=1 nf=1 m=1
MP4 net0 net0 VS VDD pch l=0.15 w=1 nf=1 m=1
MP5 IOUT net0 VS VDD pch l=0.15 w=1 nf=1 m=1
MP6 net1 VCTRL VS VDD pch l=0.15 w=1 nf=1 m=1
.ends ISR

.subckt dut VDD VSS VIN VP VCONT1 VCONT2 VCONT3 VCONT4 VCONT5 VREF VB3
.model DIODE D(IS=1e-14 N=1)
CFLY VX1 VX2 1p
CO VP VN 1p
COP VP VSS 1p
D1 VN VX2 DIODE
L1 VX1 VX3 1n
M1 VX1 VCONT2 VIN VDD pch l=0.15 w=1 nf=1 m=1
M2 VX2 VCONT3 VIN VDD pch l=0.15 w=1 nf=1 m=1
M3 VP VCONT5 VX3 VDD pch l=0.15 w=1 nf=1 m=1
M4 VX3 VCONT4 VSS VSS nch l=0.15 w=1 nf=1 m=1
M5 net1 VCONT1 VIN VDD pch l=0.15 w=1 nf=1 m=1
R1 VP VFP1 1k
R2 VFP1 VSS 1k
X1 VDD VSS VFP1 VREF net0 VX3 VX2 EA1
X2 VDD VSS net1 net0 VB3 VX1 ISR
.ends dut
