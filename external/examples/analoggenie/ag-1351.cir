* official Analog Canvas netlist; PDK X cards rewritten by convert.py
.model nch nmos
.model pch pmos

.subckt EA VDD VSS INN INP OUT
M1 VB1 VB1 VDD VDD pch l=0.15 w=1 nf=1 m=1
M10 net3 VBP VDD VDD pch l=0.15 w=1 nf=1 m=1
M11 net3 net3 net1 VSS nch l=0.15 w=1 nf=1 m=1
M12 net1 net3 VB2 VSS nch l=0.15 w=1 nf=1 m=1
M13 net0 VBP VDD VDD pch l=0.15 w=1 nf=1 m=1
M14 net0 net0 VX VSS nch l=0.15 w=1 nf=1 m=1
M15 VX net0 net1 VSS nch l=0.15 w=1 nf=1 m=1
M16 VB2 VBP VDD VDD pch l=0.15 w=1 nf=1 m=1
M17 VB2 VB2 VSS VSS nch l=0.15 w=1 nf=1 m=1
M2 OUT VB1 VDD VDD pch l=0.15 w=1 nf=1 m=1
M3 VB1 INN net2 VSS nch l=0.15 w=1 nf=1 m=1
M4 OUT INP net2 VSS nch l=0.15 w=1 nf=1 m=1
M5 net2 VBN VSS VSS nch l=0.15 w=1 nf=1 m=1
M6 VBN VBP VDD VDD pch l=0.15 w=1 nf=1 m=1
M7 VBP VBP VDD VDD pch l=0.15 w=1 nf=1 m=1
M8 VBN VBN VSS VSS nch l=0.15 w=1 nf=1 m=1
M9 VBP VX VSS VSS nch l=0.15 w=1 nf=1 m=1
.ends EA

.subckt dut VDD VSS VCONT1 VB3 VIN VCONT2 VCONT4 VCONT5 VP VCONT3 VREF
.model DIODE D(IS=1e-14 N=1)
CFLY VX1 VX2 1p
CO VP VN 1p
COP VP VSS 1p
D1 VN VX2 DIODE
L1 VX1 VX3 1n
M1 VX1 VCONT2 VIN VDD pch l=0.15 w=1 nf=1 m=1
M10 net2 net2 VSS VSS nch l=0.15 w=1 nf=1 m=1
M11 net2 VB3 VSS VSS nch l=0.15 w=1 nf=1 m=1
M2 VX2 VCONT3 VIN VDD pch l=0.15 w=1 nf=1 m=1
M3 VP VCONT5 VX3 VDD pch l=0.15 w=1 nf=1 m=1
M4 VX3 VCONT4 VSS VSS nch l=0.15 w=1 nf=1 m=1
M5 net0 VCONT1 VIN VDD pch l=0.15 w=1 nf=1 m=1
M6 VX1 net1 net0 VDD pch l=0.15 w=1 nf=1 m=1
M7 net1 net1 net0 VDD pch l=0.15 w=1 nf=1 m=1
M8 net2 net3 net0 VDD pch l=0.15 w=1 nf=1 m=1
M9 net1 net2 VSS VSS nch l=0.15 w=1 nf=1 m=1
R1 VP VFP1 1k
R2 VFP1 VSS 1k
X1 VDD VSS VFP1 VREF net3 EA
.ends dut
