* official Analog Canvas netlist; PDK X cards rewritten by convert.py
.model nch nmos
.model pch pmos

.subckt comparator VDD VSS INN OUT
M1 OUT OUT VDD VDD pch l=0.15 w=1 nf=1 m=1
M10 VB3 VB1 VDD VDD pch l=0.15 w=1 nf=1 m=1
M11 VB1 VB1 VDD VDD pch l=0.15 w=1 nf=1 m=1
M12 net5 net0 VDD VDD pch l=0.15 w=1 nf=1 m=1
M13 net0 net0 VDD VDD pch l=0.15 w=1 nf=1 m=1
M14 net3 net0 VDD VDD pch l=0.15 w=1 nf=1 m=1
M15 VB3 VB3 VSS VSS nch l=0.15 w=1 nf=1 m=1
M16 VB1 net5 VSS VSS nch l=0.15 w=1 nf=1 m=1
M17 net5 net5 VSS VSS nch l=0.15 w=1 nf=1 m=1
M18 net0 net3 VB2 VSS nch l=0.15 w=1 nf=1 m=1
M19 net3 VB2 VSS VSS nch l=0.15 w=1 nf=1 m=1
M2 OUT OUT VDD VDD pch l=0.15 w=1 nf=1 m=1
M3 OUT net1 VSS VSS nch l=0.15 w=1 nf=1 m=1
M4 net1 net1 VSS VSS nch l=0.15 w=1 nf=1 m=1
M5 net1 net2 VDD VDD pch l=0.15 w=1 nf=1 m=1
M6 net2 net2 VDD VDD pch l=0.15 w=1 nf=1 m=1
M7 net2 INN net4 VSS nch l=0.15 w=1 nf=1 m=1
M8 OUT OUT net4 VSS nch l=0.15 w=1 nf=1 m=1
M9 net4 VB3 VSS VSS nch l=0.15 w=1 nf=1 m=1
R1 VB2 VSS 1k
.ends comparator

.subckt dut VDD VSS VSTO VCONT1 VCONT2 VCONT3 VOUT
CL VOUT VSS 1p
CSTO VSTO VSS 1p
LRX net0 net2 1n
MN1 net0 VCONT2 VSS VSS nch l=0.15 w=1 nf=1 m=1
MN2 net2 VCONT3 VSS VSS nch l=0.15 w=1 nf=1 m=1
MP2 net2 net1 VOUT VDD pch l=0.15 w=1 nf=1 m=1
MP3 net0 VCONT1 VSTO VDD pch l=0.15 w=1 nf=1 m=1
X1 VDD VSS net2 net1 comparator
.ends dut
