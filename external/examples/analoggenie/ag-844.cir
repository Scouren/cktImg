* official Analog Canvas netlist; PDK X cards rewritten by convert.py
.model nch nmos
.model pch pmos

.subckt dut VDD VSS Vi1 Vi2 Vo1 Vo2
IREF1 net0 VSS DC 1m
IREF2 VDD net2 DC 1m
M1 Vo1 Vi1 net1 VSS nch l=0.15 w=1 nf=1 m=1
M2 Vo2 Vi2 net1 VSS nch l=0.15 w=1 nf=1 m=1
M3 Vo1 net0 VDD VDD pch l=0.15 w=1 nf=1 m=1
M4 Vo2 net0 VDD VDD pch l=0.15 w=1 nf=1 m=1
M5 net0 net0 VDD VDD pch l=0.15 w=1 nf=1 m=1
M6 net2 net2 VSS VSS nch l=0.15 w=1 nf=1 m=1
M7 net1 net2 VSS VSS nch l=0.15 w=1 nf=1 m=1
M8 net1 net2 VSS VSS nch l=0.15 w=1 nf=1 m=1
.ends dut
