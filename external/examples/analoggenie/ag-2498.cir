* official Analog Canvas netlist; PDK X cards rewritten by convert.py
.model nch nmos
.model pch pmos

.subckt dut VIN VSS VB1 VREF VB3 VB2 VB6 VB5 VOUT VB4
CF1 VOUT VFB 1p
Cm1 net4 VOUT 1p
Cm2 net4 VA 1p
M10 net4 VB3 net11 VIN pch l=0.15 w=1 nf=1 m=1
M11 net9 VB1 VIN VIN pch l=0.15 w=1 nf=1 m=1
M12 net6 VFB net9 net2 pch l=0.15 w=1 nf=1 m=1
M13 net5 VREF net9 net2 pch l=0.15 w=1 nf=1 m=1
M14 net6 VB2 VSS VSS nch l=0.15 w=1 nf=1 m=1
M15 net5 VB2 VSS VSS nch l=0.15 w=1 nf=1 m=1
M16 VX VG VIN VIN pch l=0.15 w=1 nf=1 m=1
M17 VG VBN net6 VSS nch l=0.15 w=1 nf=1 m=1
M18 net4 VBN net5 VSS nch l=0.15 w=1 nf=1 m=1
M19 net11 VG VIN VIN pch l=0.15 w=1 nf=1 m=1
M20 VG VB3 VX VIN pch l=0.15 w=1 nf=1 m=1
M21 net1 net4 VSS VSS nch l=0.15 w=1 nf=1 m=1
M22 net7 VN VSS VSS nch l=0.15 w=1 nf=1 m=1
M23 net1 net1 VIN VIN pch l=0.15 w=1 nf=1 m=1
M24 net7 net1 VIN VIN pch l=0.15 w=1 nf=1 m=1
M25 VN net4 VSS VSS nch l=0.15 w=1 nf=1 m=1
M26 VN VN VSS VSS nch l=0.15 w=1 nf=1 m=1
M27 VN VB4 VIN VIN pch l=0.15 w=1 nf=1 m=1
MB1 net0 net0 VIN VIN pch l=0.15 w=1 nf=1 m=1
MB2 VBN net0 VIN VIN pch l=0.15 w=1 nf=1 m=1
MB3 VBN VBN net3 VSS nch l=0.15 w=1 nf=1 m=1
MB4 net3 VBN VSS VSS nch l=0.15 w=1 nf=1 m=1
MD1 VA net4 VSS VSS nch l=0.15 w=1 nf=1 m=1
MD2 VX VB5 VSS VSS nch l=0.15 w=1 nf=1 m=1
MD3 net10 VA VX VSS nch l=0.15 w=1 nf=1 m=1
MD4 net8 VB6 VX VSS nch l=0.15 w=1 nf=1 m=1
MD5 net10 net10 VIN VIN pch l=0.15 w=1 nf=1 m=1
MD6 net8 net8 VIN VIN pch l=0.15 w=1 nf=1 m=1
MD7 VA net8 VIN VIN pch l=0.15 w=1 nf=1 m=1
MPT VOUT net7 VIN VIN pch l=0.15 w=1 nf=1 m=1
RB net0 VSS 1k
RF1 VOUT VFB 1k
RF2 VFB VSS 1k
.ends dut
