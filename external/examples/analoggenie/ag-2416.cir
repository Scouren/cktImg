* official Analog Canvas netlist; PDK X cards rewritten by convert.py
.model nch nmos
.model pch pmos

.subckt dut VDD VSS VIN pb nb VOUT VERR VREF
M1 net6 VEAOUT VIN VDD pch l=0.15 w=1 nf=1 m=1
M10 net1 net1 VDD VDD pch l=0.15 w=1 nf=1 m=1
M11 VEAOUT net1 VDD VDD pch l=0.15 w=1 nf=1 m=1
M12 VEAOUT net4 VDD VDD pch l=0.15 w=1 nf=1 m=1
M13 net4 net4 VDD VDD pch l=0.15 w=1 nf=1 m=1
M14 VEAOUT VEAOUT VSS VSS nch l=0.15 w=1 nf=1 m=1
M15 VEAOUT VEAOUT VSS VSS nch l=0.15 w=1 nf=1 m=1
M16 net1 VREF net8 VSS nch l=0.15 w=1 nf=1 m=1
M17 net4 VEAOUT net8 VSS nch l=0.15 w=1 nf=1 m=1
M18 net8 VB4 VSS VSS nch l=0.15 w=1 nf=1 m=1
M2 net0 net0 net6 VDD pch l=0.15 w=1 nf=1 m=1
M3 net0 nb VSS VSS nch l=0.15 w=1 nf=1 m=1
M4 VB4 net7 VDD VDD pch l=0.15 w=1 nf=1 m=1
M5 net7 net7 VDD VDD pch l=0.15 w=1 nf=1 m=1
M6 net3 net7 VDD VDD pch l=0.15 w=1 nf=1 m=1
M7 VB4 VB4 VSS VSS nch l=0.15 w=1 nf=1 m=1
M8 net7 net3 VSS VSS nch l=0.15 w=1 nf=1 m=1
M9 net9 net3 VSS VSS nch l=0.15 w=1 nf=1 m=1
MBIAS VERR nb VSS VSS nch l=0.15 w=1 nf=1 m=1
MCHG net5 pb VIN VDD pch l=0.15 w=1 nf=1 m=1
MCTRL VERR net0 VOUT VDD pch l=0.15 w=1 nf=1 m=1
MGEN net2 net2 VSS VSS nch l=0.15 w=1 nf=1 m=1
MINJ VERR net2 VSS VSS nch l=0.15 w=1 nf=1 m=1
MRES VOUT VERR VIN VDD pch l=0.15 w=1 nf=1 m=1
MSEN net2 VEAOUT net5 VDD pch l=0.15 w=1 nf=1 m=1
R1 net3 net9 1k
.ends dut
