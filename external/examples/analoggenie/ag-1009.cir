* official Analog Canvas netlist; PDK X cards rewritten by convert.py
.model nch nmos
.model pch pmos

.subckt dut VDD VSS vo1 vo2 vi1 vi2 VBP VBN
C1 vo1 net4 1p
C2 vo2 net1 1p
M1 net2 vi1 net5 VSS nch l=0.15 w=1 nf=1 m=1
M10 net0 vo1 VDD VDD pch l=0.15 w=1 nf=1 m=1
M11 net0 vo2 VDD VDD pch l=0.15 w=1 nf=1 m=1
M2 net3 vi2 net5 VSS nch l=0.15 w=1 nf=1 m=1
M3 net2 VBP VDD VDD pch l=0.15 w=1 nf=1 m=1
M4 net3 VBP VDD VDD pch l=0.15 w=1 nf=1 m=1
M5 net5 VBN VSS VSS nch l=0.15 w=1 nf=1 m=1
M6 vo2 net3 net0 VDD pch l=0.15 w=1 nf=1 m=1
M7 vo1 net2 net0 VDD pch l=0.15 w=1 nf=1 m=1
M8 vo2 VBN VSS VSS nch l=0.15 w=1 nf=1 m=1
M9 vo1 VBN VSS VSS nch l=0.15 w=1 nf=1 m=1
R1 net4 net2 1k
R2 net1 net3 1k
.ends dut
