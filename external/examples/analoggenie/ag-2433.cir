* official Analog Canvas netlist; PDK X cards rewritten by convert.py
.model nch nmos
.model pch pmos

.subckt Bias VDD VSS VB1 VBN
M13 VB1 VB1 VDD VDD pch l=0.15 w=1 nf=1 m=1
M14 VBN VB1 VDD VDD pch l=0.15 w=1 nf=1 m=1
M15 net1 net0 VSS VSS nch l=0.15 w=1 nf=1 m=1
M16 net0 net0 VSS VSS nch l=0.15 w=1 nf=1 m=1
M17 VB1 net0 VSS VSS nch l=0.15 w=1 nf=1 m=1
M18 VBN VBN VSS VSS nch l=0.15 w=1 nf=1 m=1
R1 VDD net1 1k
R2 VDD net0 1k
R3 net1 net0 1k
.ends Bias

.subckt EA VDD VSS VREF OUT NB
M10 OUT OUT VSS VSS nch l=0.15 w=1 nf=1 m=1
M11 net0 OUT net2 VSS nch l=0.15 w=1 nf=1 m=1
M12 net2 NB VSS VSS nch l=0.15 w=1 nf=1 m=1
M4 net1 net1 VDD VDD pch l=0.15 w=1 nf=1 m=1
M5 OUT net1 VDD VDD pch l=0.15 w=1 nf=1 m=1
M6 OUT net0 VDD VDD pch l=0.15 w=1 nf=1 m=1
M7 net0 net0 VDD VDD pch l=0.15 w=1 nf=1 m=1
M8 net1 VREF net2 VSS nch l=0.15 w=1 nf=1 m=1
M9 OUT OUT VSS VSS nch l=0.15 w=1 nf=1 m=1
.ends EA

.subckt dut VDD VSS VIN pb nb VOUT VERR VREF VB1
M1 net3 net2 VIN VDD pch l=0.15 w=1 nf=1 m=1
M2 net1 net1 net3 VDD pch l=0.15 w=1 nf=1 m=1
M3 net1 nb VSS VSS nch l=0.15 w=1 nf=1 m=1
MBIAS VERR nb VSS VSS nch l=0.15 w=1 nf=1 m=1
MCHG net5 pb VIN VDD pch l=0.15 w=1 nf=1 m=1
MCTRL VERR net1 VOUT VDD pch l=0.15 w=1 nf=1 m=1
MGEN net4 net4 VSS VSS nch l=0.15 w=1 nf=1 m=1
MINJ VERR net4 VSS VSS nch l=0.15 w=1 nf=1 m=1
MRES VOUT VERR VIN VDD pch l=0.15 w=1 nf=1 m=1
MSEN net4 net2 net5 VDD pch l=0.15 w=1 nf=1 m=1
X1 VDD VSS VREF net2 net0 EA
X2 VDD VSS VB1 net0 Bias
.ends dut
