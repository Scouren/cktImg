* official Analog Canvas netlist; PDK X cards rewritten by convert.py
.model nch nmos
.model pch pmos

.subckt opamp VDD VSS INP INN OUT
M1 net1 INP net7 net0 pch l=0.15 w=1 nf=1 m=1
M10 net1 VB2 VSS VSS nch l=0.15 w=1 nf=1 m=1
M11 net6 VB2 VSS VSS nch l=0.15 w=1 nf=1 m=1
M12 VX net2 VDD VDD pch l=0.15 w=1 nf=1 m=1
M13 VX VX net8 VSS nch l=0.15 w=1 nf=1 m=1
M14 net8 VX VSS VSS nch l=0.15 w=1 nf=1 m=1
M15 net2 net2 VDD VDD pch l=0.15 w=1 nf=1 m=1
M16 net2 net4 net3 VSS nch l=0.15 w=1 nf=1 m=1
M17 net4 net2 VDD VDD pch l=0.15 w=1 nf=1 m=1
M18 net4 net4 VSS VSS nch l=0.15 w=1 nf=1 m=1
M2 net6 INN net7 net0 pch l=0.15 w=1 nf=1 m=1
M3 net7 VB1 VDD VDD pch l=0.15 w=1 nf=1 m=1
M4 net5 net9 VDD VDD pch l=0.15 w=1 nf=1 m=1
M5 net10 net9 VDD VDD pch l=0.15 w=1 nf=1 m=1
M6 net9 VB3 net5 VDD pch l=0.15 w=1 nf=1 m=1
M7 OUT VB3 net10 VDD pch l=0.15 w=1 nf=1 m=1
M8 net9 VX net1 VSS nch l=0.15 w=1 nf=1 m=1
M9 OUT VX net6 VSS nch l=0.15 w=1 nf=1 m=1
R1 net3 VSS 1k
.ends opamp

.subckt dut VDD VSS Vref VIN VOUT
CL VOUT net0 1p
MNP VIN net2 VOUT VOUT nch l=0.15 w=1 nf=1 m=1
R1 VOUT net1 1k
R2 net1 VSS 1k
R3 net0 VSS 1k
X1 VDD VSS Vref net1 net2 opamp
.ends dut
