* official Analog Canvas netlist; PDK X cards rewritten by convert.py
.model nch nmos
.model pch pmos

.subckt EA VDD VSS VFP1 VREF VCTRL VX2
MN1 VCTRL net7 VSS VSS nch l=0.15 w=1 nf=1 m=1
MN2 net7 net7 VSS VSS nch l=0.15 w=1 nf=1 m=1
MN3 VX2 VX2 VSS VSS nch l=0.15 w=1 nf=1 m=1
MN4 net3 VX2 VSS VSS nch l=0.15 w=1 nf=1 m=1
MN5 VBP net5 VSS VSS nch l=0.15 w=1 nf=1 m=1
MN6 net5 net5 VSS VSS nch l=0.15 w=1 nf=1 m=1
MN7 net4 VBN VSS VSS nch l=0.15 w=1 nf=1 m=1
MN8 net6 VBN VSS VSS nch l=0.15 w=1 nf=1 m=1
MN9 net2 VBN VSS VSS nch l=0.15 w=1 nf=1 m=1
MP1 VCTRL net3 VDD VDD pch l=0.15 w=1 nf=1 m=1
MP10 VBP VBP VDD VDD pch l=0.15 w=1 nf=1 m=1
MP2 net3 net3 VDD VDD pch l=0.15 w=1 nf=1 m=1
MP3 net0 VBP VDD VDD pch l=0.15 w=1 nf=1 m=1
MP4 net7 VFP1 net0 net1 pch l=0.15 w=1 nf=1 m=1
MP5 VX2 VREF net0 net1 pch l=0.15 w=1 nf=1 m=1
MP6 net5 net4 VDD VDD pch l=0.15 w=1 nf=1 m=1
MP7 net4 net4 VDD VDD pch l=0.15 w=1 nf=1 m=1
MP8 VBN net2 VDD VDD pch l=0.15 w=1 nf=1 m=1
MP9 net2 net2 VDD VDD pch l=0.15 w=1 nf=1 m=1
RBIAS VBN net6 1k
.ends EA

.subckt ISR VSS VS IOUT VCTRL VB3
MN10 net0 net0 VSS VSS nch l=0.15 w=1 nf=1 m=1
MN11 net0 VB3 VSS VSS nch l=0.15 w=1 nf=1 m=1
MN12 net1 net0 VSS VSS nch l=0.15 w=1 nf=1 m=1
MP10 net0 VCTRL VS VS pch l=0.15 w=1 nf=1 m=1
MP11 net1 net1 VS VS pch l=0.15 w=1 nf=1 m=1
MP12 IOUT net1 VS VS pch l=0.15 w=1 nf=1 m=1
.ends ISR

.subckt dut VDD VSS VIN VP VCONT1 VCONT2 VCONT3 VCONT4 VCONT5 VB3 VREF
.model DIODE D(IS=1e-14 N=1)
CFLY VX1 VX2 1p
CO VP VN 1p
COP VP VSS 1p
D1 VN VX2 DIODE
L1 VX1 VX3 1n
M1 VX1 VCONT2 VIN VIN pch l=0.15 w=1 nf=1 m=1
M2 VX2 VCONT3 VIN VIN pch l=0.15 w=1 nf=1 m=1
M3 VX3 VCONT4 VSS VSS nch l=0.15 w=1 nf=1 m=1
M4 VX3 VCONT5 VP VP pch l=0.15 w=1 nf=1 m=1
M5 net0 VCONT1 VIN VIN pch l=0.15 w=1 nf=1 m=1
R1 VP VFP1 1k
R2 VFP1 VSS 1k
X1 VSS net0 VX1 net1 VB3 ISR
X2 VDD VSS VFP1 VREF net1 VX2 EA
.ends dut
