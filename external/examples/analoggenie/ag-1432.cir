* official Analog Canvas netlist; PDK X cards rewritten by convert.py
.model nch nmos
.model pch pmos

.subckt comparator VDD VSS VB1 INP OUT
M10 VX net3 VDD VDD pch l=0.15 w=1 nf=1 m=1
M11 VX VX VSS VSS nch l=0.15 w=1 nf=1 m=1
M12 net3 net3 VDD VDD pch l=0.15 w=1 nf=1 m=1
M13 net3 INP net2 VSS nch l=0.15 w=1 nf=1 m=1
M14 net2 VB2 VSS VSS nch l=0.15 w=1 nf=1 m=1
M15 OUT OUT net2 VSS nch l=0.15 w=1 nf=1 m=1
M16 OUT OUT VDD VDD pch l=0.15 w=1 nf=1 m=1
M17 OUT OUT VDD VDD pch l=0.15 w=1 nf=1 m=1
M18 OUT VX VSS VSS nch l=0.15 w=1 nf=1 m=1
M3 net1 net1 VSS VSS nch l=0.15 w=1 nf=1 m=1
M4 net0 net1 VSS VSS nch l=0.15 w=1 nf=1 m=1
M5 net0 net0 VDD VDD pch l=0.15 w=1 nf=1 m=1
M6 VB2 net0 VDD VDD pch l=0.15 w=1 nf=1 m=1
M7 VB2 VB2 VSS VSS nch l=0.15 w=1 nf=1 m=1
M8 VB1 VB2 VSS VSS nch l=0.15 w=1 nf=1 m=1
M9 VB1 VB1 VDD VDD pch l=0.15 w=1 nf=1 m=1
RF VDD net1 1k
.ends comparator

.subckt dut VDD VSS VSTO VCONT1 VCONT2 VCONT3 VOUT VB1
CL VOUT VSS 1p
CSTO VSTO VSS 1p
LRX net1 net0 1n
MN1 net1 VCONT2 VSS VSS nch l=0.15 w=1 nf=1 m=1
MN2 net0 VCONT3 VSS VSS nch l=0.15 w=1 nf=1 m=1
MP2 net0 net2 VOUT VOUT pch l=0.15 w=1 nf=1 m=1
MP3 net1 VCONT1 VSTO VSTO pch l=0.15 w=1 nf=1 m=1
X1 VDD VSS VB1 net0 net2 comparator
.ends dut
