* official Analog Canvas netlist; PDK X cards rewritten by convert.py
.model nch nmos
.model pch pmos

.subckt bias VDD VSS VB3 VB1
M10 VB3 VB4 VDD VDD pch l=0.15 w=1 nf=1 m=1
M11 VB3 VB3 VSS VSS nch l=0.15 w=1 nf=1 m=1
M22 VB4 VB4 VDD VDD pch l=0.15 w=1 nf=1 m=1
M23 VB1 VB4 VDD VDD pch l=0.15 w=1 nf=1 m=1
M24 net3 VB4 VDD VDD pch l=0.15 w=1 nf=1 m=1
M25 net1 VB4 VDD VDD pch l=0.15 w=1 nf=1 m=1
M26 VB4 net2 VSS VSS nch l=0.15 w=1 nf=1 m=1
M27 VB1 VB1 VSS VSS nch l=0.15 w=1 nf=1 m=1
M28 net3 net3 net2 VSS nch l=0.15 w=1 nf=1 m=1
M29 net2 net3 net0 VSS nch l=0.15 w=1 nf=1 m=1
M30 net1 net1 net0 VSS nch l=0.15 w=1 nf=1 m=1
M31 net0 net1 VB1 VSS nch l=0.15 w=1 nf=1 m=1
.ends bias

.subckt dut VDD VSS VREF VB2 IB VIN VOUT VB1
CL VOUT net5 1p
M1 net0 net0 VDD VDD pch l=0.15 w=1 nf=1 m=1
M13 net1 VB2 VDD VDD pch l=0.15 w=1 nf=1 m=1
M14 VX EAO net1 VDD pch l=0.15 w=1 nf=1 m=1
M15 VX VX VSS VSS nch l=0.15 w=1 nf=1 m=1
M16 GATE VX VSS VSS nch l=0.15 w=1 nf=1 m=1
M17 VDD net1 GATE VSS nch l=0.15 w=1 nf=1 m=1
M18 net2 EAO IB VSS nch l=0.15 w=1 nf=1 m=1
M19 net2 net2 VDD VDD pch l=0.15 w=1 nf=1 m=1
M2 net3 net3 VDD VDD pch l=0.15 w=1 nf=1 m=1
M20 GATE net2 VDD VDD pch l=0.15 w=1 nf=1 m=1
M21 VSS IB GATE VDD pch l=0.15 w=1 nf=1 m=1
M3 net0 VREF VX VSS nch l=0.15 w=1 nf=1 m=1
M4 net3 FB VX VSS nch l=0.15 w=1 nf=1 m=1
M5 EAO net0 VDD VDD pch l=0.15 w=1 nf=1 m=1
M6 net4 net3 VDD VDD pch l=0.15 w=1 nf=1 m=1
M7 EAO net4 VSS VSS nch l=0.15 w=1 nf=1 m=1
M8 net4 net4 VSS VSS nch l=0.15 w=1 nf=1 m=1
M9 VX VB3 VSS VSS nch l=0.15 w=1 nf=1 m=1
MNP VIN GATE VOUT VSS nch l=0.15 w=1 nf=1 m=1
R1 FB VSS 1k
R2 VOUT FB 1k
R3 net5 VSS 1k
RL VOUT VSS 1k
X1 VDD VSS VB3 VB1 bias
.ends dut
