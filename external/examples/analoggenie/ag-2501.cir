* official Analog Canvas netlist; PDK X cards rewritten by convert.py
.model nch nmos
.model pch pmos

.subckt dut VDD VSS VB1 VREF VIN VB7 VB6 VB4 VB5 VOUT
CF1 VOUT VFB 1p
Cm1 VOUT VO1 1p
Cm2 VO1 net5 1p
M1 net6 VC net3 VSS nch l=0.15 w=1 nf=1 m=1
M11 net4 VB1 VIN VDD pch l=0.15 w=1 nf=1 m=1
M12 net3 VFB net4 VDD pch l=0.15 w=1 nf=1 m=1
M13 net13 VREF net4 VDD pch l=0.15 w=1 nf=1 m=1
M14 net3 VB2 VSS VSS nch l=0.15 w=1 nf=1 m=1
M15 net13 VB2 VSS VSS nch l=0.15 w=1 nf=1 m=1
M16 net10 VB5 VIN VDD pch l=0.15 w=1 nf=1 m=1
M17 net10 VO1 VSS VSS nch l=0.15 w=1 nf=1 m=1
M18 net10 net10 VSS VSS nch l=0.15 w=1 nf=1 m=1
M2 VO1 VC net13 VSS nch l=0.15 w=1 nf=1 m=1
M21 net0 VO1 VSS VSS nch l=0.15 w=1 nf=1 m=1
M22 net9 net10 VSS VSS nch l=0.15 w=1 nf=1 m=1
M23 net0 net0 VIN VDD pch l=0.15 w=1 nf=1 m=1
M24 net9 net0 VIN VDD pch l=0.15 w=1 nf=1 m=1
M3 net6 VB3 VX VDD pch l=0.15 w=1 nf=1 m=1
M4 VO1 VB3 net11 VDD pch l=0.15 w=1 nf=1 m=1
M5 VX net6 VIN VDD pch l=0.15 w=1 nf=1 m=1
M6 net11 net6 VIN VDD pch l=0.15 w=1 nf=1 m=1
MB1 net7 VC VSS VSS nch l=0.15 w=1 nf=1 m=1
MB2 VC VC net7 VSS nch l=0.15 w=1 nf=1 m=1
MB3 VC net2 VIN VDD pch l=0.15 w=1 nf=1 m=1
MB4 net2 net2 VIN VDD pch l=0.15 w=1 nf=1 m=1
MB5 VB4 net2 VIN VDD pch l=0.15 w=1 nf=1 m=1
MB6 VB4 VB4 VSS VSS nch l=0.15 w=1 nf=1 m=1
MB7 net2 VB4 net8 VSS nch l=0.15 w=1 nf=1 m=1
MD1 net5 VO1 VSS VSS nch l=0.15 w=1 nf=1 m=1
MD2 VX VB6 VSS VSS nch l=0.15 w=1 nf=1 m=1
MD3 net12 net5 VX VSS nch l=0.15 w=1 nf=1 m=1
MD4 net1 VB7 VX VSS nch l=0.15 w=1 nf=1 m=1
MD5 net5 net1 VIN VDD pch l=0.15 w=1 nf=1 m=1
MD6 net12 net12 VIN VDD pch l=0.15 w=1 nf=1 m=1
MD7 net1 net1 VIN VDD pch l=0.15 w=1 nf=1 m=1
MPT VOUT net9 VIN VDD pch l=0.15 w=1 nf=1 m=1
RB1 net8 VSS 1k
RF1 VOUT VFB 1k
RF2 VFB VSS 1k
.ends dut
