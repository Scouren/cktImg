* official Analog Canvas netlist; PDK X cards rewritten by convert.py
.model nch nmos
.model pch pmos

.subckt dut +3.3V VSS Enable_bar RC LED
.model DIODE D(IS=1e-14 N=1)
Cext RC VSS 330nF
D1 +3.3V LED DIODE
M1 net2 RC net10 VSS nch l=0.15 w=1 nf=1 m=9
M10 net4 net9 VSS VSS nch l=0.15 w=1 nf=1 m=4
M11 net6 net1 net7 net7 pch l=0.15 w=1 nf=1 m=1
M12 net8 net4 net6 net7 pch l=0.15 w=1 nf=1 m=1
M13 net8 net4 VSS VSS nch l=0.15 w=1 nf=1 m=1
M14 net4 net8 net7 net7 pch l=0.15 w=1 nf=1 m=1
M15 net4 net8 VSS VSS nch l=0.15 w=1 nf=1 m=1
M16 LED net4 VSS VSS nch l=0.15 w=1 nf=1 m=5
M17 net0 net4 VSS VSS nch l=0.15 w=1 nf=1 m=4
M18 net7 Enable_bar +3.3V +3.3V pch l=0.15 w=1 nf=1 m=1
M2 net1 net7 net10 VSS nch l=0.15 w=1 nf=1 m=1
M3 net2 net2 net7 net7 pch l=0.15 w=1 nf=1 m=1
M4 net1 net2 net7 net7 pch l=0.15 w=1 nf=1 m=9
M5 net9 RC net5 net5 pch l=0.15 w=1 nf=1 m=9
M6 net3 VSS net5 net5 pch l=0.15 w=1 nf=1 m=1
M7 net9 net3 VSS VSS nch l=0.15 w=1 nf=1 m=1
M8 net3 net3 VSS VSS nch l=0.15 w=1 nf=1 m=9
M9 net1 net1 net7 net7 pch l=0.15 w=1 nf=1 m=1
R1 RC net0 20kΩ
R4 net10 net5 130kΩ
Rext +3.3V RC 1Meg
.ends dut
