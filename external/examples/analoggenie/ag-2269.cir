* official Analog Canvas netlist; PDK X cards rewritten by convert.py
.model nch nmos
.model pch pmos

.subckt dut VDD VSS Vref VIN VOUT VB1
CL VOUT VX 1p
M1 VX FB net4 VSS nch l=0.15 w=1 nf=1 m=1
M10 VB2 net1 VDD VDD pch l=0.15 w=1 nf=1 m=1
M11 VB2 VB2 VSS VSS nch l=0.15 w=1 nf=1 m=1
M12 VB1 VB2 VSS VSS nch l=0.15 w=1 nf=1 m=1
M13 VB1 VB1 VDD VDD pch l=0.15 w=1 nf=1 m=1
M14 net1 net1 net3 VDD pch l=0.15 w=1 nf=1 m=1
M2 net2 Vref net4 VSS nch l=0.15 w=1 nf=1 m=1
M3 VX VX VDD VDD pch l=0.15 w=1 nf=1 m=1
M4 net2 net2 VDD VDD pch l=0.15 w=1 nf=1 m=1
M5 net5 VX VDD VDD pch l=0.15 w=1 nf=1 m=1
M6 net0 net2 VDD VDD pch l=0.15 w=1 nf=1 m=1
M7 net5 net5 VSS VSS nch l=0.15 w=1 nf=1 m=1
M8 net0 net5 VSS VSS nch l=0.15 w=1 nf=1 m=1
M9 net4 VB2 VSS VSS nch l=0.15 w=1 nf=1 m=1
MNP VIN net0 VOUT VSS nch l=0.15 w=1 nf=1 m=1
R1 VOUT FB 1k
R2 FB VSS 1k
R3 VX VSS 1k
R4 VDD net3 1k
R5 net1 VSS 1k
.ends dut
