* official Analog Canvas netlist; PDK X cards rewritten by convert.py
.model nch nmos
.model pch pmos

.subckt dut VDD VSS VSTO VCONT1 VCONT2 VCONT3 VOUT VB1
CL VOUT VSS 1p
CSTO VSTO VSS 1p
LRX VX1 VX2 1n
M1 VG VX4 VDD VDD pch l=0.15 w=1 nf=1 m=1
M10 VB3 VX1 VDD VDD pch l=0.15 w=1 nf=1 m=1
M11 VB3 VB3 VSS VSS nch l=0.15 w=1 nf=1 m=1
M12 VX1 VB3 VSS VSS nch l=0.15 w=1 nf=1 m=1
M13 VB2 VB2 VDD VDD pch l=0.15 w=1 nf=1 m=1
M14 VB1 VB2 VDD VDD pch l=0.15 w=1 nf=1 m=1
M15 VB2 VB3 VSS VSS nch l=0.15 w=1 nf=1 m=1
M16 VB1 VB1 VSS VSS nch l=0.15 w=1 nf=1 m=1
M2 VX2 VB2 VDD VDD pch l=0.15 w=1 nf=1 m=1
M3 VX4 VX4 VDD VDD pch l=0.15 w=1 nf=1 m=1
M4 net1 VX2 VX2 VDD pch l=0.15 w=1 nf=1 m=1
M5 net0 VG VX2 VDD pch l=0.15 w=1 nf=1 m=1
M6 VG net1 VSS VSS nch l=0.15 w=1 nf=1 m=1
M7 net1 net1 VSS VSS nch l=0.15 w=1 nf=1 m=1
M8 net0 net0 VSS VSS nch l=0.15 w=1 nf=1 m=1
M9 VX4 net0 VSS VSS nch l=0.15 w=1 nf=1 m=1
MN1 VX1 VCONT2 VSS VSS nch l=0.15 w=1 nf=1 m=1
MN2 VX2 VCONT3 VSS VSS nch l=0.15 w=1 nf=1 m=1
MP2 VX2 VG VOUT VDD pch l=0.15 w=1 nf=1 m=1
MP3 VX1 VCONT1 VSTO VDD pch l=0.15 w=1 nf=1 m=1
R1 VDD VB3 1k
R2 VDD VX1 1k
.ends dut
