* official Analog Canvas netlist; PDK X cards rewritten by convert.py
.model nch nmos
.model pch pmos
.model qpnp pnp

.subckt opamp VDD VSS INN INP IB OUT
M1 net3 INN net1 VSS nch l=0.15 w=1 nf=1 m=1
M2 net2 INP net1 VSS nch l=0.15 w=1 nf=1 m=1
M3 net1 IB VSS VSS nch l=0.15 w=1 nf=1 m=1
M4 net3 net3 VDD VDD pch l=0.15 w=1 nf=1 m=1
M5 net2 net2 VDD VDD pch l=0.15 w=1 nf=1 m=1
M6 net0 net3 VDD VDD pch l=0.15 w=1 nf=1 m=1
M7 OUT net2 VDD VDD pch l=0.15 w=1 nf=1 m=1
M8 net0 net0 VSS VSS nch l=0.15 w=1 nf=1 m=1
M9 OUT net0 VSS VSS nch l=0.15 w=1 nf=1 m=1
.ends opamp

.subckt dut VDD VSS Vout VB1
M10 X net0 VSS VSS nch l=0.15 w=1 nf=1 m=1
M11 net0 net0 VSS VSS nch l=0.15 w=1 nf=1 m=1
M12 VB1 VB1 VDD VDD pch l=0.15 w=1 nf=1 m=1
M13 IB VB1 VDD VDD pch l=0.15 w=1 nf=1 m=1
M14 VB1 net0 VSS VSS nch l=0.15 w=1 nf=1 m=1
M15 IB IB VSS VSS nch l=0.15 w=1 nf=1 m=1
Q1 VSS VSS X qpnp m=1
Q2 VSS VSS net1 qpnp m=1
R1 Vout X 1k
R2 Vout Y 1k
R3 Y net1 1k
R4 VDD X 1k
R5 VDD net0 1k
R6 X net0 1k
X1 VDD VSS Y X IB Vout opamp
.ends dut
