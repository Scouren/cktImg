* official Analog Canvas netlist; PDK X cards rewritten by convert.py
.model nch nmos
.model pch pmos

.subckt comparator VDD VSS INN OUT
M1 VX VX VDD VDD pch l=0.15 w=1 nf=1 m=1
M10 net0 net2 VDD VDD pch l=0.15 w=1 nf=1 m=1
M11 net0 net0 VSS VSS nch l=0.15 w=1 nf=1 m=1
M12 net2 net2 VDD VDD pch l=0.15 w=1 nf=1 m=1
M13 net2 net0 net7 VSS nch l=0.15 w=1 nf=1 m=1
M14 net7 net3 VSS VSS nch l=0.15 w=1 nf=1 m=1
M15 net3 net2 VDD VDD pch l=0.15 w=1 nf=1 m=1
M16 net3 net3 VSS VSS nch l=0.15 w=1 nf=1 m=1
M17 net1 net2 VDD VDD pch l=0.15 w=1 nf=1 m=1
M18 net1 net1 VSS VSS nch l=0.15 w=1 nf=1 m=1
M19 net4 net4 VDD VDD pch l=0.15 w=1 nf=1 m=1
M2 OUT OUT VDD VDD pch l=0.15 w=1 nf=1 m=1
M20 net4 net1 VSS VSS nch l=0.15 w=1 nf=1 m=1
M21 net5 net4 VDD VDD pch l=0.15 w=1 nf=1 m=1
M22 net5 net5 VSS VSS nch l=0.15 w=1 nf=1 m=1
M3 OUT OUT VDD VDD pch l=0.15 w=1 nf=1 m=1
M4 net6 VX VDD VDD pch l=0.15 w=1 nf=1 m=1
M5 VX INN net8 VSS nch l=0.15 w=1 nf=1 m=1
M6 OUT OUT net8 VSS nch l=0.15 w=1 nf=1 m=1
M7 OUT net6 VSS VSS nch l=0.15 w=1 nf=1 m=1
M8 net6 net6 VSS VSS nch l=0.15 w=1 nf=1 m=1
M9 net8 net5 VSS VSS nch l=0.15 w=1 nf=1 m=1
.ends comparator

.subckt dut VDD VSS VSTO VCONT1 VCONT2 VCONT3 VOUT
CL VOUT VSS 1p
CSTO VSTO VSS 1p
LRX net2 net0 1n
MN1 net2 VCONT2 VSS VSS nch l=0.15 w=1 nf=1 m=1
MN2 net0 VCONT3 VSS VSS nch l=0.15 w=1 nf=1 m=1
MP2 net0 net1 VOUT VDD pch l=0.15 w=1 nf=1 m=1
MP3 net2 VCONT1 VSTO VDD pch l=0.15 w=1 nf=1 m=1
X1 VDD VSS net0 net1 comparator
.ends dut
