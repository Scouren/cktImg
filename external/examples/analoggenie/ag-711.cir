* official Analog Canvas netlist; PDK X cards rewritten by convert.py
.model nch nmos

.subckt dut VDD VSS Iout
I1 VDD net3 DC 1m
I2 VDD net4 DC 1m
I3 VDD net0 DC 1m
I4 VDD net5 DC 1m
Iin VDD net6 DC 1m
M1 Iout net5 net2 VSS nch l=0.15 w=70 nf=1 m=1
M2 net2 net6 VSS VSS nch l=0.15 w=80 nf=1 m=1
M3 net5 net0 VSS VSS nch l=0.15 w=10 nf=1 m=1
M4 net0 net0 net2 VSS nch l=0.15 w=10 nf=1 m=1
M5 net6 net3 net1 VSS nch l=0.15 w=70 nf=1 m=1
M6 net1 net6 VSS VSS nch l=0.15 w=80 nf=1 m=1
M7 net3 net4 VSS VSS nch l=0.15 w=10 nf=1 m=1
M8 net4 net4 net1 VSS nch l=0.15 w=10 nf=1 m=1
.ends dut
