* official Analog Canvas netlist; PDK X cards rewritten by convert.py
.model nch nmos
.model pch pmos

.subckt dut VDD VSS VB1 VREF VB3 VB2 VB4 VB5 VB7 VB6 VOUT VIN
CF1 VOUT VFB 1p
Cm1 VOUT V1 1p
Cm2 V1 net4 1p
M11 net2 VB1 VIN VDD pch l=0.15 w=1 nf=1 m=1
M12 net10 VFB net2 VDD pch l=0.15 w=1 nf=1 m=1
M13 net8 VREF net2 VDD pch l=0.15 w=1 nf=1 m=1
M14 net10 VB2 VSS VSS nch l=0.15 w=1 nf=1 m=1
M15 net8 VB2 VSS VSS nch l=0.15 w=1 nf=1 m=1
M16 net0 VB5 VIN VDD pch l=0.15 w=1 nf=1 m=1
M17 net0 net0 VSS VSS nch l=0.15 w=1 nf=1 m=1
M18 net0 V1 VSS VSS nch l=0.15 w=1 nf=1 m=1
M21 net7 V1 VSS VSS nch l=0.15 w=1 nf=1 m=1
M22 net9 net0 VSS VSS nch l=0.15 w=1 nf=1 m=1
M23 net7 net7 VIN VDD pch l=0.15 w=1 nf=1 m=1
M24 net9 net7 VIN VDD pch l=0.15 w=1 nf=1 m=1
M25 VX VBN net10 VSS nch l=0.15 w=1 nf=1 m=1
M26 V1 VBN net8 VSS nch l=0.15 w=1 nf=1 m=1
M27 VX VB3 VZ VDD pch l=0.15 w=1 nf=1 m=1
M28 V1 VB3 net6 VDD pch l=0.15 w=1 nf=1 m=1
M29 VZ VX VIN VDD pch l=0.15 w=1 nf=1 m=1
M30 net6 VX VIN VDD pch l=0.15 w=1 nf=1 m=1
M31 VBN VBP VIN VDD pch l=0.15 w=1 nf=1 m=1
M32 VBN VBN net12 VSS nch l=0.15 w=1 nf=1 m=1
M33 net12 VBN VSS VSS nch l=0.15 w=1 nf=1 m=1
M34 net5 VBP VIN VDD pch l=0.15 w=1 nf=1 m=1
M35 net5 net5 net13 VSS nch l=0.15 w=1 nf=1 m=1
M36 net13 net5 VB4 VSS nch l=0.15 w=1 nf=1 m=1
M37 VB4 VB4 VSS VSS nch l=0.15 w=1 nf=1 m=1
M38 VB4 VBP VIN VDD pch l=0.15 w=1 nf=1 m=1
M39 net11 VBP VIN VDD pch l=0.15 w=1 nf=1 m=1
M40 net11 net11 VY VSS nch l=0.15 w=1 nf=1 m=1
M41 VY net11 net13 VSS nch l=0.15 w=1 nf=1 m=1
M42 VBP VBP VIN VDD pch l=0.15 w=1 nf=1 m=1
M43 VBP VY VSS VSS nch l=0.15 w=1 nf=1 m=1
MD1 net4 V1 VSS VSS nch l=0.15 w=1 nf=1 m=1
MD2 VZ VB6 VSS VSS nch l=0.15 w=1 nf=1 m=1
MD3 net1 net4 VZ VSS nch l=0.15 w=1 nf=1 m=1
MD4 net3 VB7 VZ VSS nch l=0.15 w=1 nf=1 m=1
MD5 net4 net3 VIN VDD pch l=0.15 w=1 nf=1 m=1
MD6 net1 net1 VIN VDD pch l=0.15 w=1 nf=1 m=1
MD7 net3 net3 VIN VDD pch l=0.15 w=1 nf=1 m=1
MPT VOUT net9 VIN VDD pch l=0.15 w=1 nf=1 m=1
RF1 VOUT VFB 1k
RF2 VFB VSS 1k
.ends dut
