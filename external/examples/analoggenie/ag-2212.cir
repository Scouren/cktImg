* official Analog Canvas netlist; PDK X cards rewritten by convert.py
.model nch nmos
.model pch pmos

.subckt opamp VDD VSS INN INP VB2 OUT VB1 VB3 VB4
M1 net0 INP OUT VSS nch l=0.15 w=1 nf=1 m=1
M10 net2 VX VSS VSS nch l=0.15 w=1 nf=1 m=1
M11 OUT VB2 VSS VSS nch l=0.15 w=1 nf=1 m=1
M12 VBN net4 VDD VDD pch l=0.15 w=1 nf=1 m=1
M13 VBN VBN net5 VSS nch l=0.15 w=1 nf=1 m=1
M14 net5 VBN VSS VSS nch l=0.15 w=1 nf=1 m=1
M15 net4 net4 VDD VDD pch l=0.15 w=1 nf=1 m=1
M16 net4 VX VB4 VSS nch l=0.15 w=1 nf=1 m=1
M17 VX net4 VDD VDD pch l=0.15 w=1 nf=1 m=1
M18 VX VB4 VSS VSS nch l=0.15 w=1 nf=1 m=1
M2 net1 INN OUT VSS nch l=0.15 w=1 nf=1 m=1
M3 net1 VB1 VDD VDD pch l=0.15 w=1 nf=1 m=1
M4 net0 VB1 VDD VDD pch l=0.15 w=1 nf=1 m=1
M5 VX VB3 net1 VDD pch l=0.15 w=1 nf=1 m=1
M6 OUT VB3 net0 VDD pch l=0.15 w=1 nf=1 m=1
M7 VX VBN net3 VSS nch l=0.15 w=1 nf=1 m=1
M8 OUT VBN net2 VSS nch l=0.15 w=1 nf=1 m=1
M9 net3 VX VSS VSS nch l=0.15 w=1 nf=1 m=1
R1 VB4 VSS 1k
.ends opamp

.subckt dut VDD VSS VIN Vref VB1 VB2 VB3 VB4 VOUT
CL VOUT net1 1p
MNP VIN net0 VOUT VSS nch l=0.15 w=1 nf=1 m=1
R1 VOUT FB 1k
R2 FB VSS 1k
R3 net1 VSS 1k
X1 VDD VSS FB Vref VB2 net0 VB1 VB3 VB4 opamp
.ends dut
