* official Analog Canvas netlist; PDK X cards rewritten by convert.py
.model nch nmos
.model pch pmos

.subckt opamp VDD VSS INN INP OUT
M10 net4 VB4 net0 VDD pch l=0.15 w=1 nf=1 m=1
M11 OUT VB4 net5 VDD pch l=0.15 w=1 nf=1 m=1
M12 VB3 VB3 VSS VSS nch l=0.15 w=1 nf=1 m=1
M13 VB3 VB1 VDD VDD pch l=0.15 w=1 nf=1 m=1
M14 VB1 VB1 VDD VDD pch l=0.15 w=1 nf=1 m=1
M15 VB1 net1 VSS VSS nch l=0.15 w=1 nf=1 m=1
M16 net1 net1 VSS VSS nch l=0.15 w=1 nf=1 m=1
M17 net1 VX VDD VDD pch l=0.15 w=1 nf=1 m=1
M18 VX VX VDD VDD pch l=0.15 w=1 nf=1 m=1
M19 net2 VX VDD VDD pch l=0.15 w=1 nf=1 m=1
M20 VX net2 VB2 VSS nch l=0.15 w=1 nf=1 m=1
M21 net2 VB2 VSS VSS nch l=0.15 w=1 nf=1 m=1
M5 net4 INN net3 VSS nch l=0.15 w=1 nf=1 m=1
M6 OUT INP net3 VSS nch l=0.15 w=1 nf=1 m=1
M7 net3 VB3 VSS VSS nch l=0.15 w=1 nf=1 m=1
M8 net0 net4 VDD VDD pch l=0.15 w=1 nf=1 m=1
M9 net5 net4 VDD VDD pch l=0.15 w=1 nf=1 m=1
R1 VB2 VSS 1k
.ends opamp

.subckt dut VDD VSS vci phi1 phi2 vco
C1 net0 net2 1p
C2 net1 vco 1p
M1 vci phi1 net0 VSS nch l=0.15 w=1 nf=1 m=1
M2 net0 phi2 VSS VSS nch l=0.15 w=1 nf=1 m=1
M3 net2 phi1 VSS VSS nch l=0.15 w=1 nf=1 m=1
M4 net2 phi2 net1 VSS nch l=0.15 w=1 nf=1 m=1
X1 VDD VSS net1 VSS vco opamp
.ends dut
