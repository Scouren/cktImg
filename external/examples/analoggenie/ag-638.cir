* official Analog Canvas netlist; PDK X cards rewritten by convert.py
.model nch nmos
.model pch pmos

.subckt dut +1.5V -1.5V VSS In+ In- Output
Igain net1 -1.5V DC 1m
M1 net2 In+ net1 -1.5V nch l=0.15 w=1 nf=1 m=1
M10 Output net2 net3 +1.5V pch l=0.15 w=1 nf=1 m=10
M11 net5 net5 net7 -1.5V nch l=0.15 w=1 nf=1 m=5
M12 Output net5 net4 -1.5V nch l=0.15 w=1 nf=1 m=5
M13 net7 net5 -1.5V -1.5V nch l=0.15 w=1 nf=1 m=1
M14 net4 net5 -1.5V -1.5V nch l=0.15 w=1 nf=1 m=1
M2 net0 In- net1 -1.5V nch l=0.15 w=1 nf=1 m=1
M3 net6 net0 +1.5V +1.5V pch l=0.15 w=1 nf=1 m=2
M4 net8 net0 +1.5V +1.5V pch l=0.15 w=1 nf=1 m=2
M5 net0 net0 net6 +1.5V pch l=0.15 w=1 nf=1 m=10
M6 net5 net0 net8 +1.5V pch l=0.15 w=1 nf=1 m=10
M7 net9 net2 +1.5V +1.5V pch l=0.15 w=1 nf=1 m=2
M8 net3 net2 +1.5V +1.5V pch l=0.15 w=1 nf=1 m=2
M9 net2 net2 net9 +1.5V pch l=0.15 w=1 nf=1 m=10
Rload Output VSS 40kΩ
.ends dut
