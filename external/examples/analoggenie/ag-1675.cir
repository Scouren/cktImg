* official Analog Canvas netlist; PDK X cards rewritten by convert.py
.model nch nmos
.model pch pmos
.model qpnp pnp

.global VDD

.subckt A1 VSS INN INP OUT
M1 net5 VB1 VDD VDD pch l=0.15 w=1 nf=1 m=1
M10 net0 net3 VSS VSS nch l=0.15 w=1 nf=1 m=1
M11 INN INN net1 VSS nch l=0.15 w=1 nf=1 m=1
M12 VB4 VB6 VDD VDD pch l=0.15 w=1 nf=1 m=1
M13 VB6 VB6 VDD VDD pch l=0.15 w=1 nf=1 m=1
M14 net2 VB6 VDD VDD pch l=0.15 w=1 nf=1 m=1
M15 VB5 VB6 VDD VDD pch l=0.15 w=1 nf=1 m=1
M16 VB4 VB4 VSS VSS nch l=0.15 w=1 nf=1 m=1
M17 VB6 VB4 net4 VSS nch l=0.15 w=1 nf=1 m=1
M18 net4 net2 VSS VSS nch l=0.15 w=1 nf=1 m=1
M19 net2 net2 VSS VSS nch l=0.15 w=1 nf=1 m=1
M2 INN VB1 VDD VDD pch l=0.15 w=1 nf=1 m=1
M20 VB5 VB5 net7 VSS nch l=0.15 w=1 nf=1 m=1
M21 net7 VB5 VSS VSS nch l=0.15 w=1 nf=1 m=1
M3 net5 INP net1 VSS nch l=0.15 w=1 nf=1 m=1
M4 net1 VB2 VSS VSS nch l=0.15 w=1 nf=1 m=1
M5 OUT VB3 net5 VDD pch l=0.15 w=1 nf=1 m=1
M6 net3 VB3 INN VDD pch l=0.15 w=1 nf=1 m=1
M7 OUT VB5 net6 VSS nch l=0.15 w=1 nf=1 m=1
M8 net3 VB5 net0 VSS nch l=0.15 w=1 nf=1 m=1
M9 net6 net3 VSS VSS nch l=0.15 w=1 nf=1 m=1
.ends A1

.subckt dut VSS Vout
Q1 VSS VSS net0 qpnp m=1
Q2 net0 net0 X qpnp m=1
Q3 VSS VSS net1 qpnp m=1
Q4 net1 net1 net2 qpnp m=1
R1 Vout X 1k
R2 Vout Y 1k
R3 Y net2 1k
X1 VSS Y X Vout A1
.ends dut
