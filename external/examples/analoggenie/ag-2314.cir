* official Analog Canvas netlist; PDK X cards rewritten by convert.py
.model nch nmos
.model pch pmos

.subckt bias VDD VSS VN1 VN2
M22 VN1 net2 VDD VDD pch l=0.15 w=1 nf=1 m=1
M23 VN1 VN1 VN2 VSS nch l=0.15 w=1 nf=1 m=1
M24 VN2 VN2 VSS VSS nch l=0.15 w=1 nf=1 m=1
M25 net2 net2 VDD VDD pch l=0.15 w=1 nf=1 m=1
M26 net2 VB3 net1 VSS nch l=0.15 w=1 nf=1 m=1
M27 net1 net0 VSS VSS nch l=0.15 w=1 nf=1 m=1
M28 net0 net2 VDD VDD pch l=0.15 w=1 nf=1 m=1
M29 net0 net0 VSS VSS nch l=0.15 w=1 nf=1 m=1
M30 VB3 net2 VDD VDD pch l=0.15 w=1 nf=1 m=1
M31 VB3 VB3 VSS VSS nch l=0.15 w=1 nf=1 m=1
.ends bias

.subckt dut VDD VSS VB1 VREF VB2 VB4 IBUF VIN VOUT
CL VOUT net0 1p
M10 EAO VB2 VY VDD pch l=0.15 w=1 nf=1 m=1
M11 net2 VX VDD VDD pch l=0.15 w=1 nf=1 m=1
M12 VY VX VDD VDD pch l=0.15 w=1 nf=1 m=1
M13 net5 VB4 VDD VDD pch l=0.15 w=1 nf=1 m=1
M14 VX EAO net5 VDD pch l=0.15 w=1 nf=1 m=1
M15 VX VX VSS VSS nch l=0.15 w=1 nf=1 m=1
M16 GATE VX VSS VSS nch l=0.15 w=1 nf=1 m=1
M17 VDD net5 GATE VSS nch l=0.15 w=1 nf=1 m=1
M18 VY EAO IBUF VSS nch l=0.15 w=1 nf=1 m=1
M19 VY VY VDD VDD pch l=0.15 w=1 nf=1 m=1
M2 net4 VB1 VDD VDD pch l=0.15 w=1 nf=1 m=1
M20 GATE VY VDD VDD pch l=0.15 w=1 nf=1 m=1
M21 VSS IBUF GATE VDD pch l=0.15 w=1 nf=1 m=1
M3 net1 VREF net4 VDD pch l=0.15 w=1 nf=1 m=1
M4 net3 FB net4 VDD pch l=0.15 w=1 nf=1 m=1
M5 net1 VN2 VSS VSS nch l=0.15 w=1 nf=1 m=1
M6 net3 VN2 VSS VSS nch l=0.15 w=1 nf=1 m=1
M7 VX VN1 net1 VSS nch l=0.15 w=1 nf=1 m=1
M8 EAO VN1 net3 VSS nch l=0.15 w=1 nf=1 m=1
M9 VX VB2 net2 VDD pch l=0.15 w=1 nf=1 m=1
MNP VIN GATE VOUT VSS nch l=0.15 w=1 nf=1 m=1
R1 FB VSS 1k
R2 VOUT FB 1k
R3 net0 VSS 1k
RL VOUT VSS 1k
X1 VDD VSS VN1 VN2 bias
.ends dut
