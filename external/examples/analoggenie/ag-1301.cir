* official Analog Canvas netlist; PDK X cards rewritten by convert.py
.model nch nmos
.model pch pmos

.subckt EA VDD VSS INN INP VX2 OUT
MN1 VX VX VSS VSS nch l=0.15 w=1 nf=1 m=1
MN10 net0 net0 net5 VSS nch l=0.15 w=1 nf=1 m=1
MN11 net5 net0 net4 VSS nch l=0.15 w=1 nf=1 m=1
MN12 VB2 net5 VSS VSS nch l=0.15 w=1 nf=1 m=1
MN2 VX2 VX2 VSS VSS nch l=0.15 w=1 nf=1 m=1
MN3 OUT VX VSS VSS nch l=0.15 w=1 nf=1 m=1
MN4 net6 VX2 VSS VSS nch l=0.15 w=1 nf=1 m=1
MN5 VB1 VB1 VSS VSS nch l=0.15 w=1 nf=1 m=1
MN6 VBP net2 VSS VSS nch l=0.15 w=1 nf=1 m=1
MN7 net1 net1 net4 VSS nch l=0.15 w=1 nf=1 m=1
MN8 net4 net1 net2 VSS nch l=0.15 w=1 nf=1 m=1
MN9 net2 net2 VSS VSS nch l=0.15 w=1 nf=1 m=1
MP1 net6 net6 VDD VDD pch l=0.15 w=1 nf=1 m=1
MP10 net0 VB2 VDD VDD pch l=0.15 w=1 nf=1 m=1
MP11 VB2 VB2 VDD VDD pch l=0.15 w=1 nf=1 m=1
MP2 OUT net6 VDD VDD pch l=0.15 w=1 nf=1 m=1
MP3 net3 VBP VDD VDD pch l=0.15 w=1 nf=1 m=1
MP4 VX INN net3 VDD pch l=0.15 w=1 nf=1 m=1
MP5 VX2 INP net3 VDD pch l=0.15 w=1 nf=1 m=1
MP6 VB1 VBP VDD VDD pch l=0.15 w=1 nf=1 m=1
MP7 VBP VBP VDD VDD pch l=0.15 w=1 nf=1 m=1
MP8 net2 VB2 VDD VDD pch l=0.15 w=1 nf=1 m=1
MP9 net1 VB2 VDD VDD pch l=0.15 w=1 nf=1 m=1
.ends EA

.subckt dut VDD VSS VCONT1 VB3 VCONT2 VCONT3 VCONT4 VCONT5 VP VREF VIN
.model DIODE D(IS=1e-14 N=1)
CFLY VX1 VX2 1p
CO VP VN 1p
COP VP VSS 1p
D1 VN VX2 DIODE
L1 VX1 VX3 1n
M1 net0 VCONT1 VIN VDD pch l=0.15 w=1 nf=1 m=1
M2 VX1 VCONT2 VIN VDD pch l=0.15 w=1 nf=1 m=1
M3 VX2 VCONT3 VIN VDD pch l=0.15 w=1 nf=1 m=1
M4 VX3 VCONT4 VSS VSS nch l=0.15 w=1 nf=1 m=1
M5 VP VCONT5 VX3 VDD pch l=0.15 w=1 nf=1 m=1
MN6 net1 net3 VSS VSS nch l=0.15 w=1 nf=1 m=1
MN7 net3 net3 VSS VSS nch l=0.15 w=1 nf=1 m=1
MN8 net3 VB3 VSS VSS nch l=0.15 w=1 nf=1 m=1
MP4 net1 net1 net0 VDD pch l=0.15 w=1 nf=1 m=1
MP5 VX1 net1 net0 VDD pch l=0.15 w=1 nf=1 m=1
MP6 net3 net2 net0 VDD pch l=0.15 w=1 nf=1 m=1
R1 VP VFP1 1k
R2 VFP1 VSS 1k
X1 VDD VSS VFP1 VREF VX2 net2 EA
.ends dut
