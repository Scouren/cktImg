* official Analog Canvas netlist; PDK X cards rewritten by convert.py
.model nch nmos
.model pch pmos

.subckt dut VDD VSS Vref VIN VOUT
CL VOUT VX 1p
M1 VX FB net6 VSS nch l=0.15 w=1 nf=1 m=1
M10 VB2 VB2 VDD VDD pch l=0.15 w=1 nf=1 m=1
M11 VB2 net4 VSS VSS nch l=0.15 w=1 nf=1 m=1
M12 net1 VB2 VDD VDD pch l=0.15 w=1 nf=1 m=1
M13 net1 net1 net4 VSS nch l=0.15 w=1 nf=1 m=1
M14 net4 net1 net0 VSS nch l=0.15 w=1 nf=1 m=1
M15 net3 VB2 VDD VDD pch l=0.15 w=1 nf=1 m=1
M16 net3 net3 net0 VSS nch l=0.15 w=1 nf=1 m=1
M17 net0 net3 net8 VSS nch l=0.15 w=1 nf=1 m=1
M18 net8 VB2 VDD VDD pch l=0.15 w=1 nf=1 m=1
M19 net8 net8 VSS VSS nch l=0.15 w=1 nf=1 m=1
M2 VX VX VDD VDD pch l=0.15 w=1 nf=1 m=1
M20 VB1 VB1 VDD VDD pch l=0.15 w=1 nf=1 m=1
M21 VB1 net8 VSS VSS nch l=0.15 w=1 nf=1 m=1
M22 VB3 VB1 VDD VDD pch l=0.15 w=1 nf=1 m=1
M23 VB3 VB3 VSS VSS nch l=0.15 w=1 nf=1 m=1
M3 net5 net5 VDD VDD pch l=0.15 w=1 nf=1 m=1
M4 net2 net5 VDD VDD pch l=0.15 w=1 nf=1 m=1
M5 net5 Vref net6 VSS nch l=0.15 w=1 nf=1 m=1
M6 net7 VX VDD VDD pch l=0.15 w=1 nf=1 m=1
M7 net6 VB3 VSS VSS nch l=0.15 w=1 nf=1 m=1
M8 net7 net7 VSS VSS nch l=0.15 w=1 nf=1 m=1
M9 net2 net7 VSS VSS nch l=0.15 w=1 nf=1 m=1
MNP VIN net2 VOUT VOUT nch l=0.15 w=1 nf=1 m=1
R1 VOUT FB 1k
R2 FB VSS 1k
R3 VX VSS 1k
.ends dut
