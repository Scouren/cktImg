* official Analog Canvas netlist; PDK X cards rewritten by convert.py
.model nch nmos
.model pch pmos

.subckt dut VDD VSS vci phi1 phi2 vco
C1 vcx VSS 1p
C2 VX vco 1p
M1 vci phi1 vcx VSS nch l=0.15 w=1 nf=1 m=1
M10 net5 VX VSS VSS nch l=0.15 w=1 nf=1 m=1
M11 net0 VX net6 VSS nch l=0.15 w=1 nf=1 m=1
M12 net1 VSS net6 VSS nch l=0.15 w=1 nf=1 m=1
M13 net6 VB2 VSS VSS nch l=0.15 w=1 nf=1 m=1
M14 VB4 net3 VDD VDD pch l=0.15 w=1 nf=1 m=1
M15 net3 net3 VDD VDD pch l=0.15 w=1 nf=1 m=1
M16 VB5 net3 VDD VDD pch l=0.15 w=1 nf=1 m=1
M17 VB4 VB4 VSS VSS nch l=0.15 w=1 nf=1 m=1
M18 net3 VB4 net4 VSS nch l=0.15 w=1 nf=1 m=1
M19 VB5 VB5 net7 VSS nch l=0.15 w=1 nf=1 m=1
M2 vcx phi2 VX VSS nch l=0.15 w=1 nf=1 m=1
M20 net7 VB5 VSS VSS nch l=0.15 w=1 nf=1 m=1
M3 net0 VB1 VDD VDD pch l=0.15 w=1 nf=1 m=1
M4 VX VB3 net0 VDD pch l=0.15 w=1 nf=1 m=1
M5 VX VB5 net2 VSS nch l=0.15 w=1 nf=1 m=1
M6 net2 VX VSS VSS nch l=0.15 w=1 nf=1 m=1
M7 net1 VB1 VDD VDD pch l=0.15 w=1 nf=1 m=1
M8 vco VB3 net1 VDD pch l=0.15 w=1 nf=1 m=1
M9 vco VB5 net5 VSS nch l=0.15 w=1 nf=1 m=1
R1 net4 VSS 1k
.ends dut
