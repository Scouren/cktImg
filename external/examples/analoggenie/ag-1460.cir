* official Analog Canvas netlist; PDK X cards rewritten by convert.py
.model nch nmos
.model pch pmos

.subckt comparator VDD VSS IN OUT
M10 OUT net1 VSS VSS nch l=0.15 w=1 nf=1 m=1
M11 net1 net1 VSS VSS nch l=0.15 w=1 nf=1 m=1
M12 net2 net2 VSS VSS nch l=0.15 w=1 nf=1 m=1
M13 net3 net2 VSS VSS nch l=0.15 w=1 nf=1 m=1
M14 VB1 VB3 VDD VDD pch l=0.15 w=1 nf=1 m=1
M15 VB3 VB3 VDD VDD pch l=0.15 w=1 nf=1 m=1
M16 net4 VB2 VDD VDD pch l=0.15 w=1 nf=1 m=1
M17 VB2 VB2 VDD VDD pch l=0.15 w=1 nf=1 m=1
M18 VB1 VB1 VSS VSS nch l=0.15 w=1 nf=1 m=1
M19 VB3 net4 VSS VSS nch l=0.15 w=1 nf=1 m=1
M20 net0 net4 VSS VSS nch l=0.15 w=1 nf=1 m=1
M21 VB2 net4 VSS VSS nch l=0.15 w=1 nf=1 m=1
M5 IN VB3 VDD VDD pch l=0.15 w=1 nf=1 m=1
M6 net3 net3 VDD VDD pch l=0.15 w=1 nf=1 m=1
M7 OUT net3 VDD VDD pch l=0.15 w=1 nf=1 m=1
M8 net1 IN IN VDD pch l=0.15 w=1 nf=1 m=1
M9 net2 OUT IN VDD pch l=0.15 w=1 nf=1 m=1
R1 net4 net0 1k
.ends comparator

.subckt dut VDD VSS VCONT1 VCONT2 VCONT3 VSTO VOUT
CL VOUT VSS 1p
CSTO VSTO VSS 1p
LRX net1 net0 1n
MN1 net1 VCONT2 VSS VSS nch l=0.15 w=1 nf=1 m=1
MN2 net0 VCONT3 VSS VSS nch l=0.15 w=1 nf=1 m=1
MP2 net0 net2 VOUT VDD pch l=0.15 w=1 nf=1 m=1
MP3 net1 VCONT1 VSTO VDD pch l=0.15 w=1 nf=1 m=1
X1 VDD VSS net0 net2 comparator
.ends dut
