* official Analog Canvas netlist; PDK X cards rewritten by convert.py
.model nch nmos
.model pch pmos

.subckt comparator VDD VSS INN VB2 OUT
M10 net0 VB2 VSS VSS nch l=0.15 w=1 nf=1 m=1
M11 OUT net1 VSS VSS nch l=0.15 w=1 nf=1 m=1
M12 net1 net1 VSS VSS nch l=0.15 w=1 nf=1 m=1
M13 net1 VA VDD VDD pch l=0.15 w=1 nf=1 m=1
M5 VA VA VDD VDD pch l=0.15 w=1 nf=1 m=1
M6 VA INN net0 VSS nch l=0.15 w=1 nf=1 m=1
M7 OUT OUT VDD VDD pch l=0.15 w=1 nf=1 m=1
M8 OUT OUT VDD VDD pch l=0.15 w=1 nf=1 m=1
M9 OUT OUT net0 VSS nch l=0.15 w=1 nf=1 m=1
.ends comparator

.subckt dut VDD VSS VSTO VCONT1 VCONT2 VCONT3 VOUT VB1
CL VOUT VSS 1p
CSTO VSTO VSS 1p
LRX VX net0 1n
M14 VX net2 VSS VSS nch l=0.15 w=1 nf=1 m=1
M15 net2 VX VDD VDD pch l=0.15 w=1 nf=1 m=1
M16 net2 net2 VSS VSS nch l=0.15 w=1 nf=1 m=1
M17 net3 net3 VDD VDD pch l=0.15 w=1 nf=1 m=1
M18 net3 net2 VSS VSS nch l=0.15 w=1 nf=1 m=1
M19 VB2 net3 VDD VDD pch l=0.15 w=1 nf=1 m=1
M20 VB2 VB2 VSS VSS nch l=0.15 w=1 nf=1 m=1
M21 VB1 VB1 VDD VDD pch l=0.15 w=1 nf=1 m=1
M22 VB1 VB2 VSS VSS nch l=0.15 w=1 nf=1 m=1
MN1 VX VCONT2 VSS VSS nch l=0.15 w=1 nf=1 m=1
MN2 net0 VCONT3 VSS VSS nch l=0.15 w=1 nf=1 m=1
MP2 net0 net1 VOUT VOUT pch l=0.15 w=1 nf=1 m=1
MP3 VX VCONT1 VSTO VSTO pch l=0.15 w=1 nf=1 m=1
R1 VDD VX 1k
R2 VDD net2 1k
X1 VDD VSS net0 VB2 net1 comparator
.ends dut
