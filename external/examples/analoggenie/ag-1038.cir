* official Analog Canvas netlist; PDK X cards rewritten by convert.py
.model nch nmos
.model pch pmos

.subckt dut VDD VSS phiLatch_bar phiLatch VREF vin vout+ vout-
M1 vout+ vout- net0 VSS nch l=0.15 w=1 nf=1 m=1
M2 vout- vout+ net0 VSS nch l=0.15 w=1 nf=1 m=1
M3 vout+ vout- net1 VDD pch l=0.15 w=1 nf=1 m=1
M4 vout- vout+ net1 VDD pch l=0.15 w=1 nf=1 m=1
M5 net0 phiLatch VSS VSS nch l=0.15 w=1 nf=1 m=1
M6 net1 phiLatch_bar VDD VDD pch l=0.15 w=1 nf=1 m=1
M7 vin phiLatch_bar vout- VSS nch l=0.15 w=1 nf=1 m=1
M8 VREF phiLatch_bar vout+ VSS nch l=0.15 w=1 nf=1 m=1
.ends dut
