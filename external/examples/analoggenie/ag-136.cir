* official Analog Canvas netlist; PDK X cards rewritten by convert.py
.model nch nmos

.subckt dut VDD VSS Vb Vout
Cin net2 X 1p
IB VDD net3 DC 1m
M1 Vout Vb X VSS nch l=0.15 w=1 nf=1 m=1
M2 X net3 VSS VSS nch l=0.15 w=1 nf=1 m=1
M3 net3 Vb net0 VSS nch l=0.15 w=1 nf=1 m=1
MB net0 net3 VSS VSS nch l=0.15 w=1 nf=1 m=1
R1 net1 net2 1k
RD VDD Vout 1k
Vin net1 VSS DC 1
.ends dut
