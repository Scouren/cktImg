* official Analog Canvas netlist; PDK X cards rewritten by convert.py
.model qnpn npn

.subckt dut VEE VSS TUNE OUT
C1 net0 net1 1p
C2 net1 VEE 1p
C4 net5 VEE 1p
L1 net4 net0 1n
L2 net6 OUT 1n
Q1 net6 net0 net1 VEE qnpn m=1
Q2 net4 net5 net5 VEE qnpn m=1
R1 VSS net0 1k
R2 net0 VEE 1k
R3 VSS net6 1k
R4 net1 VEE 1k
R6 TUNE net5 1k
.ends dut
