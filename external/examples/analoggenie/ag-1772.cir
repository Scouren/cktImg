* official Analog Canvas netlist; PDK X cards rewritten by convert.py
.model nch nmos
.model pch pmos
.model qpnp pnp

.subckt dut VDD VSS Vout
M1 X VG VDD VDD pch l=0.15 w=1 nf=1 m=1
M10 VG VB2 net4 VDD pch l=0.15 w=1 nf=1 m=1
M11 VZ VB2 net1 VDD pch l=0.15 w=1 nf=1 m=1
M12 VG VB4 net2 VSS nch l=0.15 w=1 nf=1 m=1
M13 VZ VB4 net0 VSS nch l=0.15 w=1 nf=1 m=1
M14 net2 VB5 VSS VSS nch l=0.15 w=1 nf=1 m=1
M15 net0 VB5 VSS VSS nch l=0.15 w=1 nf=1 m=1
M16 VB5 VB5 VSS VSS nch l=0.15 w=1 nf=1 m=1
M17 VB4 net3 VDD VDD pch l=0.15 w=1 nf=1 m=1
M18 VB4 VB4 VB5 VSS nch l=0.15 w=1 nf=1 m=1
M19 net3 net3 VDD VDD pch l=0.15 w=1 nf=1 m=1
M2 Vout VG VDD VDD pch l=0.15 w=1 nf=1 m=1
M20 VB3 net3 VDD VDD pch l=0.15 w=1 nf=1 m=1
M21 VB3 VB3 VSS VSS nch l=0.15 w=1 nf=1 m=1
M22 net3 VB3 net5 VSS nch l=0.15 w=1 nf=1 m=1
M3 net6 VG VDD VDD pch l=0.15 w=1 nf=1 m=1
M4 VT VG VDD VDD pch l=0.15 w=1 nf=1 m=1
M5 VT VB1 VDD VDD pch l=0.15 w=1 nf=1 m=1
M6 net4 VZ VDD VDD pch l=0.15 w=1 nf=1 m=1
M7 net1 VZ VDD VDD pch l=0.15 w=1 nf=1 m=1
M8 net0 Y VT VDD pch l=0.15 w=1 nf=1 m=1
M9 net2 X VT VDD pch l=0.15 w=1 nf=1 m=1
Q1 VSS VSS net6 qpnp m=1
Q2 VSS net6 X qpnp m=1
Q3 VSS VSS VT qpnp m=1
Q4 VSS VT VZ qpnp m=1
R1 Y VZ 1k
R2 Vout Y 1k
R3 net5 VSS 1k
.ends dut
