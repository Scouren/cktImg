* official Analog Canvas netlist; PDK X cards rewritten by convert.py
.model nch nmos
.model pch pmos
.model qpnp pnp

.subckt A1 VDD VSS INN INP OUT
M1 net2 net2 VDD VDD pch l=0.15 w=1 nf=1 m=1
M10 VB1 VB1 VDD VDD pch l=0.15 w=1 nf=1 m=1
M11 VB1 VB3 VSS VSS nch l=0.15 w=1 nf=1 m=1
M12 VB3 VB4 VDD VDD pch l=0.15 w=1 nf=1 m=1
M13 VB3 VB3 VSS VSS nch l=0.15 w=1 nf=1 m=1
M14 VB4 VB4 VDD VDD pch l=0.15 w=1 nf=1 m=1
M15 VB4 VB2 VSS VSS nch l=0.15 w=1 nf=1 m=1
M16 VB2 VB4 VDD VDD pch l=0.15 w=1 nf=1 m=1
M17 VB2 VB2 VSS VSS nch l=0.15 w=1 nf=1 m=1
M2 net0 net0 VDD VDD pch l=0.15 w=1 nf=1 m=1
M3 net0 INN net1 VSS nch l=0.15 w=1 nf=1 m=1
M4 net2 INP net1 VSS nch l=0.15 w=1 nf=1 m=1
M5 OUT net2 VDD VDD pch l=0.15 w=1 nf=1 m=1
M6 VX net0 VDD VDD pch l=0.15 w=1 nf=1 m=1
M7 OUT VX VSS VSS nch l=0.15 w=1 nf=1 m=1
M8 VX VX VSS VSS nch l=0.15 w=1 nf=1 m=1
M9 net1 VB3 VSS VSS nch l=0.15 w=1 nf=1 m=1
.ends A1

.subckt dut VDD VSS Vout
Q1 VSS VSS net0 qpnp m=1
Q2 net0 net0 net1 qpnp m=1
Q3 VSS VSS net4 qpnp m=1
Q4 net4 net4 net2 qpnp m=1
R1 Vout net1 1k
R2 Vout net3 1k
R3 net3 net2 1k
X1 VDD VSS net3 net1 Vout A1
.ends dut
