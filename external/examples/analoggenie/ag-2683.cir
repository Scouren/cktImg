* official Analog Canvas netlist; PDK X cards rewritten by convert.py
.model nch nmos
.model pch pmos

.subckt dut VDD VSS vci phi1 phi2 vco VB1
C1 vcx VSS 1p
C2 net1 vco 1p
M1 vci phi1 vcx VSS nch l=0.15 w=1 nf=1 m=1
M10 VX vcx VDD VDD pch l=0.15 w=1 nf=1 m=1
M11 VX VX VSS VSS nch l=0.15 w=1 nf=1 m=1
M12 VB2 net3 VDD VDD pch l=0.15 w=1 nf=1 m=1
M13 VB2 VB2 VSS VSS nch l=0.15 w=1 nf=1 m=1
M14 net3 net3 VDD VDD pch l=0.15 w=1 nf=1 m=1
M15 net3 VB1 VSS VSS nch l=0.15 w=1 nf=1 m=1
M16 VB1 net3 VDD VDD pch l=0.15 w=1 nf=1 m=1
M17 VB1 VB1 VSS VSS nch l=0.15 w=1 nf=1 m=1
M2 vcx phi2 net1 VSS nch l=0.15 w=1 nf=1 m=1
M3 vcx net1 net2 VSS nch l=0.15 w=1 nf=1 m=1
M4 net0 VSS net2 VSS nch l=0.15 w=1 nf=1 m=1
M5 net2 VB2 VSS VSS nch l=0.15 w=1 nf=1 m=1
M6 vcx vcx VDD VDD pch l=0.15 w=1 nf=1 m=1
M7 net0 net0 VDD VDD pch l=0.15 w=1 nf=1 m=1
M8 vco net0 VDD VDD pch l=0.15 w=1 nf=1 m=1
M9 vco VX VSS VSS nch l=0.15 w=1 nf=1 m=1
.ends dut
