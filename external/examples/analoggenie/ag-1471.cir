* official Analog Canvas netlist; PDK X cards rewritten by convert.py
.model nch nmos
.model pch pmos
.model qnpn npn

.subckt opamp VDD VSS INN INP VB2 VB1 VB4 OUT
M1 OUT VB4 net3 VSS nch l=0.15 w=1 nf=1 m=1
M10 net4 VA VSS VSS nch l=0.15 w=1 nf=1 m=1
M11 net7 net5 VSS VSS nch l=0.15 w=1 nf=1 m=1
M12 net3 VA VSS VSS nch l=0.15 w=1 nf=1 m=1
M13 net1 net0 VDD VDD pch l=0.15 w=1 nf=1 m=1
M14 net6 net0 VDD VDD pch l=0.15 w=1 nf=1 m=1
M15 net0 VB4 net7 VSS nch l=0.15 w=1 nf=1 m=1
M2 net0 VB1 net1 VDD pch l=0.15 w=1 nf=1 m=1
M3 OUT VB1 net6 VDD pch l=0.15 w=1 nf=1 m=1
M4 net8 net5 VSS VSS nch l=0.15 w=1 nf=1 m=1
M5 net2 VB2 VDD VDD pch l=0.15 w=1 nf=1 m=1
M6 net5 INP net2 VDD pch l=0.15 w=1 nf=1 m=1
M7 VA INN net2 VDD pch l=0.15 w=1 nf=1 m=1
M8 net5 VB4 net8 VSS nch l=0.15 w=1 nf=1 m=1
M9 VA VB4 net4 VSS nch l=0.15 w=1 nf=1 m=1
.ends opamp

.subckt dut VDD VSS VB1 VB2 Vout VB3
M16 VB4 net1 VDD VDD pch l=0.15 w=1 nf=1 m=1
M17 net1 net1 VDD VDD pch l=0.15 w=1 nf=1 m=1
M18 VB3 net1 VDD VDD pch l=0.15 w=1 nf=1 m=1
M19 VB4 VB4 Z VSS nch l=0.15 w=1 nf=1 m=1
M20 Z VB4 VSS VSS nch l=0.15 w=1 nf=1 m=1
M21 net1 VB3 VSS VSS nch l=0.15 w=1 nf=1 m=1
M22 net0 VB3 VSS VSS nch l=0.15 w=1 nf=1 m=1
Q1 X X VSS VSS qnpn m=1
Q2 Z Z VSS VSS qnpn m=1
R1 Vout X 1k
R2 Vout Y 1k
R3 Y Z 1k
R4 VB3 net0 1k
X1 VDD VSS Y X VB2 VB1 VB4 Vout opamp
.ends dut
