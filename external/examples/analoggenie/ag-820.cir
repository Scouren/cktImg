* official Analog Canvas netlist; PDK X cards rewritten by convert.py
.model nch nmos
.model pch pmos

.subckt icm_opamp_vdd_vss VDD VSS VIP VIN VOUT params: gain=1e6
Blin nlin 0 V={gain*(V(VIP)-V(VIN))}
Bcore VOUT 0 V={0.5*(V(VDD)+(0.5*(V(VSS)+V(nlin)+sqrt((V(nlin)-V(VSS))*(V(nlin)-V(VSS))+(1e-4*(V(VDD)-V(VSS)))*(1e-4*(V(VDD)-V(VSS)))+1e-12)))-sqrt((V(VDD)-(0.5*(V(VSS)+V(nlin)+sqrt((V(nlin)-V(VSS))*(V(nlin)-V(VSS))+(1e-4*(V(VDD)-V(VSS)))*(1e-4*(V(VDD)-V(VSS)))+1e-12))))*(V(VDD)-(0.5*(V(VSS)+V(nlin)+sqrt((V(nlin)-V(VSS))*(V(nlin)-V(VSS))+(1e-4*(V(VDD)-V(VSS)))*(1e-4*(V(VDD)-V(VSS)))+1e-12))))+(1e-4*(V(VDD)-V(VSS)))*(1e-4*(V(VDD)-V(VSS)))+1e-12))}
.ends icm_opamp_vdd_vss

.subckt dut VDD VSS Vref Vcntl Vin2 Vin1 Vout1 Vout2
G1 VDD net0 Vcntl VSS 1m
G2 VDD net2 Vcntl VSS 1m
M1 Vout1 Vin1 net2 VDD pch l=0.15 w=1 nf=1 m=1
M2 Vout2 Vin2 net2 VDD pch l=0.15 w=1 nf=1 m=1
M3 net4 VSS net0 VDD pch l=0.15 w=1 nf=1 m=1
M4 net1 Vref net0 VDD pch l=0.15 w=1 nf=1 m=1
M5 Vout1 net3 VSS VSS nch l=0.15 w=1 nf=1 m=1
M6 Vout2 net3 VSS VSS nch l=0.15 w=1 nf=1 m=1
M7 net4 net3 VSS VSS nch l=0.15 w=1 nf=1 m=1
M8 net1 net3 VSS VSS nch l=0.15 w=1 nf=1 m=1
X1 VDD VSS net4 Vref net3 icm_opamp_vdd_vss gain=1e6
.ends dut
