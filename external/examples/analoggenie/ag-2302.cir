* official Analog Canvas netlist; PDK X cards rewritten by convert.py
.model nch nmos
.model pch pmos

.subckt dut VDD VSS VB3 VB2 VB4 IBUF VIN VOUT
CL VOUT net0 1p
M10 EAO VB2 net6 VDD pch l=0.15 w=1 nf=1 m=1
M11 net3 VB3 VDD VDD pch l=0.15 w=1 nf=1 m=1
M12 net6 VB3 VDD VDD pch l=0.15 w=1 nf=1 m=1
M13 net5 VB4 VDD VDD pch l=0.15 w=1 nf=1 m=1
M14 net4 EAO net5 VDD pch l=0.15 w=1 nf=1 m=1
M15 net4 net4 VSS VSS nch l=0.15 w=1 nf=1 m=1
M16 GATE net4 VSS VSS nch l=0.15 w=1 nf=1 m=1
M17 VDD net5 GATE VSS nch l=0.15 w=1 nf=1 m=1
M18 net2 EAO IBUF VSS nch l=0.15 w=1 nf=1 m=1
M19 net2 net2 VDD VDD pch l=0.15 w=1 nf=1 m=1
M2 net10 VB5 VSS VSS nch l=0.15 w=1 nf=1 m=1
M20 GATE net2 VDD VDD pch l=0.15 w=1 nf=1 m=1
M21 VSS IBUF GATE VDD pch l=0.15 w=1 nf=1 m=1
M22 VB1 net1 VDD VDD pch l=0.15 w=1 nf=1 m=1
M23 VB1 VB1 net11 VSS nch l=0.15 w=1 nf=1 m=1
M24 net11 VB1 VSS VSS nch l=0.15 w=1 nf=1 m=1
M25 net1 net1 VDD VDD pch l=0.15 w=1 nf=1 m=1
M26 net1 VX net7 VSS nch l=0.15 w=1 nf=1 m=1
M27 VX net7 VSS VSS nch l=0.15 w=1 nf=1 m=1
M28 VX net1 VDD VDD pch l=0.15 w=1 nf=1 m=1
M3 net6 VREF net10 VSS nch l=0.15 w=1 nf=1 m=1
M4 net3 FB net10 VSS nch l=0.15 w=1 nf=1 m=1
M5 net8 VX VSS VSS nch l=0.15 w=1 nf=1 m=1
M6 net9 VX VSS VSS nch l=0.15 w=1 nf=1 m=1
M7 VX VB1 net8 VSS nch l=0.15 w=1 nf=1 m=1
M8 EAO VB1 net9 VSS nch l=0.15 w=1 nf=1 m=1
M9 VX VB2 net3 VDD pch l=0.15 w=1 nf=1 m=1
MNP VIN GATE VOUT VSS nch l=0.15 w=1 nf=1 m=1
R1 FB VSS 1k
R2 VOUT FB 1k
R3 net7 VSS 1k
R4 net0 VSS 1k
RL VOUT VSS 1k
.ends dut
