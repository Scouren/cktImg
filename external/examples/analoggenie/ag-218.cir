* official Analog Canvas netlist; PDK X cards rewritten by convert.py
.model nch nmos

.subckt dut VDD VSS Vin Vout
CL Vout VSS 1p
M1 Vout Vin VSS VSS nch l=0.15 w=1 nf=1 m=1
RD VDD Vout 1k
.ends dut
