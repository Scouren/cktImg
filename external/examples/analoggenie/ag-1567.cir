* official Analog Canvas netlist; PDK X cards rewritten by convert.py
.model nch nmos
.model pch pmos
.model qpnp pnp

.subckt opamp VDD VSS INP INN OUT VB1 VB2
M1 net0 VP VDD VDD pch l=0.15 w=1 nf=1 m=1
M10 net1 VBN net3 VSS nch l=0.15 w=1 nf=1 m=1
M11 OUT VBN net9 VSS nch l=0.15 w=1 nf=1 m=1
M12 net7 net8 VSS VSS nch l=0.15 w=1 nf=1 m=1
M13 net2 net8 VSS VSS nch l=0.15 w=1 nf=1 m=1
M14 net3 net1 VSS VSS nch l=0.15 w=1 nf=1 m=1
M15 net9 net1 VSS VSS nch l=0.15 w=1 nf=1 m=1
M16 net6 VBP VDD VDD pch l=0.15 w=1 nf=1 m=1
M17 VBP VBP VDD VDD pch l=0.15 w=1 nf=1 m=1
M18 VB3 VBP VDD VDD pch l=0.15 w=1 nf=1 m=1
M19 VBN VBP VDD VDD pch l=0.15 w=1 nf=1 m=1
M2 net10 VP VDD VDD pch l=0.15 w=1 nf=1 m=1
M20 VBP VB3 net4 VSS nch l=0.15 w=1 nf=1 m=1
M21 VB3 VB3 VSS VSS nch l=0.15 w=1 nf=1 m=1
M22 VBN VBN net11 VSS nch l=0.15 w=1 nf=1 m=1
M23 net6 net6 VSS VSS nch l=0.15 w=1 nf=1 m=1
M24 net4 net6 VSS VSS nch l=0.15 w=1 nf=1 m=1
M25 net11 VBN VSS VSS nch l=0.15 w=1 nf=1 m=1
M3 net5 VB2 VDD VDD pch l=0.15 w=1 nf=1 m=1
M4 VP VB1 net0 VDD pch l=0.15 w=1 nf=1 m=1
M5 net8 INP net5 VDD pch l=0.15 w=1 nf=1 m=1
M6 net1 INN net5 VDD pch l=0.15 w=1 nf=1 m=1
M7 OUT VB1 net10 VDD pch l=0.15 w=1 nf=1 m=1
M8 VP VBN net7 VSS nch l=0.15 w=1 nf=1 m=1
M9 net8 VBN net2 VSS nch l=0.15 w=1 nf=1 m=1
.ends opamp

.subckt dut VDD VSS Vout VB1 VB2
Q1 VSS VSS X qpnp m=1
Q2 VSS VSS net0 qpnp m=1
R1 Vout X 1k
R2 Vout Y 1k
R3 Y net0 1k
X1 VDD VSS X Y Vout VB1 VB2 opamp
.ends dut
