* official Analog Canvas netlist; PDK X cards rewritten by convert.py
.model nch nmos
.model pch pmos

.subckt dut VDD VSS Vin1 Vin2 X Y Vb2 Vb3 Vb4 Vout1 Vout2
ISS net2 VSS DC 1m
M1 Q Vin1 net2 VSS nch l=0.15 w=1 nf=1 m=1
M10 net1 Vb4 VSS VSS nch l=0.15 w=1 nf=1 m=1
M2 P Vin2 net2 VSS nch l=0.15 w=1 nf=1 m=1
M3 Vout1 Vb3 net0 VSS nch l=0.15 w=1 nf=1 m=1
M4 Vout2 Vb3 net1 VSS nch l=0.15 w=1 nf=1 m=1
M5 Vout1 Vb2 P VDD pch l=0.15 w=1 nf=1 m=1
M6 Vout2 Vb2 Q VDD pch l=0.15 w=1 nf=1 m=1
M7 P X VDD VDD pch l=0.15 w=1 nf=1 m=1
M8 Q Y VDD VDD pch l=0.15 w=1 nf=1 m=1
M9 net0 Vb4 VSS VSS nch l=0.15 w=1 nf=1 m=1
.ends dut
