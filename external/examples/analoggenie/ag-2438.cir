* official Analog Canvas netlist; PDK X cards rewritten by convert.py
.model nch nmos
.model pch pmos

.subckt BiasCircuit VDD VSS VX
M13 VB2 VB2 VDD VDD pch l=0.15 w=1 nf=1 m=1
M14 net2 VB2 VDD VDD pch l=0.15 w=1 nf=1 m=1
M15 net0 net0 VDD VDD pch l=0.15 w=1 nf=1 m=1
M16 VX net0 VDD VDD pch l=0.15 w=1 nf=1 m=1
M17 VB1 VB1 VDD VDD pch l=0.15 w=1 nf=1 m=1
M18 VB2 net2 VSS VSS nch l=0.15 w=1 nf=1 m=1
M19 net1 net2 VSS VSS nch l=0.15 w=1 nf=1 m=1
M20 net0 net2 VSS VSS nch l=0.15 w=1 nf=1 m=1
M21 VX VX VSS VSS nch l=0.15 w=1 nf=1 m=1
M22 VB1 VX VSS VSS nch l=0.15 w=1 nf=1 m=1
R1 net2 net1 1k
.ends BiasCircuit

.subckt ErrorAmp VDD VSS VREF VEA VX
M10 net0 VREF net1 VSS nch l=0.15 w=1 nf=1 m=1
M11 net2 VEA net1 VSS nch l=0.15 w=1 nf=1 m=1
M12 net1 VX VSS VSS nch l=0.15 w=1 nf=1 m=1
M4 net0 net0 VDD VDD pch l=0.15 w=1 nf=1 m=1
M5 VEA net0 VDD VDD pch l=0.15 w=1 nf=1 m=1
M6 VEA net2 VDD VDD pch l=0.15 w=1 nf=1 m=1
M7 net2 net2 VDD VDD pch l=0.15 w=1 nf=1 m=1
M8 VEA VEA VSS VSS nch l=0.15 w=1 nf=1 m=1
M9 VEA VEA VSS VSS nch l=0.15 w=1 nf=1 m=1
.ends ErrorAmp

.subckt dut VDD VSS VIN VOUT VREF
M1 net3 net4 VIN VDD pch l=0.15 w=1 nf=1 m=1
M2 net0 net0 net3 VDD pch l=0.15 w=1 nf=1 m=1
M3 net0 nb VSS VSS nch l=0.15 w=1 nf=1 m=1
MBIAS VERR nb VSS VSS nch l=0.15 w=1 nf=1 m=1
MCHG net5 pb VIN VDD pch l=0.15 w=1 nf=1 m=1
MCTRL VERR net0 VOUT VDD pch l=0.15 w=1 nf=1 m=1
MGEN net2 net2 VSS VSS nch l=0.15 w=1 nf=1 m=1
MINJ VERR net2 VSS VSS nch l=0.15 w=1 nf=1 m=1
MRES VOUT VERR VIN VDD pch l=0.15 w=1 nf=1 m=1
MSEN net2 net4 net5 VDD pch l=0.15 w=1 nf=1 m=1
X1 VDD VSS VREF net4 net1 ErrorAmp
X2 VDD VSS net1 BiasCircuit
.ends dut
