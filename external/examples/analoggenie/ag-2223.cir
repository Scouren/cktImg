* official Analog Canvas netlist; PDK X cards rewritten by convert.py
.model nch nmos
.model pch pmos

.subckt opamp VDD VSS INP INN OUT VB1 VB3 VB2
M1 net1 VN VSS VSS nch l=0.15 w=1 nf=1 m=1
M10 net1 INN net3 VDD pch l=0.15 w=1 nf=1 m=1
M11 net3 VB1 VDD VDD pch l=0.15 w=1 nf=1 m=1
M12 VN VN VSS VSS nch l=0.15 w=1 nf=1 m=1
M13 VC VC VN VSS nch l=0.15 w=1 nf=1 m=1
M14 VC VP VDD VDD pch l=0.15 w=1 nf=1 m=1
M15 net6 net5 VB3 VSS nch l=0.15 w=1 nf=1 m=1
M16 net2 net8 net6 VSS nch l=0.15 w=1 nf=1 m=1
M17 net5 net5 net6 VSS nch l=0.15 w=1 nf=1 m=1
M18 net8 net8 net2 VSS nch l=0.15 w=1 nf=1 m=1
M19 VB3 VB3 VSS VSS nch l=0.15 w=1 nf=1 m=1
M2 net0 VN VSS VSS nch l=0.15 w=1 nf=1 m=1
M20 VP net2 VSS VSS nch l=0.15 w=1 nf=1 m=1
M21 net5 VP VDD VDD pch l=0.15 w=1 nf=1 m=1
M22 net8 VP VDD VDD pch l=0.15 w=1 nf=1 m=1
M23 VB3 VP VDD VDD pch l=0.15 w=1 nf=1 m=1
M24 VP VP VDD VDD pch l=0.15 w=1 nf=1 m=1
M3 OUT VC net1 VSS nch l=0.15 w=1 nf=1 m=1
M4 VX VC net0 VSS nch l=0.15 w=1 nf=1 m=1
M5 OUT VB2 net7 VDD pch l=0.15 w=1 nf=1 m=1
M6 VX VB2 net4 VDD pch l=0.15 w=1 nf=1 m=1
M7 net7 VX VDD VDD pch l=0.15 w=1 nf=1 m=1
M8 net4 VX VDD VDD pch l=0.15 w=1 nf=1 m=1
M9 net0 INP net3 VDD pch l=0.15 w=1 nf=1 m=1
.ends opamp

.subckt dut VDD VSS Vref VIN VOUT VB1 VB2 VB3
CL VOUT net0 1p
MNP VIN net1 VOUT VSS nch l=0.15 w=1 nf=1 m=1
R1 VOUT FB 1k
R2 FB VSS 1k
R3 net0 VSS 1k
X1 VDD VSS Vref FB net1 VB1 VB3 VB2 opamp
.ends dut
