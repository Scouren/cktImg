* official Analog Canvas netlist; PDK X cards rewritten by convert.py
.model nch nmos
.model pch pmos

.subckt dut VDD VSS Q_bar Q D D_bar CK
M1 Q_bar D net0 VSS nch l=0.15 w=1 nf=1 m=1
M2 Q D_bar net0 VSS nch l=0.15 w=1 nf=1 m=1
M3 Q_bar Q VDD VDD pch l=0.15 w=1 nf=1 m=1
M4 Q Q_bar VDD VDD pch l=0.15 w=1 nf=1 m=1
M5 net0 CK VSS VSS nch l=0.15 w=1 nf=1 m=1
.ends dut
