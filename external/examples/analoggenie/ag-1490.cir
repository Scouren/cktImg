* official Analog Canvas netlist; PDK X cards rewritten by convert.py
.model nch nmos
.model pch pmos
.model qnpn npn

.subckt opamp VDD VSS INN INP OUT VB4
M1 net3 VB1 VDD VDD pch l=0.15 w=1 nf=1 m=1
M10 net1 net0 VSS VSS nch l=0.15 w=1 nf=1 m=1
M11 net2 INN net4 VSS nch l=0.15 w=1 nf=1 m=1
M2 net2 VB1 VDD VDD pch l=0.15 w=1 nf=1 m=1
M3 net3 INP net4 VSS nch l=0.15 w=1 nf=1 m=1
M4 net4 VB2 VSS VSS nch l=0.15 w=1 nf=1 m=1
M5 OUT VB3 net3 VDD pch l=0.15 w=1 nf=1 m=1
M6 net0 VB3 net2 VDD pch l=0.15 w=1 nf=1 m=1
M7 OUT VB4 net5 VSS nch l=0.15 w=1 nf=1 m=1
M8 net0 VB4 net1 VSS nch l=0.15 w=1 nf=1 m=1
M9 net5 net0 VSS VSS nch l=0.15 w=1 nf=1 m=1
.ends opamp

.subckt dut VDD VSS Vout
M12 net0 net2 VSS VSS nch l=0.15 w=1 nf=1 m=1
M13 net2 net1 VDD VDD pch l=0.15 w=1 nf=1 m=1
M14 net2 net2 net0 VSS nch l=0.15 w=1 nf=1 m=1
M15 net1 net1 VDD VDD pch l=0.15 w=1 nf=1 m=1
Q1 X X VSS VSS qnpn m=1
Q2 net0 net0 VSS VSS qnpn m=1
R1 Vout X 1k
R2 Vout Y 1k
R3 Y net0 1k
R4 net1 VSS 1k
X1 VDD VSS Y X Vout net2 opamp
.ends dut
