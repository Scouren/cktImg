* official Analog Canvas netlist; PDK X cards rewritten by convert.py
.model nch nmos
.model pch pmos

.subckt dut VDD VSS Vref VIN VOUT
CL VOUT VX 1p
M1 VX FB net4 VSS nch l=0.15 w=1 nf=1 m=1
M10 VB1 VB1 VDD VDD pch l=0.15 w=1 nf=1 m=1
M11 VB2 VB1 VDD VDD pch l=0.15 w=1 nf=1 m=1
M12 VB2 VB2 VSS VSS nch l=0.15 w=1 nf=1 m=1
M13 VB1 net1 VSS VSS nch l=0.15 w=1 nf=1 m=1
M14 net1 net1 net3 VSS nch l=0.15 w=1 nf=1 m=1
M2 net5 Vref net4 VSS nch l=0.15 w=1 nf=1 m=1
M3 VX VX VDD VDD pch l=0.15 w=1 nf=1 m=1
M4 net5 net5 VDD VDD pch l=0.15 w=1 nf=1 m=1
M5 net2 VX VDD VDD pch l=0.15 w=1 nf=1 m=1
M6 net0 net5 VDD VDD pch l=0.15 w=1 nf=1 m=1
M7 net2 net2 VSS VSS nch l=0.15 w=1 nf=1 m=1
M8 net0 net2 VSS VSS nch l=0.15 w=1 nf=1 m=1
M9 net4 VB2 VSS VSS nch l=0.15 w=1 nf=1 m=1
MNP VIN net0 VOUT VSS nch l=0.15 w=1 nf=1 m=1
R1 VOUT FB 1k
R2 FB VSS 1k
R3 VDD net1 1k
R4 net3 VSS 1k
RESR VX VSS 1k
.ends dut
