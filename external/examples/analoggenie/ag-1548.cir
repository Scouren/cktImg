* official Analog Canvas netlist; PDK X cards rewritten by convert.py
.model nch nmos
.model pch pmos
.model qnpn npn

.subckt dut VDD VSS Vout VB1
M1 net1 X net2 VSS nch l=0.15 w=1 nf=1 m=1
M10 net3 net3 VDD VDD pch l=0.15 w=1 nf=1 m=1
M11 VB2 net3 VDD VDD pch l=0.15 w=1 nf=1 m=1
M12 VB2 VB2 VSS VSS nch l=0.15 w=1 nf=1 m=1
M13 VB1 VB2 VSS VSS nch l=0.15 w=1 nf=1 m=1
M14 VB1 VB1 VDD VDD pch l=0.15 w=1 nf=1 m=1
M2 net1 net1 VDD VDD pch l=0.15 w=1 nf=1 m=1
M3 net0 net0 VDD VDD pch l=0.15 w=1 nf=1 m=1
M4 net0 Y net2 VSS nch l=0.15 w=1 nf=1 m=1
M5 net2 VB2 VSS VSS nch l=0.15 w=1 nf=1 m=1
M6 Z net1 VDD VDD pch l=0.15 w=1 nf=1 m=1
M7 Vout net0 VDD VDD pch l=0.15 w=1 nf=1 m=1
M8 Z Z VSS VSS nch l=0.15 w=1 nf=1 m=1
M9 Vout Z VSS VSS nch l=0.15 w=1 nf=1 m=1
Q1 Z Z VSS VSS qnpn m=1
Q2 Y Y VSS VSS qnpn m=1
R1 Vout X 1k
R2 Vout Y 1k
R3 X Z 1k
R4 net3 VSS 1k
.ends dut
