* official Analog Canvas netlist; PDK X cards rewritten by convert.py
.model nch nmos
.model pch pmos

.subckt comparator VDD VSS INN OUT VB1 VB2
M10 OUT OUT net5 VSS nch l=0.15 w=1 nf=1 m=1
M11 net5 VB3 VSS VSS nch l=0.15 w=1 nf=1 m=1
M12 VB3 VB4 VDD VDD pch l=0.15 w=1 nf=1 m=1
M13 VB3 VB3 VSS VSS nch l=0.15 w=1 nf=1 m=1
M14 VB1 VB1 VDD VDD pch l=0.15 w=1 nf=1 m=1
M15 VB1 VB3 VSS VSS nch l=0.15 w=1 nf=1 m=1
M16 VB4 VB4 VDD VDD pch l=0.15 w=1 nf=1 m=1
M17 VB4 net3 VSS VSS nch l=0.15 w=1 nf=1 m=1
M18 net4 VB4 VDD VDD pch l=0.15 w=1 nf=1 m=1
M19 net4 net4 net3 VSS nch l=0.15 w=1 nf=1 m=1
M20 net3 net4 net6 VSS nch l=0.15 w=1 nf=1 m=1
M21 net2 VB4 VDD VDD pch l=0.15 w=1 nf=1 m=1
M22 net2 net2 net6 VSS nch l=0.15 w=1 nf=1 m=1
M23 VB2 VB4 VDD VDD pch l=0.15 w=1 nf=1 m=1
M24 VB2 net2 net6 VSS nch l=0.15 w=1 nf=1 m=1
M25 VB2 VB2 VSS VSS nch l=0.15 w=1 nf=1 m=1
M3 net0 net0 VDD VDD pch l=0.15 w=1 nf=1 m=1
M4 net0 INN net5 VSS nch l=0.15 w=1 nf=1 m=1
M5 net1 net0 VDD VDD pch l=0.15 w=1 nf=1 m=1
M6 net1 net1 VSS VSS nch l=0.15 w=1 nf=1 m=1
M7 OUT OUT VDD VDD pch l=0.15 w=1 nf=1 m=1
M8 OUT net1 VSS VSS nch l=0.15 w=1 nf=1 m=1
M9 OUT OUT VDD VDD pch l=0.15 w=1 nf=1 m=1
.ends comparator

.subckt dut VDD VSS VSTO VCONT1 VCONT2 VCONT3 VOUT VB1 VB2
CL VOUT VSS 1p
CSTO VSTO VSS 1p
LRX net1 net2 1n
MN1 net1 VCONT2 VSS VSS nch l=0.15 w=1 nf=1 m=1
MN2 net2 VCONT3 VSS VSS nch l=0.15 w=1 nf=1 m=1
MP2 net2 net0 VOUT VDD pch l=0.15 w=1 nf=1 m=1
MP3 net1 VCONT1 VSTO VDD pch l=0.15 w=1 nf=1 m=1
X1 VDD VSS net2 net0 VB1 VB2 comparator
.ends dut
