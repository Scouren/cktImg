* official Analog Canvas netlist; PDK X cards rewritten by convert.py
.model nch nmos
.model pch pmos

.subckt opamp VDD VSS INP INN OUT
M1 net2 net5 VDD VDD pch l=0.15 w=1 nf=1 m=1
M10 net3 INP net4 VDD pch l=0.15 w=1 nf=1 m=1
M11 net8 INN net4 VDD pch l=0.15 w=1 nf=1 m=1
M12 VB4 net0 VDD VDD pch l=0.15 w=1 nf=1 m=1
M13 VB4 VB4 VB5 VSS nch l=0.15 w=1 nf=1 m=1
M14 VB5 VB5 VSS VSS nch l=0.15 w=1 nf=1 m=1
M15 net1 net0 VDD VDD pch l=0.15 w=1 nf=1 m=1
M16 net0 net0 VDD VDD pch l=0.15 w=1 nf=1 m=1
M17 net6 net1 VSS VSS nch l=0.15 w=1 nf=1 m=1
M18 net0 net1 VSS VSS nch l=0.15 w=1 nf=1 m=1
M2 net7 net5 VDD VDD pch l=0.15 w=1 nf=1 m=1
M3 net5 VB2 net2 VDD pch l=0.15 w=1 nf=1 m=1
M4 OUT VB2 net7 VDD pch l=0.15 w=1 nf=1 m=1
M5 net5 VB4 net3 VSS nch l=0.15 w=1 nf=1 m=1
M6 OUT VB4 net8 VSS nch l=0.15 w=1 nf=1 m=1
M7 net3 VB5 VSS VSS nch l=0.15 w=1 nf=1 m=1
M8 net8 VB5 VSS VSS nch l=0.15 w=1 nf=1 m=1
M9 net4 VB1 VDD VDD pch l=0.15 w=1 nf=1 m=1
R1 net1 net6 1k
.ends opamp

.subckt dut VDD VSS Vref VIN VOUT
CL VOUT net1 1p
MNP VIN net0 VOUT VSS nch l=0.15 w=1 nf=1 m=1
R1 VOUT FB 1k
R2 FB VSS 1k
R3 net1 VSS 1k
X1 VDD VSS Vref FB net0 opamp
.ends dut
