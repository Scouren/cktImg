* official Analog Canvas netlist; PDK X cards rewritten by convert.py
.model nch nmos

.subckt dut VDD VSS Vin Vout
CL Vout VSS 1pF
M1 Vout VDD Vin VSS nch l=0.15 w=1 nf=1 m=1
.ends dut
