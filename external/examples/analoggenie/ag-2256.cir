* official Analog Canvas netlist; PDK X cards rewritten by convert.py
.model nch nmos
.model pch pmos

.subckt opamp VDD VSS INP INN CC OUT VB1
M10 net1 net1 VSS VSS nch l=0.15 w=1 nf=1 m=1
M11 net0 VB2 VSS VSS nch l=0.15 w=1 nf=1 m=1
M12 OUT net3 VSS VSS nch l=0.15 w=1 nf=1 m=1
M13 net3 OUT VDD VDD pch l=0.15 w=1 nf=1 m=1
M14 net3 net3 VSS VSS nch l=0.15 w=1 nf=1 m=1
M15 net4 net3 VSS VSS nch l=0.15 w=1 nf=1 m=1
M16 net4 net4 VDD VDD pch l=0.15 w=1 nf=1 m=1
M17 VB2 net4 VDD VDD pch l=0.15 w=1 nf=1 m=1
M18 VB2 VB2 VSS VSS nch l=0.15 w=1 nf=1 m=1
M19 VB1 VB2 VSS VSS nch l=0.15 w=1 nf=1 m=1
M20 VB1 VB1 VDD VDD pch l=0.15 w=1 nf=1 m=1
M3 CC INN net0 VSS nch l=0.15 w=1 nf=1 m=1
M4 net2 INP net0 VSS nch l=0.15 w=1 nf=1 m=1
M5 net2 net2 VDD VDD pch l=0.15 w=1 nf=1 m=1
M6 CC CC VDD VDD pch l=0.15 w=1 nf=1 m=1
M7 OUT net2 VDD VDD pch l=0.15 w=1 nf=1 m=1
M8 net1 CC VDD VDD pch l=0.15 w=1 nf=1 m=1
M9 OUT net1 VSS VSS nch l=0.15 w=1 nf=1 m=1
R3 CC VSS 1k
R4 VDD OUT 1k
R5 VDD net3 1k
.ends opamp

.subckt dut VDD VSS Vref VIN VOUT VB1
C1 net1 VOUT 1p
MNP VIN net0 VOUT VOUT nch l=0.15 w=1 nf=1 m=1
R1 VOUT FB 1k
R2 FB VSS 1k
X1 VDD VSS Vref FB net1 net0 VB1 opamp
.ends dut
