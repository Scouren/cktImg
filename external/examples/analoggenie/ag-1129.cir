* official Analog Canvas netlist; PDK X cards rewritten by convert.py
.model qnpn npn

.subckt dut VDD VSS
C1 VDD net3 1p
C2 VDD net4 1p
CE1 net1 net2 1p
CE2 net0 net2 1p
I1 net2 VSS DC 1m
L1 VDD net3 1n
L2 VDD net4 1n
Q1 net3 net4 net1 VSS qnpn m=1
Q2 net4 net3 net0 VSS qnpn m=1
R1 VDD net3 1k
R2 VDD net4 1k
RE1 net1 net2 1k
RE2 net0 net2 1k
.ends dut
