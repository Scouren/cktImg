* official Analog Canvas netlist; PDK X cards rewritten by convert.py
.model nch nmos
.model pch pmos

.subckt opamp VDD VSS INN INP OUT
M1 net2 INN net5 VSS nch l=0.15 w=1 nf=1 m=1
M10 net1 net4 VDD VDD pch l=0.15 w=1 nf=1 m=1
M11 net4 net1 VSS VSS nch l=0.15 w=1 nf=1 m=1
M12 VB1 VB1 VDD VDD pch l=0.15 w=1 nf=1 m=1
M13 VB2 VB1 VDD VDD pch l=0.15 w=1 nf=1 m=1
M14 net1 net1 VSS VSS nch l=0.15 w=1 nf=1 m=1
M15 VB1 net1 VSS VSS nch l=0.15 w=1 nf=1 m=1
M16 VB2 VB2 VSS VSS nch l=0.15 w=1 nf=1 m=1
M2 net0 INP net5 VSS nch l=0.15 w=1 nf=1 m=1
M3 net2 net2 VDD VDD pch l=0.15 w=1 nf=1 m=1
M4 net0 net0 VDD VDD pch l=0.15 w=1 nf=1 m=1
M5 net3 net2 VDD VDD pch l=0.15 w=1 nf=1 m=1
M6 OUT net0 VDD VDD pch l=0.15 w=1 nf=1 m=1
M7 net5 VB2 VSS VSS nch l=0.15 w=1 nf=1 m=1
M8 net3 net3 VSS VSS nch l=0.15 w=1 nf=1 m=1
M9 OUT net3 VSS VSS nch l=0.15 w=1 nf=1 m=1
R1 VDD net4 1k
R2 VDD net1 1k
.ends opamp

.subckt dut VDD VSS vci phi1 phi2 vco
C1 net2 net0 1p
C2 net1 vco 1p
M1 vci phi1 net2 VSS nch l=0.15 w=1 nf=1 m=1
M2 net2 phi2 VSS VSS nch l=0.15 w=1 nf=1 m=1
M3 net0 phi1 VSS VSS nch l=0.15 w=1 nf=1 m=1
M4 net0 phi2 net1 VSS nch l=0.15 w=1 nf=1 m=1
X1 VDD VSS net1 VSS vco opamp
.ends dut
