* official Analog Canvas netlist; PDK X cards rewritten by convert.py
.model nch nmos

.subckt dut VDD VSS Vin Vout
C1 X VSS 1p
C2 X net0 1p
L1 net0 Vout 1n
L2 VDD X 1n
M1 X Vin VSS VSS nch l=0.15 w=1 nf=1 m=1
RL Vout VSS 1k
.ends dut
