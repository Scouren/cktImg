* official Analog Canvas netlist; PDK X cards rewritten by convert.py
.model nch nmos
.model pch pmos

.subckt bias VDD VSS VB1 VB3
M19 VB1 VB1 VDD VDD pch l=0.15 w=1 nf=1 m=1
M20 VB3 VB1 VDD VDD pch l=0.15 w=1 nf=1 m=1
M21 VB1 net0 VSS VSS nch l=0.15 w=1 nf=1 m=1
M22 net0 net0 VSS VSS nch l=0.15 w=1 nf=1 m=1
M23 VB3 VB3 VSS VSS nch l=0.15 w=1 nf=1 m=1
R3 VDD net0 1k
.ends bias

.subckt dut VDD VSS VB2 VIN VOUT VREF IBUF
CL VOUT net0 1p
M1 net3 net3 VDD VDD pch l=0.15 w=1 nf=1 m=1
M10 net1 VB2 VDD VDD pch l=0.15 w=1 nf=1 m=1
M11 VX EAO net1 VDD pch l=0.15 w=1 nf=1 m=1
M12 VDD net1 GATE VSS nch l=0.15 w=1 nf=1 m=1
M13 VX VX VSS VSS nch l=0.15 w=1 nf=1 m=1
M14 GATE VX VSS VSS nch l=0.15 w=1 nf=1 m=1
M15 GATE net4 VDD VDD pch l=0.15 w=1 nf=1 m=1
M16 net4 net4 VDD VDD pch l=0.15 w=1 nf=1 m=1
M17 net4 EAO IBUF IBUF nch l=0.15 w=1 nf=1 m=1
M18 VSS IBUF GATE VSS pch l=0.15 w=1 nf=1 m=1
M2 net5 net5 VDD VDD pch l=0.15 w=1 nf=1 m=1
M3 net3 VREF VX VSS nch l=0.15 w=1 nf=1 m=1
M4 net5 FB VX VSS nch l=0.15 w=1 nf=1 m=1
M5 VX VB3 VSS VSS nch l=0.15 w=1 nf=1 m=1
M6 EAO net3 VDD VDD pch l=0.15 w=1 nf=1 m=1
M7 net2 net5 VDD VDD pch l=0.15 w=1 nf=1 m=1
M8 net2 net2 VSS VSS nch l=0.15 w=1 nf=1 m=1
M9 EAO net2 VSS VSS nch l=0.15 w=1 nf=1 m=1
MNP VIN GATE VOUT VOUT nch l=0.15 w=1 nf=1 m=1
R1 FB VSS 1k
R2 VOUT FB 1k
R4 net0 VSS 1k
RL VOUT VSS 1k
X1 VDD VSS VB1 VB3 bias
.ends dut
