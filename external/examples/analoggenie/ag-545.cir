* official Analog Canvas netlist; PDK X cards rewritten by convert.py
.model nch nmos

* Ideal xor-gate: switches at V(VDD,VSS)/2; vt sets the step width, td the delay
.subckt xor_gate VDD VSS A B Y params: vt=10m td=10p
BhA hA 0 V={0.5*(1+tanh((V(A,VSS)-0.5*V(VDD,VSS))/vt))}
BhB hB 0 V={0.5*(1+tanh((V(B,VSS)-0.5*V(VDD,VSS))/vt))}
Bf nfn VSS V={V(VDD,VSS)*(V(hA)+V(hB)-2*V(hA)*V(hB))}
Rd nfn ndl 1k
Cd ndl VSS {td/1000}
BY Y VSS V={V(ndl,VSS)}
.ends xor_gate

.subckt dut VDD VSS Vin X Y
C1 Vcont VSS 1p
IDD VDD P DC 1m
L1 P X 1n
L2 P Y 1n
M1 X Y VSS VSS nch l=0.15 w=1 nf=1 m=1
M2 Y X VSS VSS nch l=0.15 w=1 nf=1 m=1
Mv1 Vcont X Vcont VSS nch l=0.15 w=1 nf=1 m=1
Mv2 Vcont Y Vcont VSS nch l=0.15 w=1 nf=1 m=1
R1 VPD Vcont 1k
X1 VDD VSS Vin Y VPD xor_gate td=10p vt=10m
.ends dut
