* official Analog Canvas netlist; PDK X cards rewritten by convert.py
.model qnpn npn

.subckt dut SUB Out1 Out2
I1 net5 SUB DC 100uA
Q1 Out1 net4 net1 SUB qnpn m=1
Q2 Out2 net2 net0 SUB qnpn m=1
R1 net3 Out1 40kΩ
R2 net3 Out2 40kΩ
R3 net1 net5 2kΩ
R4 net0 net5 2kΩ
Vbias net2 SUB DC 2V
Vcc net3 SUB DC 5V
Vin net4 SUB DC 2V AC 50mV 0
.ends dut
