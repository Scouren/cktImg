* official Analog Canvas netlist; PDK X cards rewritten by convert.py
.model nch nmos
.model pch pmos
.model qnpn npn

.subckt A1 VDD VSS INP INN OUT VB1 VB2
M1 net5 net3 VDD VDD pch l=0.15 w=1 nf=1 m=1
M10 net7 INP net6 VDD pch l=0.15 w=1 nf=1 m=1
M11 net1 INN net6 VDD pch l=0.15 w=1 nf=1 m=1
M12 VB4 VP VDD VDD pch l=0.15 w=1 nf=1 m=1
M13 VB4 VB4 VB5 VSS nch l=0.15 w=1 nf=1 m=1
M14 VB5 VB5 VSS VSS nch l=0.15 w=1 nf=1 m=1
M15 VP VP VDD VDD pch l=0.15 w=1 nf=1 m=1
M16 VP VB3 net2 VSS nch l=0.15 w=1 nf=1 m=1
M17 net2 net0 VSS VSS nch l=0.15 w=1 nf=1 m=1
M18 net0 VP VDD VDD pch l=0.15 w=1 nf=1 m=1
M19 net0 net0 VSS VSS nch l=0.15 w=1 nf=1 m=1
M2 net3 VB2 net5 VDD pch l=0.15 w=1 nf=1 m=1
M20 VB3 VP VDD VDD pch l=0.15 w=1 nf=1 m=1
M21 VB3 VB3 VSS VSS nch l=0.15 w=1 nf=1 m=1
M3 net3 VB4 net7 VSS nch l=0.15 w=1 nf=1 m=1
M4 net7 VB5 VSS VSS nch l=0.15 w=1 nf=1 m=1
M5 net4 net3 VDD VDD pch l=0.15 w=1 nf=1 m=1
M6 OUT VB2 net4 VDD pch l=0.15 w=1 nf=1 m=1
M7 OUT VB4 net1 VSS nch l=0.15 w=1 nf=1 m=1
M8 net1 VB5 VSS VSS nch l=0.15 w=1 nf=1 m=1
M9 net6 VB1 VDD VDD pch l=0.15 w=1 nf=1 m=1
.ends A1

.subckt dut VDD VSS Vout VB1 VB2
Q1 X X VSS VSS qnpn m=1
Q2 net0 net0 VSS VSS qnpn m=1
R1 Vout X 1k
R2 Vout Y 1k
R3 Y net0 1k
X1 VDD VSS X Y Vout VB1 VB2 A1
.ends dut
