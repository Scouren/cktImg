* official Analog Canvas netlist; PDK X cards rewritten by convert.py
.model nch nmos
.model pch pmos

.subckt dut VDD VSS VREF VIN VB4 VB3 VB5 VOUT VB2 VB1
CF1 VOUT VFB 1p
Cm1 VOUT VO1 1p
Cm2 VO1 net7 1p
M11 net0 VBN VSS VSS nch l=0.15 w=1 nf=1 m=1
M12 VY VFB net0 VSS nch l=0.15 w=1 nf=1 m=1
M13 VX VREF net0 VSS nch l=0.15 w=1 nf=1 m=1
M14 VY VY VIN VDD pch l=0.15 w=1 nf=1 m=1
M15 VX VX VIN VDD pch l=0.15 w=1 nf=1 m=1
M16 VX VB4 VIN VDD pch l=0.15 w=1 nf=1 m=1
M17 VX VO1 VSS VSS nch l=0.15 w=1 nf=1 m=1
M18 VX VX VSS VSS nch l=0.15 w=1 nf=1 m=1
M21 net5 VO1 VSS VSS nch l=0.15 w=1 nf=1 m=1
M22 net6 VX VSS VSS nch l=0.15 w=1 nf=1 m=1
M23 net5 net5 VIN VDD pch l=0.15 w=1 nf=1 m=1
M24 net6 net5 VIN VDD pch l=0.15 w=1 nf=1 m=1
M25 VO1 VY VIN VDD pch l=0.15 w=1 nf=1 m=1
M26 net4 VX VIN VDD pch l=0.15 w=1 nf=1 m=1
M27 net4 net4 VSS VSS nch l=0.15 w=1 nf=1 m=1
M28 VO1 net4 VSS VSS nch l=0.15 w=1 nf=1 m=1
MB1 VB2 VB2 VIN VDD pch l=0.15 w=1 nf=1 m=1
MB10 VB1 VBN VSS VSS nch l=0.15 w=1 nf=1 m=1
MB2 VB2 net1 net9 VSS nch l=0.15 w=1 nf=1 m=1
MB3 net1 VB2 VIN VDD pch l=0.15 w=1 nf=1 m=1
MB4 net1 net1 VSS VSS nch l=0.15 w=1 nf=1 m=1
MB5 net3 net1 VSS VSS nch l=0.15 w=1 nf=1 m=1
MB6 net3 net3 VIN VDD pch l=0.15 w=1 nf=1 m=1
MB7 VBN net3 VIN VDD pch l=0.15 w=1 nf=1 m=1
MB8 VBN VBN VSS VSS nch l=0.15 w=1 nf=1 m=1
MB9 VB1 VB1 VIN VDD pch l=0.15 w=1 nf=1 m=1
MD1 net7 VO1 VSS VSS nch l=0.15 w=1 nf=1 m=1
MD2 net2 VB5 VSS VSS nch l=0.15 w=1 nf=1 m=1
MD3 net8 net7 net2 VSS nch l=0.15 w=1 nf=1 m=1
MD4 VY VB3 net2 VSS nch l=0.15 w=1 nf=1 m=1
MD5 net7 VY VIN VDD pch l=0.15 w=1 nf=1 m=1
MD6 net8 net8 VIN VDD pch l=0.15 w=1 nf=1 m=1
MD7 VY VY VIN VDD pch l=0.15 w=1 nf=1 m=1
MPT VOUT net6 VIN VDD pch l=0.15 w=1 nf=1 m=1
RB net9 VSS 1k
RF1 VOUT VFB 1k
RF2 VFB VSS 1k
.ends dut
