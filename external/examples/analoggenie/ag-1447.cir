* official Analog Canvas netlist; PDK X cards rewritten by convert.py
.model nch nmos
.model pch pmos

.subckt dut VDD VSS VSTO VCONT1 VCONT2 VCONT3 VOUT
CL VOUT VSS 1p
CSTO VSTO VSS 1p
LRX net7 net3 1n
M1 net1 net1 VDD VDD pch l=0.15 w=1 nf=1 m=1
M10 VB1 VB1 VDD VDD pch l=0.15 w=1 nf=1 m=1
M11 VBN net0 VDD VDD pch l=0.15 w=1 nf=1 m=1
M12 net6 net0 VDD VDD pch l=0.15 w=1 nf=1 m=1
M13 net0 net0 VDD VDD pch l=0.15 w=1 nf=1 m=1
M14 VB3 net0 VDD VDD pch l=0.15 w=1 nf=1 m=1
M15 net0 VB3 VB2 VSS nch l=0.15 w=1 nf=1 m=1
M16 VB2 net6 VSS VSS nch l=0.15 w=1 nf=1 m=1
M17 VB3 VB2 VSS VSS nch l=0.15 w=1 nf=1 m=1
M18 net6 net6 VSS VSS nch l=0.15 w=1 nf=1 m=1
M19 VB1 VBN VSS VSS nch l=0.15 w=1 nf=1 m=1
M2 net5 net1 VDD VDD pch l=0.15 w=1 nf=1 m=1
M20 VBN VBN VSS VSS nch l=0.15 w=1 nf=1 m=1
M3 net4 net4 VDD VDD pch l=0.15 w=1 nf=1 m=1
M4 net4 net4 VDD VDD pch l=0.15 w=1 nf=1 m=1
M5 net1 net3 net2 VSS nch l=0.15 w=1 nf=1 m=1
M6 net5 net5 VSS VSS nch l=0.15 w=1 nf=1 m=1
M7 net4 net5 VSS VSS nch l=0.15 w=1 nf=1 m=1
M8 net4 net4 net2 VSS nch l=0.15 w=1 nf=1 m=1
M9 net2 VBN VSS VSS nch l=0.15 w=1 nf=1 m=1
MN1 net7 VCONT2 VSS VSS nch l=0.15 w=1 nf=1 m=1
MN2 net3 VCONT3 VSS VSS nch l=0.15 w=1 nf=1 m=1
MP2 net3 net4 VOUT VDD pch l=0.15 w=1 nf=1 m=1
MP3 net7 VCONT1 VSTO VDD pch l=0.15 w=1 nf=1 m=1
.ends dut
