* official Analog Canvas netlist; PDK X cards rewritten by convert.py
.model nch nmos
.model pch pmos

.subckt dut VDD VSS VREF IBUF VB4 VIN VOUT
CL VOUT net10 1p
M1 VB5 VB5 VSS VSS nch l=0.15 w=1 nf=1 m=1
M10 EAO VB2 net6 VDD pch l=0.15 w=1 nf=1 m=1
M11 net5 VB3 VDD VDD pch l=0.15 w=1 nf=1 m=1
M12 net6 VB3 VDD VDD pch l=0.15 w=1 nf=1 m=1
M13 net8 VB4 VDD VDD pch l=0.15 w=1 nf=1 m=1
M14 net3 EAO net8 VDD pch l=0.15 w=1 nf=1 m=1
M15 net3 net3 VSS VSS nch l=0.15 w=1 nf=1 m=1
M16 GATE net3 VSS VSS nch l=0.15 w=1 nf=1 m=1
M17 VDD net8 GATE VSS nch l=0.15 w=1 nf=1 m=1
M18 net4 EAO IBUF VSS nch l=0.15 w=1 nf=1 m=1
M19 net4 net4 VDD VDD pch l=0.15 w=1 nf=1 m=1
M2 net1 VB5 VSS VSS nch l=0.15 w=1 nf=1 m=1
M20 GATE net4 VDD VDD pch l=0.15 w=1 nf=1 m=1
M21 VSS IBUF GATE VDD pch l=0.15 w=1 nf=1 m=1
M22 VB1 VB1 VB5 VSS nch l=0.15 w=1 nf=1 m=1
M23 VB1 net9 VDD VDD pch l=0.15 w=1 nf=1 m=1
M24 net9 net9 VDD VDD pch l=0.15 w=1 nf=1 m=1
M25 VX net9 VDD VDD pch l=0.15 w=1 nf=1 m=1
M26 net9 VX net0 VSS nch l=0.15 w=1 nf=1 m=1
M27 VX net0 VSS VSS nch l=0.15 w=1 nf=1 m=1
M3 net6 VREF net1 VSS nch l=0.15 w=1 nf=1 m=1
M4 net5 FB net1 VSS nch l=0.15 w=1 nf=1 m=1
M5 net7 VX VSS VSS nch l=0.15 w=1 nf=1 m=1
M6 net2 VX VSS VSS nch l=0.15 w=1 nf=1 m=1
M7 VX VB1 net7 VSS nch l=0.15 w=1 nf=1 m=1
M8 EAO VB1 net2 VSS nch l=0.15 w=1 nf=1 m=1
M9 VX VB2 net5 VDD pch l=0.15 w=1 nf=1 m=1
MNP VIN GATE VOUT VSS nch l=0.15 w=1 nf=1 m=1
R1 FB VSS 1k
R2 VOUT FB 1k
R3 net0 VSS 1k
R4 net10 VSS 1k
RL VOUT VSS 1k
.ends dut
