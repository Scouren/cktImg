* official Analog Canvas netlist; PDK X cards rewritten by convert.py
.model nch nmos
.model pch pmos

.subckt dut VDD VSS vin vout
IBIAS Vb2 VSS DC 1m
M1 net5 net4 VSS VSS nch l=0.15 w=1 nf=1 m=1
M10 net2 net2 VSS VSS nch l=0.15 w=1 nf=1 m=1
M11 vout net2 VSS VSS nch l=0.15 w=1 nf=1 m=1
M12 VDD net8 vout VSS nch l=0.15 w=1 nf=1 m=1
M13 Vb1 Vb2 net3 VDD pch l=0.15 w=1 nf=1 m=1
M14 net3 Vb1 VDD VDD pch l=0.15 w=1 nf=1 m=1
M2 net0 net4 VSS VSS nch l=0.15 w=1 nf=1 m=1
M3 net4 net1 net5 VSS nch l=0.15 w=1 nf=1 m=1
M4 net8 net1 net0 VSS nch l=0.15 w=1 nf=1 m=1
M5 net1 Vb2 net7 VDD pch l=0.15 w=1 nf=1 m=1
M6 net8 Vb2 net6 VDD pch l=0.15 w=1 nf=1 m=1
M7 net7 Vb1 VDD VDD pch l=0.15 w=1 nf=1 m=1
M8 net6 Vb1 VDD VDD pch l=0.15 w=1 nf=1 m=1
M9 net2 Vb1 VDD VDD pch l=0.15 w=1 nf=1 m=1
R1 vin net1 1k
R2 net1 net8 1k
R3 net1 net4 1k
R4 Vb1 Vb2 1k
.ends dut
