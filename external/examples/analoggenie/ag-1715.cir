* official Analog Canvas netlist; PDK X cards rewritten by convert.py
.model nch nmos
.model pch pmos
.model qpnp pnp

.subckt A1 VDD VSS INN INP OUT
M1 VB1 VB1 VDD VDD pch l=0.15 w=1 nf=1 m=1
M10 net2 net0 VSS VSS nch l=0.15 w=1 nf=1 m=1
M11 net2 net5 VDD VDD pch l=0.15 w=1 nf=1 m=1
M12 net2 net2 VSS VSS nch l=0.15 w=1 nf=1 m=1
M13 net5 net5 VDD VDD pch l=0.15 w=1 nf=1 m=1
M14 net5 INN net4 VSS nch l=0.15 w=1 nf=1 m=1
M15 net1 net1 VDD VDD pch l=0.15 w=1 nf=1 m=1
M16 net1 INP net4 VSS nch l=0.15 w=1 nf=1 m=1
M17 OUT net1 VDD VDD pch l=0.15 w=1 nf=1 m=1
M18 OUT net2 VSS VSS nch l=0.15 w=1 nf=1 m=1
M19 net4 VB2 VSS VSS nch l=0.15 w=1 nf=1 m=1
M2 VB1 VB2 VSS VSS nch l=0.15 w=1 nf=1 m=1
M3 VB2 net3 VDD VDD pch l=0.15 w=1 nf=1 m=1
M4 VB2 VB2 VSS VSS nch l=0.15 w=1 nf=1 m=1
M5 net3 net3 VDD VDD pch l=0.15 w=1 nf=1 m=1
M6 net3 net0 VSS VSS nch l=0.15 w=1 nf=1 m=1
M7 net0 net0 VSS VSS nch l=0.15 w=1 nf=1 m=1
M8 net0 net2 VDD VDD pch l=0.15 w=1 nf=1 m=1
M9 net2 net2 VDD VDD pch l=0.15 w=1 nf=1 m=1
R1 VDD net0 1k
.ends A1

.subckt dut VDD VSS Vout
Q1 VSS VSS net1 qpnp m=1
Q2 net1 net1 X qpnp m=1
Q3 VSS VSS net0 qpnp m=1
Q4 net0 net0 net2 qpnp m=1
R1 Vout X 1k
R2 Vout Y 1k
R3 Y net2 1k
X1 VDD VSS Y X Vout A1
.ends dut
