* official Analog Canvas netlist; PDK X cards rewritten by convert.py
.model nch nmos
.model pch pmos
.model qpnp pnp

.subckt opamp VDD VSS INN INP OUT
M1 INN VB1 VDD VDD pch l=0.15 w=1 nf=1 m=1
M10 net4 INP net7 VSS nch l=0.15 w=1 nf=1 m=1
M11 net7 VB2 VSS VSS nch l=0.15 w=1 nf=1 m=1
M12 VB5 net3 VDD VDD pch l=0.15 w=1 nf=1 m=1
M13 VB5 VB5 net5 VSS nch l=0.15 w=1 nf=1 m=1
M14 net5 VB5 VSS VSS nch l=0.15 w=1 nf=1 m=1
M15 net3 net3 VDD VDD pch l=0.15 w=1 nf=1 m=1
M16 VB4 net3 VDD VDD pch l=0.15 w=1 nf=1 m=1
M17 net3 VB4 net6 VSS nch l=0.15 w=1 nf=1 m=1
M18 VB4 VB4 VSS VSS nch l=0.15 w=1 nf=1 m=1
M2 net4 VB1 VDD VDD pch l=0.15 w=1 nf=1 m=1
M3 net0 VB3 INN VDD pch l=0.15 w=1 nf=1 m=1
M4 OUT VB3 net4 VDD pch l=0.15 w=1 nf=1 m=1
M5 net0 VB5 net1 VSS nch l=0.15 w=1 nf=1 m=1
M6 OUT VB5 net2 VSS nch l=0.15 w=1 nf=1 m=1
M7 net1 net0 VSS VSS nch l=0.15 w=1 nf=1 m=1
M8 net2 net0 VSS VSS nch l=0.15 w=1 nf=1 m=1
M9 INN INN net7 VSS nch l=0.15 w=1 nf=1 m=1
R4 net6 VSS 1k
.ends opamp

.subckt dut VDD VSS Vout
Q1 VSS VSS net0 qpnp m=1
Q2 net0 net0 X qpnp m=1
Q3 VSS VSS net1 qpnp m=1
Q4 net1 net1 net2 qpnp m=1
R1 Vout X 1k
R2 Vout Y 1k
R3 Y net2 1k
X1 VDD VSS Y X Vout opamp
.ends dut
