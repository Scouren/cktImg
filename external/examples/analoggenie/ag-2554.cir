* official Analog Canvas netlist; PDK X cards rewritten by convert.py
.model nch nmos
.model pch pmos

.subckt AMP1 VDD VSS INN INP VB2 VB1 VBN OUT
M10 net0 INN net7 VDD pch l=0.15 w=1 nf=1 m=1
M11 net3 INP net7 VDD pch l=0.15 w=1 nf=1 m=1
M12 net7 VB2 VDD VDD pch l=0.15 w=1 nf=1 m=1
M13 net8 net0 VSS VSS nch l=0.15 w=1 nf=1 m=1
M14 net2 net3 VSS VSS nch l=0.15 w=1 nf=1 m=1
M15 net1 net0 VSS VSS nch l=0.15 w=1 nf=1 m=1
M16 net6 net3 VSS VSS nch l=0.15 w=1 nf=1 m=1
M17 OUT VBN net8 VSS nch l=0.15 w=1 nf=1 m=1
M18 VX VBN net2 VSS nch l=0.15 w=1 nf=1 m=1
M19 net0 VBN net1 VSS nch l=0.15 w=1 nf=1 m=1
M20 net3 VBN net6 VSS nch l=0.15 w=1 nf=1 m=1
M6 net4 VX VDD VDD pch l=0.15 w=1 nf=1 m=1
M7 net5 VX VDD VDD pch l=0.15 w=1 nf=1 m=1
M8 OUT VB1 net4 VDD pch l=0.15 w=1 nf=1 m=1
M9 VX VB1 net5 VDD pch l=0.15 w=1 nf=1 m=1
.ends AMP1

.subckt dut VDD VSS Vref Vout biasp biascas biasn VB1 VB2 VB3
C1 Vset VSS 1p
C2 n3 Vout 1p
M1 Vout n3 VDD VDD pch l=0.15 w=1 nf=1 m=1
M2 n1 Vset Vout VDD pch l=0.15 w=1 nf=1 m=1
M21 VBP VBP VDD VDD pch l=0.15 w=1 nf=1 m=1
M22 n3 VBP VDD VDD pch l=0.15 w=1 nf=1 m=1
M23 VBN VBP VDD VDD pch l=0.15 w=1 nf=1 m=1
M24 VBP n3 VB3 VSS nch l=0.15 w=1 nf=1 m=1
M25 n3 VB3 VSS VSS nch l=0.15 w=1 nf=1 m=1
M26 VBN VBN net0 VSS nch l=0.15 w=1 nf=1 m=1
M27 net0 VBN VSS VSS nch l=0.15 w=1 nf=1 m=1
M3 n1 biasn VSS VSS nch l=0.15 w=1 nf=1 m=1
M4 n3 biasp VDD VDD pch l=0.15 w=1 nf=1 m=1
M5 n3 biascas n1 VSS nch l=0.15 w=1 nf=1 m=1
R1 fb VSS 1k
R2 Vout fb 1k
R3 VB3 VSS 1k
X1 VDD VSS fb Vref VB2 VB1 VBN Vset AMP1
.ends dut
