* official Analog Canvas netlist; PDK X cards rewritten by convert.py
.model nch nmos
.model pch pmos

.subckt dut VDD VSS VIN VREF VB4 VB3 VB2 VOUT
CF1 VOUT VFB 1p
Cm1 VOUT VA 1p
Cm2 VA net8 1p
M1 VC VC VIN VDD pch l=0.15 w=1 nf=1 m=1
M11 net9 VB5 VSS VSS nch l=0.15 w=1 nf=1 m=1
M12 VD VFB net9 VSS nch l=0.15 w=1 nf=1 m=1
M13 VC VREF net9 VSS nch l=0.15 w=1 nf=1 m=1
M14 net0 net0 VSS VSS nch l=0.15 w=1 nf=1 m=1
M15 VA net0 VSS VSS nch l=0.15 w=1 nf=1 m=1
M16 VC VB4 VIN VDD pch l=0.15 w=1 nf=1 m=1
M17 VC VA VSS VSS nch l=0.15 w=1 nf=1 m=1
M18 VC VC VSS VSS nch l=0.15 w=1 nf=1 m=1
M2 net0 VC VIN VDD pch l=0.15 w=1 nf=1 m=1
M21 net5 VA VSS VSS nch l=0.15 w=1 nf=1 m=1
M22 net7 VC VSS VSS nch l=0.15 w=1 nf=1 m=1
M23 net5 net5 VIN VDD pch l=0.15 w=1 nf=1 m=1
M24 net7 net5 VIN VDD pch l=0.15 w=1 nf=1 m=1
M3 VD VD VIN VDD pch l=0.15 w=1 nf=1 m=1
M4 VA VD VIN VDD pch l=0.15 w=1 nf=1 m=1
MB1 net1 VP VIN VDD pch l=0.15 w=1 nf=1 m=1
MB2 VP VP VIN VDD pch l=0.15 w=1 nf=1 m=1
MB3 net2 VP VIN VDD pch l=0.15 w=1 nf=1 m=1
MB4 VB5 VP VIN VDD pch l=0.15 w=1 nf=1 m=1
MB5 net1 net1 VSS VSS nch l=0.15 w=1 nf=1 m=1
MB6 net4 net1 VSS VSS nch l=0.15 w=1 nf=1 m=1
MB7 VP net2 net4 VSS nch l=0.15 w=1 nf=1 m=1
MB8 net2 net2 VSS VSS nch l=0.15 w=1 nf=1 m=1
MB9 VB5 VB5 VSS VSS nch l=0.15 w=1 nf=1 m=1
MD1 net8 VA VSS VSS nch l=0.15 w=1 nf=1 m=1
MD2 net6 VB2 VSS VSS nch l=0.15 w=1 nf=1 m=1
MD3 net3 net8 net6 VSS nch l=0.15 w=1 nf=1 m=1
MD4 VD VB3 net6 VSS nch l=0.15 w=1 nf=1 m=1
MD5 net8 VD VIN VDD pch l=0.15 w=1 nf=1 m=1
MD6 net3 net3 VIN VDD pch l=0.15 w=1 nf=1 m=1
MD7 VD VD VIN VDD pch l=0.15 w=1 nf=1 m=1
MPT VOUT net7 VIN VDD pch l=0.15 w=1 nf=1 m=1
RF1 VOUT VFB 1k
RF2 VFB VSS 1k
.ends dut
