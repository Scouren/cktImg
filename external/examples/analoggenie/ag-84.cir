* official Analog Canvas netlist; PDK X cards rewritten by convert.py
.model nch nmos
.model pch pmos

.subckt dut VDD VSS Vb2 Vout1 Vout2 Vin1 Vin2 Vb1
M1 Vout1 Vin1 net1 VSS nch l=0.15 w=1 nf=1 m=1
M2 Vout2 Vin2 net1 VSS nch l=0.15 w=1 nf=1 m=1
M3 Vout1 Vb2 net0 VDD pch l=0.15 w=1 nf=1 m=1
M4 Vout2 Vb2 net2 VDD pch l=0.15 w=1 nf=1 m=1
M5 net1 Vb1 VSS VSS nch l=0.15 w=1 nf=1 m=1
R1 VDD net0 1k
R2 VDD net2 1k
.ends dut
