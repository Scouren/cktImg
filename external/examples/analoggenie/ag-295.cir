* official Analog Canvas netlist; PDK X cards rewritten by convert.py
.model nch nmos
.model pch pmos

.subckt dut VDD VSS Vin1 Vin2 Vb4 Vb3 Vb2 Vb1
C1 net7 Vin1 1p
C2 net5 Vin2 1p
I1 net1 VSS DC 1m
M1 net0 net8 net1 VSS nch l=0.15 w=1 nf=1 m=1
M10 net4 Vb4 VDD VDD pch l=0.15 w=1 nf=1 m=1
M2 net4 net6 net1 VSS nch l=0.15 w=1 nf=1 m=1
M3 X Vb3 net0 VDD pch l=0.15 w=1 nf=1 m=1
M4 Y Vb3 net4 VDD pch l=0.15 w=1 nf=1 m=1
M5 X Vb2 net3 VSS nch l=0.15 w=1 nf=1 m=1
M6 Y Vb2 net2 VSS nch l=0.15 w=1 nf=1 m=1
M7 net3 Vb1 VSS VSS nch l=0.15 w=1 nf=1 m=1
M8 net2 Vb1 VSS VSS nch l=0.15 w=1 nf=1 m=1
M9 net0 Vb4 VDD VDD pch l=0.15 w=1 nf=1 m=1
R1 net8 net7 1k
R2 net6 net5 1k
R3 X net8 1k
R4 net6 Y 1k
.ends dut
