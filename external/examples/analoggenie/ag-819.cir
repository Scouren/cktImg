* official Analog Canvas netlist; PDK X cards rewritten by convert.py
.model pch pmos

.subckt dut VDD VSS Vin+ Vin- Vout- Vout+ Vcntl_p Vcntl
G1 VDD net0 Vcntl_p VSS 1m
G2 Vout- VSS Vcntl VSS 1m
G3 Vout+ VSS Vcntl VSS 1m
M1 Vout- Vin+ net0 VDD pch l=0.15 w=1 nf=1 m=1
M2 Vout+ Vin- net0 VDD pch l=0.15 w=1 nf=1 m=1
.ends dut
