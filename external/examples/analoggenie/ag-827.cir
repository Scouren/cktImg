* official Analog Canvas netlist; PDK X cards rewritten by convert.py
.model nch nmos
.model pch pmos

.subckt dut VDD VSS Vi Vo
I1 VDD Vo DC 1m
I2 net0 VSS DC 1m
M1 net0 Vi Vo VDD pch l=0.15 w=1 nf=1 m=1
M2 Vo net0 VSS VSS nch l=0.15 w=1 nf=1 m=1
.ends dut
