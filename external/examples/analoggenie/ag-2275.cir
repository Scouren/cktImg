* official Analog Canvas netlist; PDK X cards rewritten by convert.py
.model nch nmos
.model pch pmos

.subckt dut VDD VSS VREF VB2 IBUF VIN VOUT
CL VOUT net9 1p
M1 net7 net4 VDD VDD pch l=0.15 w=1 nf=1 m=1
M10 EAO VB1 net10 VDD pch l=0.15 w=1 nf=1 m=1
M11 net11 VY VDD VDD pch l=0.15 w=1 nf=1 m=1
M12 net10 net4 VDD VDD pch l=0.15 w=1 nf=1 m=1
M13 VX VB4 VDD VDD pch l=0.15 w=1 nf=1 m=1
M14 net1 EAO VX VDD pch l=0.15 w=1 nf=1 m=1
M15 net1 net1 VSS VSS nch l=0.15 w=1 nf=1 m=1
M16 GATE net1 VSS VSS nch l=0.15 w=1 nf=1 m=1
M17 VDD VX GATE VSS nch l=0.15 w=1 nf=1 m=1
M18 net3 EAO IBUF VSS nch l=0.15 w=1 nf=1 m=1
M19 net3 net3 VDD VDD pch l=0.15 w=1 nf=1 m=1
M2 net6 VY VDD VDD pch l=0.15 w=1 nf=1 m=1
M20 GATE net3 VDD VDD pch l=0.15 w=1 nf=1 m=1
M21 VSS IBUF GATE VDD pch l=0.15 w=1 nf=1 m=1
M22 net4 VB1 net7 VDD pch l=0.15 w=1 nf=1 m=1
M23 VY VB1 net6 VDD pch l=0.15 w=1 nf=1 m=1
M24 VX VB2 VSS VSS nch l=0.15 w=1 nf=1 m=1
M25 VZ net0 VDD VDD pch l=0.15 w=1 nf=1 m=1
M26 VZ VZ net8 VSS nch l=0.15 w=1 nf=1 m=1
M27 net8 VZ VSS VSS nch l=0.15 w=1 nf=1 m=1
M28 net0 net0 VDD VDD pch l=0.15 w=1 nf=1 m=1
M29 net0 VY VB3 VSS nch l=0.15 w=1 nf=1 m=1
M3 net4 VREF VX VSS nch l=0.15 w=1 nf=1 m=1
M30 VY net0 VDD VDD pch l=0.15 w=1 nf=1 m=1
M31 VY VB3 VSS VSS nch l=0.15 w=1 nf=1 m=1
M4 VY FB VX VSS nch l=0.15 w=1 nf=1 m=1
M5 net2 net12 VSS VSS nch l=0.15 w=1 nf=1 m=1
M6 net5 net12 VSS VSS nch l=0.15 w=1 nf=1 m=1
M7 net12 VZ net2 VSS nch l=0.15 w=1 nf=1 m=1
M8 EAO VZ net5 VSS nch l=0.15 w=1 nf=1 m=1
M9 net12 VB1 net11 VDD pch l=0.15 w=1 nf=1 m=1
MNP VIN GATE VOUT VSS nch l=0.15 w=1 nf=1 m=1
R1 FB VSS 1k
R2 VOUT FB 1k
R3 VB3 VSS 1k
R4 net9 VSS 1k
RL VOUT VSS 1k
.ends dut
