* official Analog Canvas netlist; PDK X cards rewritten by convert.py
.model nch nmos
.model pch pmos

.subckt bias VDD VSS VB5 VBN
M22 VB5 VB6 VDD VDD pch l=0.15 w=1 nf=1 m=1
M23 VB5 VB5 VBN VSS nch l=0.15 w=1 nf=1 m=1
M24 VB6 VB6 VDD VDD pch l=0.15 w=1 nf=1 m=1
M25 net0 VB6 VDD VDD pch l=0.15 w=1 nf=1 m=1
M26 VB3 VB6 VDD VDD pch l=0.15 w=1 nf=1 m=1
M27 VB6 VB3 net1 VSS nch l=0.15 w=1 nf=1 m=1
M28 net1 net0 VSS VSS nch l=0.15 w=1 nf=1 m=1
M29 net0 net0 VSS VSS nch l=0.15 w=1 nf=1 m=1
M30 VB3 VB3 VSS VSS nch l=0.15 w=1 nf=1 m=1
.ends bias

.subckt dut VDD VSS VB1 VB2 VREF VB4 IBUF VIN VOUT
CL VOUT net1 1p
M1 net4 net4 VSS VSS nch l=0.15 w=1 nf=1 m=1
M10 EAO VB2 net3 VDD pch l=0.15 w=1 nf=1 m=1
M11 net9 VB1 VDD VDD pch l=0.15 w=1 nf=1 m=1
M12 net3 VB1 VDD VDD pch l=0.15 w=1 nf=1 m=1
M13 net2 VB4 VDD VDD pch l=0.15 w=1 nf=1 m=1
M14 net7 EAO net2 VDD pch l=0.15 w=1 nf=1 m=1
M15 net7 net7 VSS VSS nch l=0.15 w=1 nf=1 m=1
M16 GATE net7 VSS VSS nch l=0.15 w=1 nf=1 m=1
M17 VDD net2 GATE VSS nch l=0.15 w=1 nf=1 m=1
M18 net0 EAO IBUF VSS nch l=0.15 w=1 nf=1 m=1
M19 net0 net0 VDD VDD pch l=0.15 w=1 nf=1 m=1
M2 net5 net4 VSS VSS nch l=0.15 w=1 nf=1 m=1
M20 GATE net0 VDD VDD pch l=0.15 w=1 nf=1 m=1
M21 VSS IBUF GATE VDD pch l=0.15 w=1 nf=1 m=1
M3 net3 VREF net5 VSS nch l=0.15 w=1 nf=1 m=1
M4 net9 FB net5 VSS nch l=0.15 w=1 nf=1 m=1
M5 net6 net10 VSS VSS nch l=0.15 w=1 nf=1 m=1
M6 net8 net10 VSS VSS nch l=0.15 w=1 nf=1 m=1
M7 net10 VB5 net6 VSS nch l=0.15 w=1 nf=1 m=1
M8 EAO VB5 net8 VSS nch l=0.15 w=1 nf=1 m=1
M9 net10 VB2 net9 VDD pch l=0.15 w=1 nf=1 m=1
MNP VIN GATE VOUT VSS nch l=0.15 w=1 nf=1 m=1
R1 FB VSS 1k
R2 VOUT FB 1k
R3 net1 VSS 1k
RL VOUT VSS 1k
X1 VDD VSS VB5 net4 bias
.ends dut
