* official Analog Canvas netlist; PDK X cards rewritten by convert.py
.model nch nmos
.model pch pmos

.subckt dut VDD VSS VSTO VCONT1 VCONT2 VCONT3 VOUT VB1
CL VOUT VSS 1p
CSTO VSTO VSS 1p
LRX net4 VX 1n
M1 VB3 net1 VDD VDD pch l=0.15 w=1 nf=1 m=1
M10 VB3 VB3 VDD VDD pch l=0.15 w=1 nf=1 m=1
M11 VB3 net0 VSS VSS nch l=0.15 w=1 nf=1 m=1
M12 net0 VB3 VDD VDD pch l=0.15 w=1 nf=1 m=1
M13 net0 net0 VSS VSS nch l=0.15 w=1 nf=1 m=1
M14 net2 net0 VSS VSS nch l=0.15 w=1 nf=1 m=1
M15 net2 net2 VDD VDD pch l=0.15 w=1 nf=1 m=1
M16 VB2 net2 VDD VDD pch l=0.15 w=1 nf=1 m=1
M17 VB2 VB2 VSS VSS nch l=0.15 w=1 nf=1 m=1
M18 VB1 VB1 VDD VDD pch l=0.15 w=1 nf=1 m=1
M19 VB1 VB2 VSS VSS nch l=0.15 w=1 nf=1 m=1
M2 VB3 VB3 VSS VSS nch l=0.15 w=1 nf=1 m=1
M3 net1 net1 VDD VDD pch l=0.15 w=1 nf=1 m=1
M4 net1 VX net3 VSS nch l=0.15 w=1 nf=1 m=1
M5 VG VG VDD VDD pch l=0.15 w=1 nf=1 m=1
M6 VG VG net3 VSS nch l=0.15 w=1 nf=1 m=1
M7 net3 VB2 VSS VSS nch l=0.15 w=1 nf=1 m=1
M8 VG VG VDD VDD pch l=0.15 w=1 nf=1 m=1
M9 VG VB3 VSS VSS nch l=0.15 w=1 nf=1 m=1
MN1 net4 VCONT2 VSS VSS nch l=0.15 w=1 nf=1 m=1
MN2 VX VCONT3 VSS VSS nch l=0.15 w=1 nf=1 m=1
MP2 VX VG VOUT VDD pch l=0.15 w=1 nf=1 m=1
MP3 net4 VCONT1 VSTO VDD pch l=0.15 w=1 nf=1 m=1
R1 VDD net0 1k
.ends dut
