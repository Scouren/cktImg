* official Analog Canvas netlist; PDK X cards rewritten by convert.py
.model nch nmos

.subckt dut VDD VSS Vin1 Vin2 Vout1 Vout2
I1 VDD net2 DC 1m
I2 VDD net0 DC 1m
I3 VDD Vout1 DC 1m
I4 VDD Vout2 DC 1m
I5 net3 VSS DC 1m
I6 net1 VSS DC 1m
M1 net2 Vin1 net3 VSS nch l=0.15 w=1 nf=1 m=1
M2 net0 Vin2 net3 VSS nch l=0.15 w=1 nf=1 m=1
M3 Vout1 net0 net1 VSS nch l=0.15 w=1 nf=1 m=1
M4 Vout2 net2 net1 VSS nch l=0.15 w=1 nf=1 m=1
Rf1 Vin1 Vout1 1k
Rf2 Vin2 Vout2 1k
.ends dut
