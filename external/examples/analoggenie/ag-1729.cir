* official Analog Canvas netlist; PDK X cards rewritten by convert.py
.model nch nmos
.model pch pmos
.model qpnp pnp

.subckt opamp VDD VSS INN INP OUT
M1 net0 INN net5 VSS nch l=0.15 w=1 nf=1 m=1
M10 net2 net2 net4 VDD pch l=0.15 w=1 nf=1 m=1
M11 VB2 net2 VDD VDD pch l=0.15 w=1 nf=1 m=1
M12 VB2 VB2 VSS VSS nch l=0.15 w=1 nf=1 m=1
M13 VB1 VB2 VSS VSS nch l=0.15 w=1 nf=1 m=1
M14 VB1 VB1 VDD VDD pch l=0.15 w=1 nf=1 m=1
M2 net1 INP net5 VSS nch l=0.15 w=1 nf=1 m=1
M3 net1 net1 VDD VDD pch l=0.15 w=1 nf=1 m=1
M4 net0 net0 VDD VDD pch l=0.15 w=1 nf=1 m=1
M5 OUT net1 VDD VDD pch l=0.15 w=1 nf=1 m=1
M6 net3 net0 VDD VDD pch l=0.15 w=1 nf=1 m=1
M7 OUT net3 VSS VSS nch l=0.15 w=1 nf=1 m=1
M8 net3 net3 VSS VSS nch l=0.15 w=1 nf=1 m=1
M9 net5 VB2 VSS VSS nch l=0.15 w=1 nf=1 m=1
R4 VDD net4 1k
R5 net2 VSS 1k
.ends opamp

.subckt dut VDD VSS Vout
Q1 VSS VSS net1 qpnp m=1
Q2 net1 net1 X qpnp m=1
Q3 VSS VSS net2 qpnp m=1
Q4 net2 net2 net0 qpnp m=1
R1 Vout X 1k
R2 Vout Y 1k
R3 Y net0 1k
X1 VDD VSS Y X Vout opamp
.ends dut
