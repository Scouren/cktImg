* official Analog Canvas netlist; PDK X cards rewritten by convert.py
.model nch nmos
.model pch pmos

.subckt AMP1 VDD VSS INP INN OUT
M10 net7 VB2 VDD VDD pch l=0.15 w=1 nf=1 m=1
M11 net8 INP net7 VDD pch l=0.15 w=1 nf=1 m=1
M12 net0 INN net7 VDD pch l=0.15 w=1 nf=1 m=1
M13 net4 VBN net3 VSS nch l=0.15 w=1 nf=1 m=1
M14 net8 VBN net10 VSS nch l=0.15 w=1 nf=1 m=1
M15 net0 VBN net11 VSS nch l=0.15 w=1 nf=1 m=1
M16 OUT VBN net12 VSS nch l=0.15 w=1 nf=1 m=1
M17 net3 net8 VSS VSS nch l=0.15 w=1 nf=1 m=1
M18 net10 net8 VSS VSS nch l=0.15 w=1 nf=1 m=1
M19 net11 net0 VSS VSS nch l=0.15 w=1 nf=1 m=1
M20 net12 net0 VSS VSS nch l=0.15 w=1 nf=1 m=1
M21 VBP VBP VDD VDD pch l=0.15 w=1 nf=1 m=1
M22 net9 VBP VDD VDD pch l=0.15 w=1 nf=1 m=1
M23 VBN VBP VDD VDD pch l=0.15 w=1 nf=1 m=1
M24 VBP net9 VSS VSS nch l=0.15 w=1 nf=1 m=1
M25 net2 net9 VSS VSS nch l=0.15 w=1 nf=1 m=1
M26 VBN VBN net5 VSS nch l=0.15 w=1 nf=1 m=1
M27 net5 VBN VSS VSS nch l=0.15 w=1 nf=1 m=1
M6 net1 net4 VDD VDD pch l=0.15 w=1 nf=1 m=1
M7 net6 net4 VDD VDD pch l=0.15 w=1 nf=1 m=1
M8 net4 VB1 net1 VDD pch l=0.15 w=1 nf=1 m=1
M9 OUT VB1 net6 VDD pch l=0.15 w=1 nf=1 m=1
R3 net9 net2 1k
.ends AMP1

.subckt dut VDD VSS Vref biasp biascas biasn Vout
C1 Vset VSS 1p
C2 n3 Vout 1p
M1 Vout n3 VDD VDD pch l=0.15 w=1 nf=1 m=1
M2 n1 Vset Vout VDD pch l=0.15 w=1 nf=1 m=1
M3 n1 biasn VSS VSS nch l=0.15 w=1 nf=1 m=1
M4 n3 biasp VDD VDD pch l=0.15 w=1 nf=1 m=1
M5 n3 biascas n1 VSS nch l=0.15 w=1 nf=1 m=1
R1 fb VSS 1k
R2 Vout fb 1k
X1 VDD VSS Vref fb Vset AMP1
.ends dut
