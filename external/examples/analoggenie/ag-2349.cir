* official Analog Canvas netlist; PDK X cards rewritten by convert.py
.model nch nmos
.model pch pmos

.subckt dut VDD VSS VREF VB2 IB VIN VOUT VB1
CL VOUT net7 1p
M1 net2 net2 VDD VDD pch l=0.15 w=1 nf=1 m=1
M10 net3 VB2 VDD VDD pch l=0.15 w=1 nf=1 m=1
M11 VX EAO net3 VDD pch l=0.15 w=1 nf=1 m=1
M12 VX VX VSS VSS nch l=0.15 w=1 nf=1 m=1
M13 VDD net3 GATE VSS nch l=0.15 w=1 nf=1 m=1
M14 GATE VX VSS VSS nch l=0.15 w=1 nf=1 m=1
M15 GATE net5 VDD VDD pch l=0.15 w=1 nf=1 m=1
M16 net5 net5 VDD VDD pch l=0.15 w=1 nf=1 m=1
M17 net5 EAO IB VSS nch l=0.15 w=1 nf=1 m=1
M18 VSS IB GATE VDD pch l=0.15 w=1 nf=1 m=1
M19 net0 net0 VSS VSS nch l=0.15 w=1 nf=1 m=1
M2 net6 net6 VDD VDD pch l=0.15 w=1 nf=1 m=1
M20 net1 net0 VSS VSS nch l=0.15 w=1 nf=1 m=1
M21 net1 net1 VDD VDD pch l=0.15 w=1 nf=1 m=1
M22 VBN net1 VDD VDD pch l=0.15 w=1 nf=1 m=1
M23 VBN VBN VSS VSS nch l=0.15 w=1 nf=1 m=1
M24 VB1 VBN VSS VSS nch l=0.15 w=1 nf=1 m=1
M25 VB1 VB1 VDD VDD pch l=0.15 w=1 nf=1 m=1
M3 net2 VREF VX VSS nch l=0.15 w=1 nf=1 m=1
M4 net6 FB VX VSS nch l=0.15 w=1 nf=1 m=1
M5 VX VBN VSS VSS nch l=0.15 w=1 nf=1 m=1
M6 EAO net2 VDD VDD pch l=0.15 w=1 nf=1 m=1
M7 net4 net6 VDD VDD pch l=0.15 w=1 nf=1 m=1
M8 EAO net4 VSS VSS nch l=0.15 w=1 nf=1 m=1
M9 net4 net4 VSS VSS nch l=0.15 w=1 nf=1 m=1
MNP VIN GATE VOUT VSS nch l=0.15 w=1 nf=1 m=1
R1 FB VSS 1k
R2 VOUT FB 1k
R3 VDD net0 1k
RESR net7 VSS 1k
RL VOUT VSS 1k
.ends dut
