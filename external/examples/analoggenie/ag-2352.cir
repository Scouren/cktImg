* official Analog Canvas netlist; PDK X cards rewritten by convert.py
.model nch nmos
.model pch pmos

.subckt dut VDD VSS VREF VB3 IBUF VIN VOUT VB2 VB1
CL VOUT net11 1p
M1 net9 net9 VDD VDD pch l=0.15 w=1 nf=1 m=1
M10 net0 net0 VDD VDD pch l=0.15 w=1 nf=1 m=1
M11 net4 net2 VDD VDD pch l=0.15 w=1 nf=1 m=1
M12 EAO net0 VDD VDD pch l=0.15 w=1 nf=1 m=1
M13 net8 VB3 VDD VDD pch l=0.15 w=1 nf=1 m=1
M14 VX EAO net8 VDD pch l=0.15 w=1 nf=1 m=1
M15 VX VX VSS VSS nch l=0.15 w=1 nf=1 m=1
M16 GATE VX VSS VSS nch l=0.15 w=1 nf=1 m=1
M17 VDD net8 GATE VSS nch l=0.15 w=1 nf=1 m=1
M18 net6 EAO IBUF IBUF nch l=0.15 w=1 nf=1 m=1
M19 net6 net6 VDD VDD pch l=0.15 w=1 nf=1 m=1
M2 VBN net9 VDD VDD pch l=0.15 w=1 nf=1 m=1
M20 GATE net6 VDD VDD pch l=0.15 w=1 nf=1 m=1
M21 VSS IBUF GATE VSS pch l=0.15 w=1 nf=1 m=1
M22 VBN VBN VSS VSS nch l=0.15 w=1 nf=1 m=1
M23 VB1 VBN VSS VSS nch l=0.15 w=1 nf=1 m=1
M24 VB1 VB1 VDD VDD pch l=0.15 w=1 nf=1 m=1
M25 VB2 VB2 VDD VDD pch l=0.15 w=1 nf=1 m=1
M26 net1 VB2 VDD VDD pch l=0.15 w=1 nf=1 m=1
M27 net5 VB2 VDD VDD pch l=0.15 w=1 nf=1 m=1
M28 net3 VB2 VDD VDD pch l=0.15 w=1 nf=1 m=1
M29 VB2 net7 VSS VSS nch l=0.15 w=1 nf=1 m=1
M3 net0 VREF VX VSS nch l=0.15 w=1 nf=1 m=1
M30 net1 net1 net7 VSS nch l=0.15 w=1 nf=1 m=1
M31 net7 net1 net10 VSS nch l=0.15 w=1 nf=1 m=1
M32 net5 net5 net10 VSS nch l=0.15 w=1 nf=1 m=1
M33 net10 net5 net3 VSS nch l=0.15 w=1 nf=1 m=1
M34 net3 net3 VSS VSS nch l=0.15 w=1 nf=1 m=1
M4 net2 FB VX VSS nch l=0.15 w=1 nf=1 m=1
M5 VX VBN VSS VSS nch l=0.15 w=1 nf=1 m=1
M6 net4 net4 VSS VSS nch l=0.15 w=1 nf=1 m=1
M7 net9 net3 VSS VSS nch l=0.15 w=1 nf=1 m=1
M8 EAO net4 VSS VSS nch l=0.15 w=1 nf=1 m=1
M9 net2 net2 VDD VDD pch l=0.15 w=1 nf=1 m=1
MNP VIN GATE VOUT VOUT nch l=0.15 w=1 nf=1 m=1
R1 FB VSS 1k
R2 VOUT FB 1k
RESR net11 VSS 1k
RL VOUT VSS 1k
.ends dut
