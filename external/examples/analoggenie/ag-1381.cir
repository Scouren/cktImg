* official Analog Canvas netlist; PDK X cards rewritten by convert.py
.model nch nmos
.model pch pmos

.subckt dut VDD VSS VSTO VCONT1 VCONT2 VCONT3 VOUT VB1 VB3 VB2 VB4
CL VOUT VSS 1p
CSTO VSTO VSS 1p
LRX VX VY 1n
M10 net2 net0 VSS VSS nch l=0.15 w=1 nf=1 m=1
M11 net1 VY VX VSS nch l=0.15 w=1 nf=1 m=1
M12 net3 VC VX VSS nch l=0.15 w=1 nf=1 m=1
M13 VX VB2 VSS VSS nch l=0.15 w=1 nf=1 m=1
M14 VB5 net4 VDD VDD pch l=0.15 w=1 nf=1 m=1
M15 VB5 VB5 net5 VSS nch l=0.15 w=1 nf=1 m=1
M16 net5 VB5 VSS VSS nch l=0.15 w=1 nf=1 m=1
M17 net4 net4 VDD VDD pch l=0.15 w=1 nf=1 m=1
M18 net4 VB4 VSS VSS nch l=0.15 w=1 nf=1 m=1
M19 VB4 net4 VDD VDD pch l=0.15 w=1 nf=1 m=1
M20 VB4 VB4 VSS VSS nch l=0.15 w=1 nf=1 m=1
M3 net1 VB1 VDD VDD pch l=0.15 w=1 nf=1 m=1
M4 net3 VB1 VDD VDD pch l=0.15 w=1 nf=1 m=1
M5 net0 VB3 net1 VDD pch l=0.15 w=1 nf=1 m=1
M6 VC VB3 net3 VDD pch l=0.15 w=1 nf=1 m=1
M7 net0 VB5 net6 VSS nch l=0.15 w=1 nf=1 m=1
M8 VC VB5 net2 VSS nch l=0.15 w=1 nf=1 m=1
M9 net6 net0 VSS VSS nch l=0.15 w=1 nf=1 m=1
MN1 VX VCONT2 VSS VSS nch l=0.15 w=1 nf=1 m=1
MN2 VY VCONT3 VSS VSS nch l=0.15 w=1 nf=1 m=1
MP2 VY VC VOUT VDD pch l=0.15 w=1 nf=1 m=1
MP3 VX VCONT1 VSTO VDD pch l=0.15 w=1 nf=1 m=1
.ends dut
