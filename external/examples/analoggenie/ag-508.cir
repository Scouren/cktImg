* official Analog Canvas netlist; PDK X cards rewritten by convert.py
.model nch nmos
.model pch pmos

.subckt dut VDD VSS VLO VLO_bar VRF Vb X Y
C1 N VSS 1p
L1 P N 1n
M1 P VRF VSS VSS nch l=0.15 w=1 nf=1 m=1
M2 X VLO P VSS nch l=0.15 w=1 nf=1 m=1
M3 Y VLO_bar P VSS nch l=0.15 w=1 nf=1 m=1
M4 N Vb VDD VDD pch l=0.15 w=1 nf=1 m=1
RD1 VDD X 1k
RD2 VDD Y 1k
.ends dut
