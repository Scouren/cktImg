* official Analog Canvas netlist; PDK X cards rewritten by convert.py
.model nch nmos
.model pch pmos

.subckt dut VDD VSS GND vin- vin+ VBIAS vout
CII vout GND 1p
M1 net3 vin- net1 VSS nch l=0.15 w=1 nf=1 m=1
M10 vout net4 VDD VDD pch l=0.15 w=1 nf=1 m=1
M11 vout net4 VSS VSS nch l=0.15 w=1 nf=1 m=1
M2 net2 vin+ net1 VSS nch l=0.15 w=1 nf=1 m=1
M3 net3 net3 VDD VDD pch l=0.15 w=1 nf=1 m=1
M4 net2 net3 VDD VDD pch l=0.15 w=1 nf=1 m=1
M5 net1 VBIAS VSS VSS nch l=0.15 w=1 nf=1 m=1
M6 net0 net2 VDD VDD pch l=0.15 w=1 nf=1 m=1
M7 net0 VBIAS VSS VSS nch l=0.15 w=1 nf=1 m=1
M8 net4 net0 VDD VDD pch l=0.15 w=1 nf=1 m=1
M9 net4 net0 VSS VSS nch l=0.15 w=1 nf=1 m=1
.ends dut
