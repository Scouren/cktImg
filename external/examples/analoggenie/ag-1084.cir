* official Analog Canvas netlist; PDK X cards rewritten by convert.py
.model nch nmos
.model pch pmos

.subckt dut VDD VSS Vb Vout
I1 X VSS DC 1m
M1 Y Vb X VSS nch l=0.15 w=1 nf=1 m=1
M2 Vout X VSS VSS nch l=0.15 w=1 nf=1 m=1
M4 Y Y VDD VDD pch l=0.15 w=1 nf=1 m=1
M5 Vout Y VDD VDD pch l=0.15 w=1 nf=1 m=1
RS net0 X 1k
VS net0 VSS DC 1 SIN(0 1 1k 0 0 0)
.ends dut
