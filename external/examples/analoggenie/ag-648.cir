* official Analog Canvas netlist; PDK X cards rewritten by convert.py
.model nch nmos
.model pch pmos

.subckt dut VDD VSS Vout
I1 VDD net8 DC 2uA
M1 net8 net8 VSS VSS nch l=0.15 w=1 nf=1 m=1
M10 net1 net3 net0 VSS nch l=0.15 w=1 nf=1 m=1
M11 net0 net8 VSS VSS nch l=0.15 w=1 nf=1 m=1
M12 net11 net11 VDD VDD pch l=0.15 w=1 nf=1 m=1
M13 net14 net11 VDD VDD pch l=0.15 w=1 nf=1 m=1
M14 net11 net12 net6 VSS nch l=0.15 w=1 nf=1 m=1
M15 net14 net1 net6 VSS nch l=0.15 w=1 nf=1 m=1
M16 net6 net8 VSS VSS nch l=0.15 w=1 nf=1 m=1
M17 net9 net9 VDD VDD pch l=0.15 w=1 nf=1 m=1
M18 net4 net9 VDD VDD pch l=0.15 w=1 nf=1 m=1
M19 net9 net11 net5 VSS nch l=0.15 w=1 nf=1 m=1
M2 net2 net2 VDD VDD pch l=0.15 w=1 nf=1 m=1
M20 net4 net14 net5 VSS nch l=0.15 w=1 nf=1 m=1
M21 net5 net8 VSS VSS nch l=0.15 w=1 nf=1 m=1
M22 net13 net13 VDD VDD pch l=0.15 w=1 nf=1 m=1
M23 Vout net13 VDD VDD pch l=0.15 w=1 nf=1 m=1
M24 net13 net9 net10 VSS nch l=0.15 w=1 nf=1 m=1
M25 Vout net4 net10 VSS nch l=0.15 w=1 nf=1 m=1
M26 net10 net8 VSS VSS nch l=0.15 w=1 nf=1 m=1
M3 net3 net2 VDD VDD pch l=0.15 w=1 nf=1 m=1
M4 net2 net13 net7 VSS nch l=0.15 w=1 nf=1 m=1
M5 net3 Vout net7 VSS nch l=0.15 w=1 nf=1 m=1
M6 net7 net8 VSS VSS nch l=0.15 w=1 nf=1 m=1
M7 net12 net12 VDD VDD pch l=0.15 w=1 nf=1 m=1
M8 net1 net12 VDD VDD pch l=0.15 w=1 nf=1 m=1
M9 net12 net2 net0 VSS nch l=0.15 w=1 nf=1 m=1
.ends dut
