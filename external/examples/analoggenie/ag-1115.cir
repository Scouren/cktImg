* official Analog Canvas netlist; PDK X cards rewritten by convert.py
.model nch nmos
.model pch pmos

.subckt dut VDD VSS Vout_bar Vout Vtune
C1 net0 net3 1p
C2 net2 net1 1p
CV1 Vtune net0 1p
CV2 Vtune net2 1p
L net1 net3 1n
M1a net3 net1 VSS VSS nch l=0.15 w=1 nf=1 m=1
M1b net1 net3 VSS VSS nch l=0.15 w=1 nf=1 m=1
M2a net3 net1 VDD VDD pch l=0.15 w=1 nf=1 m=1
M2b net1 net3 VDD VDD pch l=0.15 w=1 nf=1 m=1
M3a Vout_bar net3 VSS VSS nch l=0.15 w=1 nf=1 m=1
M3b Vout net1 VSS VSS nch l=0.15 w=1 nf=1 m=1
M4a Vout_bar net3 VDD VDD pch l=0.15 w=1 nf=1 m=1
M4b Vout net1 VDD VDD pch l=0.15 w=1 nf=1 m=1
R1 net0 VSS 1k
R2 net2 VSS 1k
.ends dut
