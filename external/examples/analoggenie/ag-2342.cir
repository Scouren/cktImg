* official Analog Canvas netlist; PDK X cards rewritten by convert.py
.model nch nmos
.model pch pmos

.subckt bias VDD VSS VBN
M22 net2 net1 VDD VDD pch l=0.15 w=1 nf=1 m=1
M23 net2 net2 VSS VSS nch l=0.15 w=1 nf=1 m=1
M24 net1 net1 VDD VDD pch l=0.15 w=1 nf=1 m=1
M25 net1 net3 net0 VSS nch l=0.15 w=1 nf=1 m=1
M26 net0 net2 VSS VSS nch l=0.15 w=1 nf=1 m=1
M27 net3 net1 VDD VDD pch l=0.15 w=1 nf=1 m=1
M28 net3 net3 VSS VSS nch l=0.15 w=1 nf=1 m=1
M29 net4 net4 VDD VDD pch l=0.15 w=1 nf=1 m=1
M30 net4 net3 VSS VSS nch l=0.15 w=1 nf=1 m=1
M31 VBN net4 VDD VDD pch l=0.15 w=1 nf=1 m=1
M32 VBN VBN VSS VSS nch l=0.15 w=1 nf=1 m=1
.ends bias

.subckt dut VDD VSS VREF VB4 IBUF VIN VOUT
CL VOUT net1 1p
M1 net5 net5 VDD VDD pch l=0.15 w=1 nf=1 m=1
M13 net3 VB4 VDD VDD pch l=0.15 w=1 nf=1 m=1
M14 VX EAO net3 VDD pch l=0.15 w=1 nf=1 m=1
M15 VX VX VSS VSS nch l=0.15 w=1 nf=1 m=1
M16 GATE VX VSS VSS nch l=0.15 w=1 nf=1 m=1
M17 VDD net3 GATE VSS nch l=0.15 w=1 nf=1 m=1
M18 net4 EAO IBUF IBUF nch l=0.15 w=1 nf=1 m=1
M19 net4 net4 VDD VDD pch l=0.15 w=1 nf=1 m=1
M2 net0 net0 VDD VDD pch l=0.15 w=1 nf=1 m=1
M20 GATE net4 VDD VDD pch l=0.15 w=1 nf=1 m=1
M21 VSS IBUF GATE VSS pch l=0.15 w=1 nf=1 m=1
M3 net5 VREF VX VSS nch l=0.15 w=1 nf=1 m=1
M4 net0 FB VX VSS nch l=0.15 w=1 nf=1 m=1
M5 VX VBN VSS VSS nch l=0.15 w=1 nf=1 m=1
M6 EAO net5 VDD VDD pch l=0.15 w=1 nf=1 m=1
M7 net2 net0 VDD VDD pch l=0.15 w=1 nf=1 m=1
M8 net2 net2 VSS VSS nch l=0.15 w=1 nf=1 m=1
M9 EAO net2 VSS VSS nch l=0.15 w=1 nf=1 m=1
MNP VIN GATE VOUT VOUT nch l=0.15 w=1 nf=1 m=1
R1 FB VSS 1k
R2 VOUT FB 1k
R3 net1 VSS 1k
RL VOUT VSS 1k
X1 VDD VSS VBN bias
.ends dut
