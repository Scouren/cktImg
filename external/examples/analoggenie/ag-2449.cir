* official Analog Canvas netlist; PDK X cards rewritten by convert.py
.model nch nmos
.model pch pmos

.subckt dut VDD VSS VB1 VREF VIN VOUT VERR
M1 net1 VEA VIN VDD pch l=0.15 w=1 nf=1 m=1
M10 VERR nb VSS VSS nch l=0.15 w=1 nf=1 m=1
M11 net5 net5 VDD VDD pch l=0.15 w=1 nf=1 m=1
M12 VEA net5 VDD VDD pch l=0.15 w=1 nf=1 m=1
M13 VEA net6 VDD VDD pch l=0.15 w=1 nf=1 m=1
M14 net6 net6 VDD VDD pch l=0.15 w=1 nf=1 m=1
M15 VEA VEA VSS VSS nch l=0.15 w=1 nf=1 m=1
M16 VEA VEA VSS VSS nch l=0.15 w=1 nf=1 m=1
M17 net5 VREF net8 VSS nch l=0.15 w=1 nf=1 m=1
M18 net6 VEA net8 VSS nch l=0.15 w=1 nf=1 m=1
M19 net8 VX VSS VSS nch l=0.15 w=1 nf=1 m=1
M2 net4 net4 net1 VDD pch l=0.15 w=1 nf=1 m=1
M20 net3 net3 net7 VDD pch l=0.15 w=1 nf=1 m=1
M21 VX net3 VDD VDD pch l=0.15 w=1 nf=1 m=1
M22 VX VX VSS VSS nch l=0.15 w=1 nf=1 m=1
M23 VB1 VX VSS VSS nch l=0.15 w=1 nf=1 m=1
M24 VB1 VB1 VDD VDD pch l=0.15 w=1 nf=1 m=1
M3 net4 nb VSS VSS nch l=0.15 w=1 nf=1 m=1
M4 net2 pb VIN VDD pch l=0.15 w=1 nf=1 m=1
M5 net0 VEA net2 VDD pch l=0.15 w=1 nf=1 m=1
M6 net0 net0 VSS VSS nch l=0.15 w=1 nf=1 m=1
M7 VERR net0 VSS VSS nch l=0.15 w=1 nf=1 m=1
M8 VOUT VERR VIN VDD pch l=0.15 w=1 nf=1 m=1
M9 VERR net4 VOUT VDD pch l=0.15 w=1 nf=1 m=1
R1 VDD net7 1k
R2 net3 VSS 1k
.ends dut
