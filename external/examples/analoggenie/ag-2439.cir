* official Analog Canvas netlist; PDK X cards rewritten by convert.py
.model nch nmos
.model pch pmos

.subckt dut VDD VSS VIN VOUT VREF VB1
M1 net5 VEAOUT VIN VDD pch l=0.15 w=1 nf=1 m=1
M10 net1 VB4 VSS VSS nch l=0.15 w=1 nf=1 m=1
M11 VEAOUT VEAOUT VSS VSS nch l=0.15 w=1 nf=1 m=1
M12 VEAOUT VEAOUT VSS VSS nch l=0.15 w=1 nf=1 m=1
M13 net4 net4 VSS VSS nch l=0.15 w=1 nf=1 m=1
M14 net8 net4 VSS VSS nch l=0.15 w=1 nf=1 m=1
M15 net8 net8 VDD VDD pch l=0.15 w=1 nf=1 m=1
M16 VB4 net8 VDD VDD pch l=0.15 w=1 nf=1 m=1
M17 VB4 VB4 VSS VSS nch l=0.15 w=1 nf=1 m=1
M18 VB1 VB4 VSS VSS nch l=0.15 w=1 nf=1 m=1
M19 VB1 VB1 VDD VDD pch l=0.15 w=1 nf=1 m=1
M2 net6 net6 net5 VDD pch l=0.15 w=1 nf=1 m=1
M3 net6 nb VSS VSS nch l=0.15 w=1 nf=1 m=1
M4 net3 net3 VDD VDD pch l=0.15 w=1 nf=1 m=1
M5 VEAOUT net3 VDD VDD pch l=0.15 w=1 nf=1 m=1
M6 net0 net0 VDD VDD pch l=0.15 w=1 nf=1 m=1
M7 VEAOUT net0 VDD VDD pch l=0.15 w=1 nf=1 m=1
M8 net3 VREF net1 VSS nch l=0.15 w=1 nf=1 m=1
M9 net0 VEAOUT net1 VSS nch l=0.15 w=1 nf=1 m=1
MBIAS VERR nb VSS VSS nch l=0.15 w=1 nf=1 m=1
MCHG net7 pb VIN VDD pch l=0.15 w=1 nf=1 m=1
MCTRL VERR net6 VOUT VDD pch l=0.15 w=1 nf=1 m=1
MGEN net2 net2 VSS VSS nch l=0.15 w=1 nf=1 m=1
MINJ VERR net2 VSS VSS nch l=0.15 w=1 nf=1 m=1
MRES VOUT VERR VIN VDD pch l=0.15 w=1 nf=1 m=1
MSEN net2 VEAOUT net7 VDD pch l=0.15 w=1 nf=1 m=1
R1 VDD net4 1k
.ends dut
