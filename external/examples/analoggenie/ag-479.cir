* official Analog Canvas netlist; PDK X cards rewritten by convert.py
.model nch nmos

.subckt opamp_differential VDD VSS VIP VIN VOP VON params: gain=1e6 vocm=0
VCM ncm 0 DC {vocm}
EPLUS VOP ncm VIP VIN {gain/2}
EMINUS VON ncm VIN VIP {gain/2}
.ends opamp_differential

.subckt dut VDD VSS Voutn Voutp
C1 A net0 1p
I1 A VSS DC 1m
M1 B A VSS VSS nch l=0.15 w=1 nf=1 m=1
M2 X B VSS VSS nch l=0.15 w=1 nf=1 m=1
M3 Y X VSS VSS nch l=0.15 w=1 nf=1 m=1
R1 VDD B 75Ω
R2 VDD X 200Ω
R3 VDD Y 150Ω
RF A Y 1000Ω
RS net1 net0 1k
Vin net1 VSS DC 1
X1 VDD VSS Y X Voutp Voutn opamp_differential gain=1e6
.ends dut
