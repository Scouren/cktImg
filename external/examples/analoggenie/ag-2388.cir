* official Analog Canvas netlist; PDK X cards rewritten by convert.py
.model nch nmos
.model pch pmos

.subckt AEA VDD VSS VREF OUT VC
M1 net0 VB1 VDD VDD pch l=0.15 w=1 nf=1 m=1
M10 net2 VC VSS VSS nch l=0.15 w=1 nf=1 m=1
M11 net4 OUT net1 VSS nch l=0.15 w=1 nf=1 m=1
M12 VBP VBP VDD VDD pch l=0.15 w=1 nf=1 m=1
M13 VB4 VBP VDD VDD pch l=0.15 w=1 nf=1 m=1
M14 VBP VB4 VSS VSS nch l=0.15 w=1 nf=1 m=1
M15 VB4 VB4 VSS VSS nch l=0.15 w=1 nf=1 m=1
M16 VBN VBP VDD VDD pch l=0.15 w=1 nf=1 m=1
M17 VBN VBN OUT VSS nch l=0.15 w=1 nf=1 m=1
M18 OUT VBN VSS VSS nch l=0.15 w=1 nf=1 m=1
M2 net4 VB1 VDD VDD pch l=0.15 w=1 nf=1 m=1
M3 net0 VREF net1 VSS nch l=0.15 w=1 nf=1 m=1
M4 net1 VB2 VSS VSS nch l=0.15 w=1 nf=1 m=1
M5 OUT VB3 net0 VDD pch l=0.15 w=1 nf=1 m=1
M6 VC VB3 net4 VDD pch l=0.15 w=1 nf=1 m=1
M7 OUT VBN net3 VSS nch l=0.15 w=1 nf=1 m=1
M8 VC VBN net2 VSS nch l=0.15 w=1 nf=1 m=1
M9 net3 VC VSS VSS nch l=0.15 w=1 nf=1 m=1
.ends AEA

.subckt dut VDD VSS VIN pb VOUT VERR VREF
M1 net3 net0 VIN VDD pch l=0.15 w=1 nf=1 m=1
M2 VC VC net3 VDD pch l=0.15 w=1 nf=1 m=1
M3 VC nb VSS VSS nch l=0.15 w=1 nf=1 m=1
MBIAS VERR nb VSS VSS nch l=0.15 w=1 nf=1 m=1
MCHG net1 pb VIN VDD pch l=0.15 w=1 nf=1 m=1
MCTRL VERR VC VOUT VDD pch l=0.15 w=1 nf=1 m=1
MGEN net2 net2 VSS VSS nch l=0.15 w=1 nf=1 m=1
MINJ VERR net2 VSS VSS nch l=0.15 w=1 nf=1 m=1
MRES VOUT VERR VIN VDD pch l=0.15 w=1 nf=1 m=1
MSEN net2 net0 net1 VDD pch l=0.15 w=1 nf=1 m=1
X1 VDD VSS VREF net0 VC AEA
.ends dut
