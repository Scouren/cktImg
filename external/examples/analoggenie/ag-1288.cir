* official Analog Canvas netlist; PDK X cards rewritten by convert.py
.model nch nmos
.model pch pmos

.subckt EA VDD VSS INP INN OUT VX3
M12 OUT VX3 VDD VDD pch l=0.15 w=1 nf=1 m=1
M13 VX3 VX3 VDD VDD pch l=0.15 w=1 nf=1 m=1
M14 net3 net3 VDD VDD pch l=0.15 w=1 nf=1 m=1
M15 VM net3 VDD VDD pch l=0.15 w=1 nf=1 m=1
M16 VX3 INP net1 VSS nch l=0.15 w=1 nf=1 m=1
M17 net3 INN net1 VSS nch l=0.15 w=1 nf=1 m=1
M18 net1 VB3 VSS VSS nch l=0.15 w=1 nf=1 m=1
M19 OUT VM VSS VSS nch l=0.15 w=1 nf=1 m=1
M20 VM VM VSS VSS nch l=0.15 w=1 nf=1 m=1
M21 VB3 VB1 VDD VDD pch l=0.15 w=1 nf=1 m=1
M22 VB3 VB3 VSS VSS nch l=0.15 w=1 nf=1 m=1
M23 VB1 VB1 VDD VDD pch l=0.15 w=1 nf=1 m=1
M24 VB1 net2 VSS VSS nch l=0.15 w=1 nf=1 m=1
M25 net2 net2 VSS VSS nch l=0.15 w=1 nf=1 m=1
M26 net2 net0 VDD VDD pch l=0.15 w=1 nf=1 m=1
M27 net0 net0 net2 VDD pch l=0.15 w=1 nf=1 m=1
RB1 VDD net2 1k
RB2 net0 VSS 1k
.ends EA

.subckt ISR VDD VSS P OUT CTRL VB2
M10 net1 net0 VSS VSS nch l=0.15 w=1 nf=1 m=1
M11 net0 VB2 VSS VSS nch l=0.15 w=1 nf=1 m=1
M6 OUT net1 P VDD pch l=0.15 w=1 nf=1 m=1
M7 net1 net1 P VDD pch l=0.15 w=1 nf=1 m=1
M8 net0 CTRL P VDD pch l=0.15 w=1 nf=1 m=1
M9 net0 net0 VSS VSS nch l=0.15 w=1 nf=1 m=1
.ends ISR

.subckt dut VDD VSS VP VREF VB2 VIN VCONT1 VCONT3 VCONT5 VCONT4 VCONT2
.model DIODE D(IS=1e-14 N=1)
CFLY net0 VX2 1p
CO VP VN 1p
COP VP VSS 1p
D1 VN VX2 DIODE
L1 net0 VX3 1n
M1 net0 VCONT2 VIN VDD pch l=0.15 w=1 nf=1 m=1
M2 VX2 VCONT3 VIN VDD pch l=0.15 w=1 nf=1 m=1
M3 VP VCONT5 VX3 VDD pch l=0.15 w=1 nf=1 m=1
M4 VX3 VCONT4 VSS VSS nch l=0.15 w=1 nf=1 m=1
M5 net1 VCONT1 VIN VDD pch l=0.15 w=1 nf=1 m=1
R1 VP VFP1 1k
R2 VFP1 VSS 1k
X1 VDD VSS net1 net0 net2 VB2 ISR
X2 VDD VSS VREF VFP1 net2 VX3 EA
.ends dut
