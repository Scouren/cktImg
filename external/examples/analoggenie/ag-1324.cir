* official Analog Canvas netlist; PDK X cards rewritten by convert.py
.model nch nmos
.model pch pmos

.subckt dut VDD VSS VREF VB2 VCONT1 VCONT2 VCONT3 VIN VCONT4 VCONT5 VP
.model DIODE D(IS=1e-14 N=1)
CFLY VX1 VX2 1p
CO VP VN 1p
COP VP VSS 1p
D1 VN VX2 DIODE
L1 VX1 VX3 1n
M1 VX1 VCONT2 VIN VDD pch l=0.15 w=1 nf=1 m=1
M2 VX2 VCONT3 VIN VDD pch l=0.15 w=1 nf=1 m=1
M3 VP VCONT5 VX3 VDD pch l=0.15 w=1 nf=1 m=1
M4 VX3 VCONT4 VSS VSS nch l=0.15 w=1 nf=1 m=1
M5 VS VCONT1 VIN VDD pch l=0.15 w=1 nf=1 m=1
MN1 VX VX VSS VSS nch l=0.15 w=1 nf=1 m=1
MN10 VB1 VB4 VX2 VSS nch l=0.15 w=1 nf=1 m=1
MN11 VS VS VSS VSS nch l=0.15 w=1 nf=1 m=1
MN12 VX2 VS VSS VSS nch l=0.15 w=1 nf=1 m=1
MN2 VX2 VX2 VSS VSS nch l=0.15 w=1 nf=1 m=1
MN3 VCTRL VX VSS VSS nch l=0.15 w=1 nf=1 m=1
MN4 net0 VX2 VSS VSS nch l=0.15 w=1 nf=1 m=1
MN5 net1 VB2 VSS VSS nch l=0.15 w=1 nf=1 m=1
MN6 net1 net1 VSS VSS nch l=0.15 w=1 nf=1 m=1
MN7 net2 net1 VSS VSS nch l=0.15 w=1 nf=1 m=1
MN8 VB3 VB4 VSS VSS nch l=0.15 w=1 nf=1 m=1
MN9 VB4 VB4 VSS VSS nch l=0.15 w=1 nf=1 m=1
MP1 net0 net0 VDD VDD pch l=0.15 w=1 nf=1 m=1
MP10 VB4 VB1 VDD VDD pch l=0.15 w=1 nf=1 m=1
MP11 VB1 VB1 VDD VDD pch l=0.15 w=1 nf=1 m=1
MP12 VS VB1 VDD VDD pch l=0.15 w=1 nf=1 m=1
MP2 VCTRL net0 VDD VDD pch l=0.15 w=1 nf=1 m=1
MP3 net3 VB3 VDD VDD pch l=0.15 w=1 nf=1 m=1
MP4 net2 net2 VS VDD pch l=0.15 w=1 nf=1 m=1
MP5 VX1 net2 VS VDD pch l=0.15 w=1 nf=1 m=1
MP6 net1 VCTRL VS VDD pch l=0.15 w=1 nf=1 m=1
MP7 VX VFP1 net3 VDD pch l=0.15 w=1 nf=1 m=1
MP8 VX2 VREF net3 VDD pch l=0.15 w=1 nf=1 m=1
MP9 VB3 VB3 VDD VDD pch l=0.15 w=1 nf=1 m=1
R1 VP VFP1 1k
R2 VFP1 VSS 1k
.ends dut
