* official Analog Canvas netlist; PDK X cards rewritten by convert.py
.model nch nmos
.model pch pmos

* Ideal inverter: switches at V(VDD,VSS)/2; vt sets the step width, td the delay
.subckt inverter VDD VSS A Y params: vt=10m td=10p
BhA hA 0 V={0.5*(1+tanh((V(A,VSS)-0.5*V(VDD,VSS))/vt))}
Bf nfn VSS V={V(VDD,VSS)*(1-V(hA))}
Rd nfn ndl 1k
Cd ndl VSS {td/1000}
BY Y VSS V={V(ndl,VSS)}
.ends inverter

.subckt dut VDD VSS QA QB Vb2 Vb1 Vcont
C1 net0 VSS 1p
M1 Vcont net1 net2 VDD pch l=0.15 w=1 nf=1 m=1
M2 Vcont QB net3 VSS nch l=0.15 w=1 nf=1 m=1
M3 net2 Vb2 VDD VDD pch l=0.15 w=1 nf=1 m=1
M4 net3 Vb1 VSS VSS nch l=0.15 w=1 nf=1 m=1
R1 Vcont net0 1k
X1 VDD VSS QA net1 inverter td=10p vt=10m
.ends dut
