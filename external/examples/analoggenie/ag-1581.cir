* official Analog Canvas netlist; PDK X cards rewritten by convert.py
.model nch nmos
.model pch pmos
.model qpnp pnp

.subckt opamp VDD VSS INN INP VB2 VB1 VB3 OUT
M1 net2 VB1 VDD VDD pch l=0.15 w=1 nf=1 m=1
M10 net0 INP net7 VSS nch l=0.15 w=1 nf=1 m=1
M11 net7 VB2 VSS VSS nch l=0.15 w=1 nf=1 m=1
M12 net5 net5 net8 VDD pch l=0.15 w=1 nf=1 m=1
M13 VC net5 VDD VDD pch l=0.15 w=1 nf=1 m=1
M14 VC VC net4 VSS nch l=0.15 w=1 nf=1 m=1
M15 net4 VC VSS VSS nch l=0.15 w=1 nf=1 m=1
M2 net0 VB1 VDD VDD pch l=0.15 w=1 nf=1 m=1
M3 net3 VB3 net2 VDD pch l=0.15 w=1 nf=1 m=1
M4 OUT VB3 net0 VDD pch l=0.15 w=1 nf=1 m=1
M5 net3 VC net6 VSS nch l=0.15 w=1 nf=1 m=1
M6 OUT VC net1 VSS nch l=0.15 w=1 nf=1 m=1
M7 net6 net3 VSS VSS nch l=0.15 w=1 nf=1 m=1
M8 net1 net3 VSS VSS nch l=0.15 w=1 nf=1 m=1
M9 net2 INN net7 VSS nch l=0.15 w=1 nf=1 m=1
R4 VDD net8 1k
R5 net5 VSS 1k
.ends opamp

.subckt dut VDD VSS Vout VB2 VB1 VB3
Q1 VSS VSS X qpnp m=1
Q2 VSS VSS net0 qpnp m=1
R1 Vout X 1k
R2 Vout Y 1k
R3 Y net0 1k
X1 VDD VSS Y X VB2 VB1 VB3 Vout opamp
.ends dut
