* official Analog Canvas netlist; PDK X cards rewritten by convert.py
.model nch nmos
.model pch pmos
.model qnpn npn

.subckt opamp VDD VSS VB4 VB2 VB1 INP INN OUT
M1 net7 VB2 VDD VDD pch l=0.15 w=1 nf=1 m=1
M10 net8 VB4 net6 VSS nch l=0.15 w=1 nf=1 m=1
M11 OUT VB4 net3 VSS nch l=0.15 w=1 nf=1 m=1
M12 net0 net5 VSS VSS nch l=0.15 w=1 nf=1 m=1
M13 net2 net5 VSS VSS nch l=0.15 w=1 nf=1 m=1
M14 net6 net8 VSS VSS nch l=0.15 w=1 nf=1 m=1
M15 net3 net8 VSS VSS nch l=0.15 w=1 nf=1 m=1
M2 net5 INP net7 net9 pch l=0.15 w=1 nf=1 m=1
M3 net8 INN net7 net9 pch l=0.15 w=1 nf=1 m=1
M4 net4 VP VDD VDD pch l=0.15 w=1 nf=1 m=1
M5 net1 VP VDD VDD pch l=0.15 w=1 nf=1 m=1
M6 VP VB1 net4 VDD pch l=0.15 w=1 nf=1 m=1
M7 OUT VB1 net1 VDD pch l=0.15 w=1 nf=1 m=1
M8 VP VB4 net0 VSS nch l=0.15 w=1 nf=1 m=1
M9 net5 VB4 net2 VSS nch l=0.15 w=1 nf=1 m=1
.ends opamp

.subckt dut VDD VSS Vout VB3 VB1 VB2
M16 VB4 net1 VDD VDD pch l=0.15 w=1 nf=1 m=1
M17 VB4 VB4 VZ VSS nch l=0.15 w=1 nf=1 m=1
M18 VZ VB4 VSS VSS nch l=0.15 w=1 nf=1 m=1
M19 net1 net1 VDD VDD pch l=0.15 w=1 nf=1 m=1
M20 net1 net0 VB3 VSS nch l=0.15 w=1 nf=1 m=1
M21 net0 net1 VDD VDD pch l=0.15 w=1 nf=1 m=1
M22 net0 VB3 VSS VSS nch l=0.15 w=1 nf=1 m=1
Q1 X X VSS VSS qnpn m=1
Q2 VZ VZ VSS VSS qnpn m=1
R1 Vout X 1k
R2 Vout Y 1k
R3 Y VZ 1k
R4 VB3 VSS 1k
X1 VDD VSS VB4 VB2 VB1 X Y Vout opamp
.ends dut
