* official Analog Canvas netlist; PDK X cards rewritten by convert.py
.model nch nmos
.model pch pmos

.subckt dut VDD VSS VB2 VREF VB1 VB3 VB4 IBUF VIN VOUT
CL VOUT net5 1p
M10 net1 VB1 net13 VDD pch l=0.15 w=1 nf=1 m=1
M11 net7 net1 VDD VDD pch l=0.15 w=1 nf=1 m=1
M12 net13 net1 VDD VDD pch l=0.15 w=1 nf=1 m=1
M13 net0 VB4 VDD VDD pch l=0.15 w=1 nf=1 m=1
M14 VX EAO net0 VDD pch l=0.15 w=1 nf=1 m=1
M15 VX VX VSS VSS nch l=0.15 w=1 nf=1 m=1
M16 GATE VX VSS VSS nch l=0.15 w=1 nf=1 m=1
M17 VDD net0 GATE VSS nch l=0.15 w=1 nf=1 m=1
M18 net6 EAO IBUF VSS nch l=0.15 w=1 nf=1 m=1
M19 net6 net6 VDD VDD pch l=0.15 w=1 nf=1 m=1
M2 EAO VB2 VDD VDD pch l=0.15 w=1 nf=1 m=1
M20 GATE net6 VDD VDD pch l=0.15 w=1 nf=1 m=1
M21 VSS IBUF GATE VDD pch l=0.15 w=1 nf=1 m=1
M22 net9 VB5 net12 VSS nch l=0.15 w=1 nf=1 m=1
M23 VX VB5 net3 VSS nch l=0.15 w=1 nf=1 m=1
M24 net12 net9 VSS VSS nch l=0.15 w=1 nf=1 m=1
M25 net3 VX VSS VSS nch l=0.15 w=1 nf=1 m=1
M26 net2 net2 VDD VDD pch l=0.15 w=1 nf=1 m=1
M27 net4 net2 VDD VDD pch l=0.15 w=1 nf=1 m=1
M28 net2 net4 VB3 VSS nch l=0.15 w=1 nf=1 m=1
M29 net4 VB3 VSS VSS nch l=0.15 w=1 nf=1 m=1
M3 VX VREF EAO VDD pch l=0.15 w=1 nf=1 m=1
M30 VB5 net2 VDD VDD pch l=0.15 w=1 nf=1 m=1
M31 VB5 VB5 net8 VSS nch l=0.15 w=1 nf=1 m=1
M32 net8 VB5 VSS VSS nch l=0.15 w=1 nf=1 m=1
M4 net9 FB EAO VDD pch l=0.15 w=1 nf=1 m=1
M5 net10 net9 VSS VSS nch l=0.15 w=1 nf=1 m=1
M6 net11 VX VSS VSS nch l=0.15 w=1 nf=1 m=1
M7 EAO VB5 net10 VSS nch l=0.15 w=1 nf=1 m=1
M8 net1 VB5 net11 VSS nch l=0.15 w=1 nf=1 m=1
M9 EAO VB1 net7 VDD pch l=0.15 w=1 nf=1 m=1
MNP VIN GATE VOUT VSS nch l=0.15 w=1 nf=1 m=1
R1 FB VSS 1k
R2 VOUT FB 1k
R3 VB3 VSS 1k
R4 net5 VSS 1k
RL VOUT VSS 1k
.ends dut
