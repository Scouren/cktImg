* official Analog Canvas netlist; PDK X cards rewritten by convert.py
.model nch nmos
.model pch pmos

.subckt dut VDD VSS biasp biascas biasn Vout Vref
C1 Vset VSS 1p
C2 n3 Vout 1p
M1 Vout n3 VDD VDD pch l=0.15 w=1 nf=1 m=1
M10 n3 VC net3 VSS nch l=0.15 w=1 nf=1 m=1
M11 Vset VC n1 VSS nch l=0.15 w=1 nf=1 m=1
M12 net3 n3 VSS VSS nch l=0.15 w=1 nf=1 m=1
M13 n1 n3 VSS VSS nch l=0.15 w=1 nf=1 m=1
M14 net7 fb net2 VSS nch l=0.15 w=1 nf=1 m=1
M15 net4 Vref net2 VSS nch l=0.15 w=1 nf=1 m=1
M16 net2 VB2 VSS VSS nch l=0.15 w=1 nf=1 m=1
M17 VC net0 VDD VDD pch l=0.15 w=1 nf=1 m=1
M18 net0 net0 VDD VDD pch l=0.15 w=1 nf=1 m=1
M19 net0 net6 VSS VSS nch l=0.15 w=1 nf=1 m=1
M2 n1 Vset Vout VDD pch l=0.15 w=1 nf=1 m=1
M20 net6 net0 VDD VDD pch l=0.15 w=1 nf=1 m=1
M21 net1 net6 VSS VSS nch l=0.15 w=1 nf=1 m=1
M22 VC VC net5 VSS nch l=0.15 w=1 nf=1 m=1
M23 net5 VC VSS VSS nch l=0.15 w=1 nf=1 m=1
M3 n1 biasn VSS VSS nch l=0.15 w=1 nf=1 m=1
M4 n3 biasp VDD VDD pch l=0.15 w=1 nf=1 m=1
M5 n3 biascas n1 VSS nch l=0.15 w=1 nf=1 m=1
M6 net7 VB1 VDD VDD pch l=0.15 w=1 nf=1 m=1
M7 net4 VB1 VDD VDD pch l=0.15 w=1 nf=1 m=1
M8 n3 VB3 net7 VDD pch l=0.15 w=1 nf=1 m=1
M9 Vset VB3 net4 VDD pch l=0.15 w=1 nf=1 m=1
R1 fb VSS 1k
R2 Vout fb 1k
R3 net6 net1 1k
.ends dut
