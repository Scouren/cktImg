* official Analog Canvas netlist; PDK X cards rewritten by convert.py
.model nch nmos
.model pch pmos

.subckt dut VDD VSS VIN VCONT1 VCONT2 VCONT3 VCONT4 VCONT5 VP VB4 VB1 VREF VB2 VB3
.model DIODE D(IS=1e-14 N=1)
CFLY VX1 VX2 1p
CO VP VN 1p
COP VP VSS 1p
D1 VN VX2 DIODE
L1 VX1 VX3 1n
M1 VX1 VCONT2 VIN VDD pch l=0.15 w=1 nf=1 m=1
M2 VX2 VCONT3 VIN VDD pch l=0.15 w=1 nf=1 m=1
M3 VX3 VCONT5 VP VDD pch l=0.15 w=1 nf=1 m=1
M4 VX3 VCONT4 VSS VSS nch l=0.15 w=1 nf=1 m=1
M5 net9 VCONT1 VIN VDD pch l=0.15 w=1 nf=1 m=1
MN1 net5 VFP1 net10 VSS nch l=0.15 w=1 nf=1 m=1
MN10 net1 VB4 VSS VSS nch l=0.15 w=1 nf=1 m=1
MN11 VB3 VB3 VSS VSS nch l=0.15 w=1 nf=1 m=1
MN12 net0 VB3 VSS VSS nch l=0.15 w=1 nf=1 m=1
MN13 VBN VBN net3 VSS nch l=0.15 w=1 nf=1 m=1
MN14 net3 VBN VSS VSS nch l=0.15 w=1 nf=1 m=1
MN2 net4 VREF net10 VSS nch l=0.15 w=1 nf=1 m=1
MN3 net10 VB2 VSS VSS nch l=0.15 w=1 nf=1 m=1
MN4 VG VBN VX1 VSS nch l=0.15 w=1 nf=1 m=1
MN5 VX1 VG VSS VSS nch l=0.15 w=1 nf=1 m=1
MN6 VCTRL VBN net8 VSS nch l=0.15 w=1 nf=1 m=1
MN7 net8 VG VSS VSS nch l=0.15 w=1 nf=1 m=1
MN8 net1 net1 VSS VSS nch l=0.15 w=1 nf=1 m=1
MN9 net6 net1 VSS VSS nch l=0.15 w=1 nf=1 m=1
MP1 VFP1 net5 VDD VDD pch l=0.15 w=1 nf=1 m=1
MP10 net6 net6 net9 VDD pch l=0.15 w=1 nf=1 m=1
MP11 VX1 net6 net9 VDD pch l=0.15 w=1 nf=1 m=1
MP12 VB3 net0 VDD VDD pch l=0.15 w=1 nf=1 m=1
MP13 net0 net0 VDD VDD pch l=0.15 w=1 nf=1 m=1
MP14 VBN net0 VDD VDD pch l=0.15 w=1 nf=1 m=1
MP2 net2 net5 VDD VDD pch l=0.15 w=1 nf=1 m=1
MP3 VN net4 VDD VDD pch l=0.15 w=1 nf=1 m=1
MP4 net7 net4 VDD VDD pch l=0.15 w=1 nf=1 m=1
MP5 VG VB1 VFP1 VDD pch l=0.15 w=1 nf=1 m=1
MP6 net5 VB1 net2 VDD pch l=0.15 w=1 nf=1 m=1
MP7 net4 VB1 VN VDD pch l=0.15 w=1 nf=1 m=1
MP8 VCTRL VB1 net7 VDD pch l=0.15 w=1 nf=1 m=1
MP9 net1 VCTRL net9 VDD pch l=0.15 w=1 nf=1 m=1
R1 VP VFP1 1k
R2 VFP1 VSS 1k
.ends dut
