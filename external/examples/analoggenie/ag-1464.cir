* official Analog Canvas netlist; PDK X cards rewritten by convert.py
.model nch nmos
.model pch pmos
.model qnpn npn

.subckt A1 VDD VSS VB1 VB3 VB2 INN INP OUT
M1 net1 net4 VDD VDD pch l=0.15 w=1 nf=1 m=1
M10 VX VB1 net5 VDD pch l=0.15 w=1 nf=1 m=1
M11 net4 VB1 net3 VDD pch l=0.15 w=1 nf=1 m=1
M12 net0 VB1 net2 VDD pch l=0.15 w=1 nf=1 m=1
M13 OUT VB3 net7 VSS nch l=0.15 w=1 nf=1 m=1
M14 VX VB3 net8 VSS nch l=0.15 w=1 nf=1 m=1
M15 net6 VB2 VSS VSS nch l=0.15 w=1 nf=1 m=1
M2 net2 net0 VDD VDD pch l=0.15 w=1 nf=1 m=1
M3 net0 INN net6 VSS nch l=0.15 w=1 nf=1 m=1
M4 net4 INP net6 VSS nch l=0.15 w=1 nf=1 m=1
M5 net3 net4 VDD VDD pch l=0.15 w=1 nf=1 m=1
M6 net5 net0 VDD VDD pch l=0.15 w=1 nf=1 m=1
M7 net7 VX VSS VSS nch l=0.15 w=1 nf=1 m=1
M8 net8 VX VSS VSS nch l=0.15 w=1 nf=1 m=1
M9 OUT VB1 net1 VDD pch l=0.15 w=1 nf=1 m=1
.ends A1

.subckt dut VDD VSS Vout VB1 VB2
M16 VB3 net0 VDD VDD pch l=0.15 w=1 nf=1 m=1
M17 net0 net0 net2 VDD pch l=0.15 w=1 nf=1 m=1
M18 VB3 VB3 net1 VSS nch l=0.15 w=1 nf=1 m=1
M19 net1 VB3 VSS VSS nch l=0.15 w=1 nf=1 m=1
Q1 X X VSS VSS qnpn m=1
Q2 net1 net1 VSS VSS qnpn m=1
R1 Vout X 1k
R2 Vout Y 1k
R3 Y net1 1k
R4 VDD net2 1k
R5 net0 VSS 1k
X1 VDD VSS VB1 VB3 VB2 Y X Vout A1
.ends dut
