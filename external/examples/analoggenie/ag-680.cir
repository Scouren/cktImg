* official Analog Canvas netlist; PDK X cards rewritten by convert.py
.model nch nmos

.subckt dut VSS Vref Vout
M1 Vout Vref net0 VSS nch l=0.15 w=1 nf=1 m=1
M2 net0 net0 VSS VSS nch l=0.15 w=1 nf=1 m=1
.ends dut
