* official Analog Canvas netlist; PDK X cards rewritten by convert.py
.model nch nmos
.model pch pmos
.model qnpn npn

.subckt dut VDD VSS Vout VB1
M1 net5 X net6 VSS nch l=0.15 w=1 nf=1 m=1
M10 net1 net3 VSS VSS nch l=0.15 w=1 nf=1 m=1
M11 net3 net1 VDD VDD pch l=0.15 w=1 nf=1 m=1
M12 net3 net3 VSS VSS nch l=0.15 w=1 nf=1 m=1
M13 net0 net0 VDD VDD pch l=0.15 w=1 nf=1 m=1
M14 net0 net3 VSS VSS nch l=0.15 w=1 nf=1 m=1
M15 VB2 net0 VDD VDD pch l=0.15 w=1 nf=1 m=1
M16 VB2 VB2 VSS VSS nch l=0.15 w=1 nf=1 m=1
M17 VB1 VB1 VDD VDD pch l=0.15 w=1 nf=1 m=1
M18 VB1 VB2 VSS VSS nch l=0.15 w=1 nf=1 m=1
M2 net2 Y net6 VSS nch l=0.15 w=1 nf=1 m=1
M3 net5 net5 VDD VDD pch l=0.15 w=1 nf=1 m=1
M4 net2 net2 VDD VDD pch l=0.15 w=1 nf=1 m=1
M5 net6 VB2 VSS VSS nch l=0.15 w=1 nf=1 m=1
M6 Vout net5 VDD VDD pch l=0.15 w=1 nf=1 m=1
M7 net4 net2 VDD VDD pch l=0.15 w=1 nf=1 m=1
M8 Vout net4 VSS VSS nch l=0.15 w=1 nf=1 m=1
M9 net4 net4 VSS VSS nch l=0.15 w=1 nf=1 m=1
Q1 X X VSS VSS qnpn m=1
Q2 net4 net4 VSS VSS qnpn m=1
R1 Vout X 1k
R2 Vout Y 1k
R3 Y net4 1k
R4 VDD net1 1k
R5 VDD net3 1k
.ends dut
