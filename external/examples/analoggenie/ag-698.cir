* official Analog Canvas netlist; PDK X cards rewritten by convert.py
.model nch nmos

.subckt dut VSS IIN IOUT
CL IOUT VSS 1p
M1 IIN IIN VSS VSS nch l=0.15 w=1 nf=1 m=1
M2 IOUT IIN VSS VSS nch l=0.15 w=1 nf=1 m=1
.ends dut
