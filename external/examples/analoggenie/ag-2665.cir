* official Analog Canvas netlist; PDK X cards rewritten by convert.py
.model nch nmos
.model pch pmos

.subckt opamp VDD VSS INN INP OUT
M10 net0 VB4 net4 VSS nch l=0.15 w=1 nf=1 m=1
M11 OUT VB4 net3 VSS nch l=0.15 w=1 nf=1 m=1
M12 net4 VB5 VSS VSS nch l=0.15 w=1 nf=1 m=1
M13 net3 VB5 VSS VSS nch l=0.15 w=1 nf=1 m=1
M14 VB4 net2 VDD VDD pch l=0.15 w=1 nf=1 m=1
M15 VB4 VB4 VB5 VSS nch l=0.15 w=1 nf=1 m=1
M16 VB5 VB5 VSS VSS nch l=0.15 w=1 nf=1 m=1
M17 net2 net2 VDD VDD pch l=0.15 w=1 nf=1 m=1
M18 net2 VB3 VSS VSS nch l=0.15 w=1 nf=1 m=1
M19 VB3 net2 VDD VDD pch l=0.15 w=1 nf=1 m=1
M20 VB3 VB3 VSS VSS nch l=0.15 w=1 nf=1 m=1
M3 INN VB1 VDD VDD pch l=0.15 w=1 nf=1 m=1
M4 net4 INP INN VDD pch l=0.15 w=1 nf=1 m=1
M5 net3 INN INN VDD pch l=0.15 w=1 nf=1 m=1
M6 net5 net0 VDD VDD pch l=0.15 w=1 nf=1 m=1
M7 net1 net0 VDD VDD pch l=0.15 w=1 nf=1 m=1
M8 net0 VB2 net5 VDD pch l=0.15 w=1 nf=1 m=1
M9 OUT VB2 net1 VDD pch l=0.15 w=1 nf=1 m=1
.ends opamp

.subckt dut VDD VSS vci phi1 phi2 vco
C1 vcx VSS 1p
C2 net0 vco 1p
M1 vci phi1 vcx VSS nch l=0.15 w=1 nf=1 m=1
M2 vcx phi2 net0 VSS nch l=0.15 w=1 nf=1 m=1
X1 VDD VSS net0 VSS vco opamp
.ends dut
