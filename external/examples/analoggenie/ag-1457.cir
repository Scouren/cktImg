* official Analog Canvas netlist; PDK X cards rewritten by convert.py
.model nch nmos
.model pch pmos

.subckt zcd VDD VSS INN OUT VB1
M1 VB1 VBP VDD VDD pch l=0.15 w=1 nf=1 m=1
M10 VB1 VB1 VSS VSS nch l=0.15 w=1 nf=1 m=1
M11 VBP net3 VSS VSS nch l=0.15 w=1 nf=1 m=1
M12 net3 net3 VSS VSS nch l=0.15 w=1 nf=1 m=1
M13 VX net3 VSS VSS nch l=0.15 w=1 nf=1 m=1
M14 VX VX VSS VSS nch l=0.15 w=1 nf=1 m=1
M15 net0 net0 VSS VSS nch l=0.15 w=1 nf=1 m=1
M16 net2 net0 VSS VSS nch l=0.15 w=1 nf=1 m=1
M17 OUT VX VSS VSS nch l=0.15 w=1 nf=1 m=1
M2 VBP VBP VDD VDD pch l=0.15 w=1 nf=1 m=1
M3 net3 VX VDD VDD pch l=0.15 w=1 nf=1 m=1
M4 VX VX VDD VDD pch l=0.15 w=1 nf=1 m=1
M5 INN VBP VDD VDD pch l=0.15 w=1 nf=1 m=1
M6 net2 net2 VDD VDD pch l=0.15 w=1 nf=1 m=1
M7 OUT net2 VDD VDD pch l=0.15 w=1 nf=1 m=1
M8 VX INN INN net1 pch l=0.15 w=1 nf=1 m=1
M9 net0 OUT INN net1 pch l=0.15 w=1 nf=1 m=1
R1 VDD net3 1k
.ends zcd

.subckt dut VDD VSS VSTO VCONT1 VCONT2 VCONT3 VOUT VB1
CL VOUT VSS 1p
CSTO VSTO VSS 1p
LRX net2 net0 1n
MN1 net2 VCONT2 VSS VSS nch l=0.15 w=1 nf=1 m=1
MN2 net0 VCONT3 VSS VSS nch l=0.15 w=1 nf=1 m=1
MP2 net0 net1 VOUT VOUT pch l=0.15 w=1 nf=1 m=1
MP3 net2 VCONT1 VSTO VSTO pch l=0.15 w=1 nf=1 m=1
X1 VDD VSS net0 net1 VB1 zcd
.ends dut
