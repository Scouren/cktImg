* official Analog Canvas netlist; PDK X cards rewritten by convert.py
.model nch nmos
.model pch pmos

.subckt dut VDD VSS vci phi1 phi2 vco
C1 net1 net5 1p
C2 net4 vco 1p
M1 vci phi1 net1 VSS nch l=0.15 w=1 nf=1 m=1
M10 net2 VB1 VSS VSS nch l=0.15 w=1 nf=1 m=1
M11 net3 net3 VSS VSS nch l=0.15 w=1 nf=1 m=1
M12 net0 net3 VSS VSS nch l=0.15 w=1 nf=1 m=1
M13 net0 net0 VDD VDD pch l=0.15 w=1 nf=1 m=1
M14 VB1 net0 VDD VDD pch l=0.15 w=1 nf=1 m=1
M15 VB1 VB1 VSS VSS nch l=0.15 w=1 nf=1 m=1
M16 VX VB1 VSS VSS nch l=0.15 w=1 nf=1 m=1
M2 net1 phi2 VSS VSS nch l=0.15 w=1 nf=1 m=1
M3 net5 phi1 VSS VSS nch l=0.15 w=1 nf=1 m=1
M4 net5 phi2 net4 VSS nch l=0.15 w=1 nf=1 m=1
M5 VX net4 net2 VSS nch l=0.15 w=1 nf=1 m=1
M6 vco VSS net2 VSS nch l=0.15 w=1 nf=1 m=1
M7 VX VX VDD VDD pch l=0.15 w=1 nf=1 m=1
M8 VX VX VDD VDD pch l=0.15 w=1 nf=1 m=1
M9 vco VX VDD VDD pch l=0.15 w=1 nf=1 m=1
R1 VDD net3 1k
.ends dut
