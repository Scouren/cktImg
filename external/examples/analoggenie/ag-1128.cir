* official Analog Canvas netlist; PDK X cards rewritten by convert.py
.model pch pmos

.subckt dut VDD VSS VBias Vtune Out+ Out-
CE VDD net0 1p
L1 VSS Out+ 1n
L2 VSS Out- 1n
M1 Out+ Out- net0 net0 pch l=0.15 w=1 nf=1 m=1
M2 Out- Out+ net0 net0 pch l=0.15 w=1 nf=1 m=1
M3 net0 VBias VDD VDD pch l=0.15 w=1 nf=1 m=1
M4 Vtune Out+ Vtune VDD pch l=0.15 w=1 nf=1 m=1
M5 Vtune Out- Vtune VDD pch l=0.15 w=1 nf=1 m=1
k L1 L2 1
.ends dut
