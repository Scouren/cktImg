* official Analog Canvas netlist; PDK X cards rewritten by convert.py
.model nch nmos
.model pch pmos

.subckt dut VDD VSS VSTO VC1 VC2 VC3 VOUT
CL VOUT VSS 1p
CSTO VSTO VSS 1p
LRX net0 VX 1n
M10 VG VG VDD VDD pch l=0.15 w=1 nf=1 m=1
M11 VB1 VB1 VSS VSS nch l=0.15 w=1 nf=1 m=1
M12 VB1 net3 VDD VDD pch l=0.15 w=1 nf=1 m=1
M13 net3 net3 net4 VDD pch l=0.15 w=1 nf=1 m=1
M14 net1 VB1 VSS VSS nch l=0.15 w=1 nf=1 m=1
M3 net2 VX net1 VSS nch l=0.15 w=1 nf=1 m=1
M4 VG VG net1 VSS nch l=0.15 w=1 nf=1 m=1
M5 net2 net2 VDD VDD pch l=0.15 w=1 nf=1 m=1
M6 VG VG VDD VDD pch l=0.15 w=1 nf=1 m=1
M7 VY net2 VDD VDD pch l=0.15 w=1 nf=1 m=1
M8 VY VY VSS VSS nch l=0.15 w=1 nf=1 m=1
M9 VG VY VSS VSS nch l=0.15 w=1 nf=1 m=1
MN1 net0 VC2 VSS VSS nch l=0.15 w=1 nf=1 m=1
MN2 VX VC3 VSS VSS nch l=0.15 w=1 nf=1 m=1
MP2 VX VG VOUT VDD pch l=0.15 w=1 nf=1 m=1
MP3 net0 VC1 VSTO VDD pch l=0.15 w=1 nf=1 m=1
R1 VDD net4 1k
R2 net3 VSS 1k
.ends dut
