* official Analog Canvas netlist; PDK X cards rewritten by convert.py
.model nch nmos
.model pch pmos

.subckt opamp VDD VSS INN INP OUT
M10 OUT net2 VSS VSS nch l=0.15 w=1 nf=1 m=1
M11 net2 INN VDD VDD pch l=0.15 w=1 nf=1 m=1
M12 net2 net2 VSS VSS nch l=0.15 w=1 nf=1 m=1
M13 VB1 VB1 VDD VDD pch l=0.15 w=1 nf=1 m=1
M14 VB1 VB3 VSS VSS nch l=0.15 w=1 nf=1 m=1
M15 VB3 net3 VDD VDD pch l=0.15 w=1 nf=1 m=1
M16 VB3 VB3 VSS VSS nch l=0.15 w=1 nf=1 m=1
M17 net3 net3 VDD VDD pch l=0.15 w=1 nf=1 m=1
M18 net3 net0 VSS VSS nch l=0.15 w=1 nf=1 m=1
M19 net0 VB2 VDD VDD pch l=0.15 w=1 nf=1 m=1
M20 net0 net0 VSS VSS nch l=0.15 w=1 nf=1 m=1
M21 VB2 VB2 VDD VDD pch l=0.15 w=1 nf=1 m=1
M22 VB2 net0 VX VSS nch l=0.15 w=1 nf=1 m=1
M23 net1 VB2 VDD VDD pch l=0.15 w=1 nf=1 m=1
M24 net1 net1 VSS VSS nch l=0.15 w=1 nf=1 m=1
M25 VX net1 VSS VSS nch l=0.15 w=1 nf=1 m=1
M4 INN net4 VDD VDD pch l=0.15 w=1 nf=1 m=1
M5 net5 net4 VDD VDD pch l=0.15 w=1 nf=1 m=1
M6 INN INN VX VSS nch l=0.15 w=1 nf=1 m=1
M7 net5 INP VX VSS nch l=0.15 w=1 nf=1 m=1
M8 VX VB3 VSS VSS nch l=0.15 w=1 nf=1 m=1
M9 OUT net5 VDD VDD pch l=0.15 w=1 nf=1 m=1
.ends opamp

.subckt dut VDD VSS vci phi1 phi2 vco
C1 vcx VSS 1p
C2 net0 vco 1p
M1 vci phi1 vcx VSS nch l=0.15 w=1 nf=1 m=1
M2 vcx phi2 net0 VSS nch l=0.15 w=1 nf=1 m=1
X1 VDD VSS net0 VSS vco opamp
.ends dut
