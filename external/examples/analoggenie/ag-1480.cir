* official Analog Canvas netlist; PDK X cards rewritten by convert.py
.model nch nmos
.model pch pmos
.model qnpn npn

.global VDD

.subckt opamp VSS INN INP OUT
M1 net0 VB1 VDD VDD pch l=0.15 w=1 nf=1 m=1
M10 net5 net3 VSS VSS nch l=0.15 w=1 nf=1 m=1
M11 net2 VB5 VSS VSS nch l=0.15 w=1 nf=1 m=1
M12 VB3 net1 VDD VDD pch l=0.15 w=1 nf=1 m=1
M13 net6 VB3 VSS VSS nch l=0.15 w=1 nf=1 m=1
M14 net1 net1 VDD VDD pch l=0.15 w=1 nf=1 m=1
M15 net1 VB3 VSS VSS nch l=0.15 w=1 nf=1 m=1
M16 VB4 net1 VDD VDD pch l=0.15 w=1 nf=1 m=1
M17 VB4 VB4 VB5 VSS nch l=0.15 w=1 nf=1 m=1
M18 VB5 VB5 VSS VSS nch l=0.15 w=1 nf=1 m=1
M2 net4 VB1 VDD VDD pch l=0.15 w=1 nf=1 m=1
M3 net4 INN net2 VSS nch l=0.15 w=1 nf=1 m=1
M4 net0 INP net2 VSS nch l=0.15 w=1 nf=1 m=1
M5 OUT VB2 net0 VDD pch l=0.15 w=1 nf=1 m=1
M6 net3 VB2 net4 VDD pch l=0.15 w=1 nf=1 m=1
M7 OUT VB4 net7 VSS nch l=0.15 w=1 nf=1 m=1
M8 net3 VB4 net5 VSS nch l=0.15 w=1 nf=1 m=1
M9 net7 net3 VSS VSS nch l=0.15 w=1 nf=1 m=1
R4 VB3 net6 1k
.ends opamp

.subckt dut VSS Vout
Q1 X X VSS VSS qnpn m=1
Q2 net0 net0 VSS VSS qnpn m=1
R1 Vout X 1k
R2 Vout Y 1k
R3 Y net0 1k
X1 VSS Y X Vout opamp
.ends dut
