* official Analog Canvas netlist; PDK X cards rewritten by convert.py
.model nch nmos
.model pch pmos

.subckt opamp VDD VSS INN INP OUT VX
M10 net2 VB3 net1 VDD pch l=0.15 w=1 nf=1 m=1
M11 OUT VB3 net7 VDD pch l=0.15 w=1 nf=1 m=1
M12 net2 VCN net6 VSS nch l=0.15 w=1 nf=1 m=1
M13 OUT VCN VX VSS nch l=0.15 w=1 nf=1 m=1
M14 net6 net2 VSS VSS nch l=0.15 w=1 nf=1 m=1
M15 VX net2 VSS VSS nch l=0.15 w=1 nf=1 m=1
M16 VCN net5 VDD VDD pch l=0.15 w=1 nf=1 m=1
M17 VCN VCN net3 VSS nch l=0.15 w=1 nf=1 m=1
M18 net3 VCN VSS VSS nch l=0.15 w=1 nf=1 m=1
M19 net5 net5 VDD VDD pch l=0.15 w=1 nf=1 m=1
M20 net5 VB4 net0 VSS nch l=0.15 w=1 nf=1 m=1
M21 VB4 net5 VDD VDD pch l=0.15 w=1 nf=1 m=1
M22 VB4 VB4 VSS VSS nch l=0.15 w=1 nf=1 m=1
M5 net1 INN net4 VSS nch l=0.15 w=1 nf=1 m=1
M6 net7 INP net4 VSS nch l=0.15 w=1 nf=1 m=1
M7 net4 VB2 VSS VSS nch l=0.15 w=1 nf=1 m=1
M8 net1 VB1 VDD VDD pch l=0.15 w=1 nf=1 m=1
M9 net7 VB1 VDD VDD pch l=0.15 w=1 nf=1 m=1
R1 net0 VSS 1k
.ends opamp

.subckt dut VDD VSS vci phi1 phi2 vco
C1 net1 VX 1p
C2 net0 vco 1p
M1 vci phi1 VX VSS nch l=0.15 w=1 nf=1 m=1
M2 VX phi2 VSS VSS nch l=0.15 w=1 nf=1 m=1
M3 net1 phi1 VSS VSS nch l=0.15 w=1 nf=1 m=1
M4 net1 phi2 net0 VSS nch l=0.15 w=1 nf=1 m=1
X1 VDD VSS net0 VSS vco VX opamp
.ends dut
