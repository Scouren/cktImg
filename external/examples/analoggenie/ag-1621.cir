* official Analog Canvas netlist; PDK X cards rewritten by convert.py
.model nch nmos
.model pch pmos
.model qpnp pnp

.subckt opamp VDD VSS IN- IN+ OUT
M1 net4 net2 VDD VDD pch l=0.15 w=1 nf=1 m=1
M10 VB3 VB1 VDD VDD pch l=0.15 w=1 nf=1 m=1
M11 VB3 VB3 VSS VSS nch l=0.15 w=1 nf=1 m=1
M12 VB1 VB1 VDD VDD pch l=0.15 w=1 nf=1 m=1
M13 VB1 net3 VSS VSS nch l=0.15 w=1 nf=1 m=1
M14 net3 VB2 VDD VDD pch l=0.15 w=1 nf=1 m=1
M15 net3 net3 VSS VSS nch l=0.15 w=1 nf=1 m=1
M16 net6 VB2 VDD VDD pch l=0.15 w=1 nf=1 m=1
M17 net6 net6 net8 VSS nch l=0.15 w=1 nf=1 m=1
M18 net8 net6 net3 VSS nch l=0.15 w=1 nf=1 m=1
M19 net7 VB2 VDD VDD pch l=0.15 w=1 nf=1 m=1
M2 net2 net2 VDD VDD pch l=0.15 w=1 nf=1 m=1
M20 net7 net7 net1 VSS nch l=0.15 w=1 nf=1 m=1
M21 net1 net7 net8 VSS nch l=0.15 w=1 nf=1 m=1
M22 VB2 VB2 VDD VDD pch l=0.15 w=1 nf=1 m=1
M23 VB2 net1 VSS VSS nch l=0.15 w=1 nf=1 m=1
M3 net5 net5 VDD VDD pch l=0.15 w=1 nf=1 m=1
M4 OUT net5 VDD VDD pch l=0.15 w=1 nf=1 m=1
M5 net2 IN- net0 VSS nch l=0.15 w=1 nf=1 m=1
M6 net5 IN+ net0 VSS nch l=0.15 w=1 nf=1 m=1
M7 net0 VB3 VSS VSS nch l=0.15 w=1 nf=1 m=1
M8 net4 net4 VSS VSS nch l=0.15 w=1 nf=1 m=1
M9 OUT net4 VSS VSS nch l=0.15 w=1 nf=1 m=1
.ends opamp

.subckt dut VDD VSS Vout
Q1 VSS VSS X qpnp m=1
Q2 VSS VSS net0 qpnp m=1
R1 Vout X 1k
R2 Vout Y 1k
R3 Y net0 1k
X1 VDD VSS Y X Vout opamp
.ends dut
