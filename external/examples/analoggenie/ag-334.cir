* official Analog Canvas netlist; PDK X cards rewritten by convert.py
.model nch nmos
.model pch pmos

.subckt dut VDD VSS Vb1 Vb2 Vin1 Vin2 Vout1 Vout2
M1 Vout1 Vb1 VDD Vin1 pch l=0.15 w=1 nf=1 m=1
M2 Vout2 Vb1 VDD Vin2 pch l=0.15 w=1 nf=1 m=1
M3 Vout1 Vb2 VSS VSS nch l=0.15 w=1 nf=1 m=1
M4 Vout2 Vb2 VSS VSS nch l=0.15 w=1 nf=1 m=1
.ends dut
