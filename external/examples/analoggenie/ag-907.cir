* official Analog Canvas netlist; PDK X cards rewritten by convert.py
.model nch nmos
.model pch pmos

.subckt dut VDD VSS VB in- in+ Vo
C Vo net1 1p
I1 VDD net2 DC 1m
I2 VDD net1 DC 1m
I3 VDD Vo DC 1m
I4 1 VSS DC 1m
M1 net0 in- net2 VDD pch l=0.15 w=1 nf=1 m=1
M11 1 VB net1 VDD pch l=0.15 w=1 nf=1 m=1
M2 1 in+ net2 VDD pch l=0.15 w=1 nf=1 m=1
M3 net0 net0 VSS VSS nch l=0.15 w=1 nf=1 m=1
M4 1 net0 VSS VSS nch l=0.15 w=1 nf=1 m=1
M6 Vo 1 VSS VSS nch l=0.15 w=1 nf=1 m=1
.ends dut
