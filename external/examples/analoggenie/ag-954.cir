* official Analog Canvas netlist; PDK X cards rewritten by convert.py
.model nch nmos
.model pch pmos

.subckt dut VDD VSS Vin+ Vin- VNBias1 iOUT
M1 net1 Vin+ net2 VSS nch l=0.15 w=1 nf=1 m=1
M2 iOUT Vin- net0 VSS nch l=0.15 w=1 nf=1 m=1
M3 net1 net1 VDD VDD pch l=0.15 w=1 nf=1 m=1
M4 iOUT net1 VDD VDD pch l=0.15 w=1 nf=1 m=1
M5A net2 VNBias1 VSS VSS nch l=0.15 w=1 nf=1 m=1
M5B net0 VNBias1 VSS VSS nch l=0.15 w=1 nf=1 m=1
M6 net2 Vin+ net0 VSS nch l=0.15 w=1 nf=1 m=1
M7 net2 Vin- net0 VSS nch l=0.15 w=1 nf=1 m=1
.ends dut
