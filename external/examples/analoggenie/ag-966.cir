* official Analog Canvas netlist; PDK X cards rewritten by convert.py
.model nch nmos
.model pch pmos

.subckt dut VDD VSS VP1 vin VP2 VN2 VN1 vout
M1 net0 vin VSS VSS nch l=0.15 w=1 nf=1 m=1
M2 net0 VP1 VDD VDD pch l=0.15 w=1 nf=1 m=1
M3 net0 VP1 VDD VDD pch l=0.15 w=1 nf=1 m=1
M4 vout VP2 net0 VDD pch l=0.15 w=1 nf=1 m=1
M5 vout VN2 net1 VSS nch l=0.15 w=1 nf=1 m=1
M6 net1 VN1 VSS VSS nch l=0.15 w=1 nf=1 m=1
.ends dut
