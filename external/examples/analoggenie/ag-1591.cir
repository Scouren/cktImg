* official Analog Canvas netlist; PDK X cards rewritten by convert.py
.model nch nmos
.model pch pmos
.model qpnp pnp

.subckt A1 VDD VSS VB3 VB2 VB1 INP INN OUT
M1 VP net0 VDD VDD pch l=0.15 w=1 nf=1 m=1
M10 VX VB4 net1 VSS nch l=0.15 w=1 nf=1 m=1
M11 net1 VB5 VSS VSS nch l=0.15 w=1 nf=1 m=1
M12 VP VB1 VDD VDD pch l=0.15 w=1 nf=1 m=1
M13 net1 INP VP VDD pch l=0.15 w=1 nf=1 m=1
M14 net3 INN VP VDD pch l=0.15 w=1 nf=1 m=1
M15 net4 VX VDD VDD pch l=0.15 w=1 nf=1 m=1
M16 OUT VB2 net4 VDD pch l=0.15 w=1 nf=1 m=1
M17 OUT VB4 net3 VSS nch l=0.15 w=1 nf=1 m=1
M18 net3 VB5 VSS VSS nch l=0.15 w=1 nf=1 m=1
M2 VP VB3 VSS VSS nch l=0.15 w=1 nf=1 m=1
M3 net0 net0 VDD VDD pch l=0.15 w=1 nf=1 m=1
M4 net0 VP VB3 VSS nch l=0.15 w=1 nf=1 m=1
M5 VB4 net0 VDD VDD pch l=0.15 w=1 nf=1 m=1
M6 VB4 VB4 VB5 VSS nch l=0.15 w=1 nf=1 m=1
M7 VB5 VB5 VSS VSS nch l=0.15 w=1 nf=1 m=1
M8 net2 VX VDD VDD pch l=0.15 w=1 nf=1 m=1
M9 VX VB2 net2 VDD pch l=0.15 w=1 nf=1 m=1
R4 VB3 VSS 1k
.ends A1

.subckt dut VDD VSS Vout VB1 VB2 VB3
Q1 VSS VSS net0 qpnp m=1
Q2 VSS VSS net2 qpnp m=1
R1 Vout net0 1k
R2 Vout net1 1k
R3 net1 net2 1k
X1 VDD VSS VB3 VB2 VB1 net0 net1 Vout A1
.ends dut
