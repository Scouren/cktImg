* official Analog Canvas netlist; PDK X cards rewritten by convert.py
.model nch nmos
.model pch pmos
.model qpnp pnp

.subckt opamp VDD VSS INN INP OUT VB1 VB2
M1 net9 VB3 VSS VSS nch l=0.15 w=1 nf=1 m=1
M10 net4 net4 VSS VSS nch l=0.15 w=1 nf=1 m=1
M11 OUT net4 VSS VSS nch l=0.15 w=1 nf=1 m=1
M12 VB2 VB2 VDD VDD pch l=0.15 w=1 nf=1 m=1
M13 net2 VB2 VDD VDD pch l=0.15 w=1 nf=1 m=1
M14 net7 VB2 VDD VDD pch l=0.15 w=1 nf=1 m=1
M15 net3 VB2 VDD VDD pch l=0.15 w=1 nf=1 m=1
M16 VB2 net6 VSS VSS nch l=0.15 w=1 nf=1 m=1
M17 net2 net2 net6 VSS nch l=0.15 w=1 nf=1 m=1
M18 net6 net2 net8 VSS nch l=0.15 w=1 nf=1 m=1
M19 net8 net7 net3 VSS nch l=0.15 w=1 nf=1 m=1
M2 net5 INN net9 VSS nch l=0.15 w=1 nf=1 m=1
M20 net3 net3 VSS VSS nch l=0.15 w=1 nf=1 m=1
M21 net7 net7 net8 VSS nch l=0.15 w=1 nf=1 m=1
M22 net1 net1 VDD VDD pch l=0.15 w=1 nf=1 m=1
M23 VB3 net1 VDD VDD pch l=0.15 w=1 nf=1 m=1
M24 VB1 VB1 VDD VDD pch l=0.15 w=1 nf=1 m=1
M25 net1 net3 VSS VSS nch l=0.15 w=1 nf=1 m=1
M26 VB3 VB3 VSS VSS nch l=0.15 w=1 nf=1 m=1
M27 VB1 VB3 VSS VSS nch l=0.15 w=1 nf=1 m=1
M3 net0 INP net9 VSS nch l=0.15 w=1 nf=1 m=1
M6 net5 net5 VDD VDD pch l=0.15 w=1 nf=1 m=1
M7 net0 net0 VDD VDD pch l=0.15 w=1 nf=1 m=1
M8 net4 net5 VDD VDD pch l=0.15 w=1 nf=1 m=1
M9 OUT net0 VDD VDD pch l=0.15 w=1 nf=1 m=1
.ends opamp

.subckt dut VDD VSS Vout VB1 VB2
Q1 VSS VSS X qpnp m=1
Q2 VSS VSS net0 qpnp m=1
R1 Vout X 1k
R2 Vout Y 1k
R3 Y net0 1k
X1 VDD VSS Y X Vout VB1 VB2 opamp
.ends dut
