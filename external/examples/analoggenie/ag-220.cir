* official Analog Canvas netlist; PDK X cards rewritten by convert.py
.model nch nmos

.subckt dut VDD VSS Vin1 Vin2 Vout1 Vout2 Vb
M1 Vout1 Vin1 net2 VSS nch l=0.15 w=1 nf=1 m=1
M2 Vout2 Vin2 net0 VSS nch l=0.15 w=1 nf=1 m=1
M3 net1 Vb VSS VSS nch l=0.15 w=1 nf=1 m=1
R1 VDD Vout1 1k
R2 VDD Vout2 1k
RS net2 net1 1k
RS2 net1 net0 1k
.ends dut
