* official Analog Canvas netlist; PDK X cards rewritten by convert.py
.model nch nmos
.model pch pmos

.subckt dut VDD VSS VB3 VB1 VREF VB2 VIN VB6 VB5 VB4 VOUT
CF1 VOUT VFB 1p
Cm1 VOUT VO1 1p
Cm2 net9 VO1 1p
M10 net6 VP VIN VDD pch l=0.15 w=1 nf=1 m=1
M11 VX VB1 VIN VDD pch l=0.15 w=1 nf=1 m=1
M12 net4 VFB VX VDD pch l=0.15 w=1 nf=1 m=1
M13 net7 VREF VX VDD pch l=0.15 w=1 nf=1 m=1
M14 net4 VN1 VSS VSS nch l=0.15 w=1 nf=1 m=1
M15 net7 VN1 VSS VSS nch l=0.15 w=1 nf=1 m=1
M16 VY VP VIN VDD pch l=0.15 w=1 nf=1 m=1
M17 VP VN2 net4 VSS nch l=0.15 w=1 nf=1 m=1
M18 VO1 VN2 net7 VSS nch l=0.15 w=1 nf=1 m=1
M19 VP VB2 VY VDD pch l=0.15 w=1 nf=1 m=1
M20 VO1 VB2 net6 VDD pch l=0.15 w=1 nf=1 m=1
M21 net1 VO1 VSS VSS nch l=0.15 w=1 nf=1 m=1
M22 net8 net2 VSS VSS nch l=0.15 w=1 nf=1 m=1
M23 net1 net1 VIN VDD pch l=0.15 w=1 nf=1 m=1
M24 net8 net1 VIN VDD pch l=0.15 w=1 nf=1 m=1
M25 net2 VB4 VIN VDD pch l=0.15 w=1 nf=1 m=1
M26 net2 net2 VSS VSS nch l=0.15 w=1 nf=1 m=1
M27 net2 VO1 VSS VSS nch l=0.15 w=1 nf=1 m=1
M31 VN2 net3 VIN VDD pch l=0.15 w=1 nf=1 m=1
M32 VN2 VN2 VN1 VSS nch l=0.15 w=1 nf=1 m=1
M33 VN1 VN1 VSS VSS nch l=0.15 w=1 nf=1 m=1
M34 net3 net3 VIN VDD pch l=0.15 w=1 nf=1 m=1
M35 VX net3 VIN VDD pch l=0.15 w=1 nf=1 m=1
M36 net3 VX VB3 VSS nch l=0.15 w=1 nf=1 m=1
M37 VX VB3 VSS VSS nch l=0.15 w=1 nf=1 m=1
MD1 net9 VO1 VSS VSS nch l=0.15 w=1 nf=1 m=1
MD2 VY VB5 VSS VSS nch l=0.15 w=1 nf=1 m=1
MD3 net5 net9 VY VSS nch l=0.15 w=1 nf=1 m=1
MD4 net0 VB6 VY VSS nch l=0.15 w=1 nf=1 m=1
MD5 net9 net0 VIN VDD pch l=0.15 w=1 nf=1 m=1
MD6 net5 net5 VIN VDD pch l=0.15 w=1 nf=1 m=1
MD7 net0 net0 VIN VDD pch l=0.15 w=1 nf=1 m=1
MPT VOUT net8 VIN VDD pch l=0.15 w=1 nf=1 m=1
RB VB3 VSS 1k
RF1 VOUT VFB 1k
RF2 VFB VSS 1k
.ends dut
