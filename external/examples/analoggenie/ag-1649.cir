* official Analog Canvas netlist; PDK X cards rewritten by convert.py
.model nch nmos
.model pch pmos
.model qpnp pnp

.subckt opamp VDD VSS INN INP VB2 VB1 OUT VE
M1 net8 INN net4 VSS nch l=0.15 w=1 nf=1 m=1
M10 VX VB1 net11 VDD pch l=0.15 w=1 nf=1 m=1
M11 OUT VB1 net9 VDD pch l=0.15 w=1 nf=1 m=1
M12 VX VB5 net7 VSS nch l=0.15 w=1 nf=1 m=1
M13 OUT VB5 VE VSS nch l=0.15 w=1 nf=1 m=1
M14 net7 VX VSS VSS nch l=0.15 w=1 nf=1 m=1
M15 VE VX VSS VSS nch l=0.15 w=1 nf=1 m=1
M16 VB5 VB6 VDD VDD pch l=0.15 w=1 nf=1 m=1
M17 VB5 VB5 net6 VSS nch l=0.15 w=1 nf=1 m=1
M18 net6 VB5 VSS VSS nch l=0.15 w=1 nf=1 m=1
M19 VB6 VB6 VDD VDD pch l=0.15 w=1 nf=1 m=1
M2 net0 INP net4 VSS nch l=0.15 w=1 nf=1 m=1
M20 net2 VB6 VDD VDD pch l=0.15 w=1 nf=1 m=1
M21 net3 VB6 VDD VDD pch l=0.15 w=1 nf=1 m=1
M22 VB6 net2 net5 VSS nch l=0.15 w=1 nf=1 m=1
M23 net2 net5 VSS VSS nch l=0.15 w=1 nf=1 m=1
M24 net5 net3 VSS VSS nch l=0.15 w=1 nf=1 m=1
M25 net3 net3 VSS VSS nch l=0.15 w=1 nf=1 m=1
M3 net4 VB2 VSS VSS nch l=0.15 w=1 nf=1 m=1
M4 net1 net8 VDD VDD pch l=0.15 w=1 nf=1 m=1
M5 net10 net0 VDD VDD pch l=0.15 w=1 nf=1 m=1
M6 net8 VB1 net1 VDD pch l=0.15 w=1 nf=1 m=1
M7 net0 VB1 net10 VDD pch l=0.15 w=1 nf=1 m=1
M8 net11 net8 VDD VDD pch l=0.15 w=1 nf=1 m=1
M9 net9 net0 VDD VDD pch l=0.15 w=1 nf=1 m=1
.ends opamp

.subckt dut VDD VSS Vout VB2 VB1
Q1 VSS VSS net2 qpnp m=1
Q2 net2 net2 X qpnp m=1
Q3 VSS VSS net1 qpnp m=1
Q4 net1 net1 net0 qpnp m=1
R1 Vout X 1k
R2 Vout Y 1k
R3 Y net0 1k
X1 VDD VSS Y X VB2 VB1 Vout net0 opamp
.ends dut
