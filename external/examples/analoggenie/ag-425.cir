* official Analog Canvas netlist; PDK X cards rewritten by convert.py
.model nch nmos

.subckt dut VDD VSS
C1 net1 net2 1p
C2 net0 net2 1p
LP net0 net1 1n
M1 net0 net1 net2 VSS nch l=0.15 w=1 nf=1 m=1
RP net0 net1 1k
.ends dut
