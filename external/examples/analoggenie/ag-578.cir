* official Analog Canvas netlist; PDK X cards rewritten by convert.py
.model nch nmos

.subckt dut VDD VSS Vin
C1 X net0 1p
L1 VDD X 1n
M1 X Vin VSS VSS nch l=0.15 w=1 nf=1 m=1
RL net0 VSS 1k
.ends dut
