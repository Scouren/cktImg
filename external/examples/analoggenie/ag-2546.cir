* official Analog Canvas netlist; PDK X cards rewritten by convert.py
.model nch nmos
.model pch pmos

.subckt dut VDD VSS VB2 biasp biascas biasn Vout
C1 Vset VSS 1p
C2 n3 Vout 1p
M1 Vout n3 VDD VDD pch l=0.15 w=1 nf=1 m=1
M10 net10 VB1 net3 VDD pch l=0.15 w=1 nf=1 m=1
M11 n3 VB1 net6 VDD pch l=0.15 w=1 nf=1 m=1
M12 net4 VB1 net11 VDD pch l=0.15 w=1 nf=1 m=1
M13 Vset VB1 net8 VDD pch l=0.15 w=1 nf=1 m=1
M14 n3 fb net1 VSS nch l=0.15 w=1 nf=1 m=1
M15 net4 Vref net1 VSS nch l=0.15 w=1 nf=1 m=1
M16 net1 VB2 VSS VSS nch l=0.15 w=1 nf=1 m=1
M17 net10 VB7 net7 VSS nch l=0.15 w=1 nf=1 m=1
M18 net7 net10 VSS VSS nch l=0.15 w=1 nf=1 m=1
M19 Vset VB7 net5 VSS nch l=0.15 w=1 nf=1 m=1
M2 n1 Vset Vout VDD pch l=0.15 w=1 nf=1 m=1
M20 net5 net10 VSS VSS nch l=0.15 w=1 nf=1 m=1
M21 VB3 net2 VDD VDD pch l=0.15 w=1 nf=1 m=1
M22 net2 net2 VDD VDD pch l=0.15 w=1 nf=1 m=1
M23 VB7 net2 VDD VDD pch l=0.15 w=1 nf=1 m=1
M24 VB3 VB3 VSS VSS nch l=0.15 w=1 nf=1 m=1
M25 net2 VB3 net9 VSS nch l=0.15 w=1 nf=1 m=1
M26 VB7 VB7 net0 VSS nch l=0.15 w=1 nf=1 m=1
M27 net0 VB7 VSS VSS nch l=0.15 w=1 nf=1 m=1
M3 n1 biasn VSS VSS nch l=0.15 w=1 nf=1 m=1
M4 n3 biasp VDD VDD pch l=0.15 w=1 nf=1 m=1
M5 n3 biascas n1 VSS nch l=0.15 w=1 nf=1 m=1
M6 net3 n3 VDD VDD pch l=0.15 w=1 nf=1 m=1
M7 net6 n3 VDD VDD pch l=0.15 w=1 nf=1 m=1
M8 net11 net4 VDD VDD pch l=0.15 w=1 nf=1 m=1
M9 net8 net4 VDD VDD pch l=0.15 w=1 nf=1 m=1
R1 fb VSS 1k
R2 Vout fb 1k
R3 net9 VSS 1k
.ends dut
