* official Analog Canvas netlist; PDK X cards rewritten by convert.py
.model nch nmos
.model pch pmos
.model qnpn npn

.subckt dut VDD VSS GND vin- vin+ vout
I1 VDD net5 DC 20uA
M1 net0 vin- net4 VSS nch l=0.15 w=1 nf=1 m=1
M2 net3 vin+ net4 VSS nch l=0.15 w=1 nf=1 m=1
M3 net0 net0 VDD VDD pch l=0.15 w=1 nf=1 m=1
M4 net3 net0 VDD VDD pch l=0.15 w=1 nf=1 m=1
M5 net4 net5 VSS VSS nch l=0.15 w=1 nf=1 m=1
M6 net1 net3 VDD VDD pch l=0.15 w=1 nf=1 m=1
M7 net1 net5 VSS VSS nch l=0.15 w=1 nf=1 m=1
M8 net5 net5 VSS VSS nch l=0.15 w=1 nf=1 m=1
M9 vout net5 VSS VSS nch l=0.15 w=1 nf=1 m=1
Q1 VDD net1 net2 VSS qnpn m=1
Q2 VDD net2 vout VSS qnpn m=1
.ends dut
