* official Analog Canvas netlist; PDK X cards rewritten by convert.py
.model nch nmos

.subckt dut VDD VSS Vin Vout
M1 net0 Vin net1 VSS nch l=0.15 w=1 nf=1 m=1
M2 Vout net0 net1 VSS nch l=0.15 w=1 nf=1 m=1
R1 VDD net0 20kΩ
R2 VDD Vout 10kΩ
R3 net1 VSS 5kΩ
.ends dut
