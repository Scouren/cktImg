* official Analog Canvas netlist; PDK X cards rewritten by convert.py
.model nch nmos

.subckt dut VDD VSS Vout
Cin net1 X 1p
IB VDD net0 DC 1m
M1 Vout net0 X VSS nch l=0.15 w=1 nf=1 m=1
MB net0 net0 net2 VSS nch l=0.15 w=1 nf=1 m=1
R1 net3 net1 1k
RB net2 VSS 1k
RD VDD Vout 1k
RS X VSS 1k
Vin net3 VSS DC 1
.ends dut
