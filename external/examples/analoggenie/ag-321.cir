* official Analog Canvas netlist; PDK X cards rewritten by convert.py
.model nch nmos
.model pch pmos

.subckt dut VDD VSS Vin Vout
CL Vout VSS 1p
ISS net0 VSS DC 1m
M1 net1 Vin net0 VSS nch l=0.15 w=1 nf=1 m=1
M2 Vout X net0 VSS nch l=0.15 w=1 nf=1 m=1
M3 net1 net1 VDD VDD pch l=0.15 w=1 nf=1 m=1
M4 Vout net1 VDD VDD pch l=0.15 w=1 nf=1 m=1
R1 Vout X 1k
R2 X VSS 1k
.ends dut
