* official Analog Canvas netlist; PDK X cards rewritten by convert.py
.model nch nmos
.model pch pmos

.subckt bias VDD VSS VIN VBN2 VBN1
M31 net0 net0 VIN VDD pch l=0.15 w=1 nf=1 m=1
M32 net2 net0 VIN VDD pch l=0.15 w=1 nf=1 m=1
M33 VBN2 net0 VIN VDD pch l=0.15 w=1 nf=1 m=1
M34 net2 net2 VSS VSS nch l=0.15 w=1 nf=1 m=1
M35 net0 net2 net1 VSS nch l=0.15 w=1 nf=1 m=1
M36 VBN2 VBN2 VBN1 VSS nch l=0.15 w=1 nf=1 m=1
M37 VBN1 VBN1 VSS VSS nch l=0.15 w=1 nf=1 m=1
R1 net1 VSS 1k
.ends bias

.subckt dut VDD VSS VB1 VREF VB5 VB3 VB2 VB4 VOUT VIN
CF1 VOUT VFB 1p
Cm1 net6 VOUT 1p
Cm2 net6 net5 1p
M11 net8 VB1 VIN VDD pch l=0.15 w=1 nf=1 m=1
M12 net1 VFB net8 VDD pch l=0.15 w=1 nf=1 m=1
M13 net10 VREF net8 VDD pch l=0.15 w=1 nf=1 m=1
M14 net1 VBN1 VSS VSS nch l=0.15 w=1 nf=1 m=1
M15 net10 VBN1 VSS VSS nch l=0.15 w=1 nf=1 m=1
M16 VX VB3 VIN VDD pch l=0.15 w=1 nf=1 m=1
M17 VX net6 VSS VSS nch l=0.15 w=1 nf=1 m=1
M18 VX VX VSS VSS nch l=0.15 w=1 nf=1 m=1
M21 net9 net6 VSS VSS nch l=0.15 w=1 nf=1 m=1
M22 net4 VX VSS VSS nch l=0.15 w=1 nf=1 m=1
M23 net9 net9 VIN VDD pch l=0.15 w=1 nf=1 m=1
M24 net4 net9 VIN VDD pch l=0.15 w=1 nf=1 m=1
M25 VY net0 VIN VDD pch l=0.15 w=1 nf=1 m=1
M26 net3 net0 VIN VDD pch l=0.15 w=1 nf=1 m=1
M27 net0 VB5 VY VDD pch l=0.15 w=1 nf=1 m=1
M28 net6 VB5 net3 VDD pch l=0.15 w=1 nf=1 m=1
M29 net0 VBN2 net1 VSS nch l=0.15 w=1 nf=1 m=1
M30 net6 VBN2 net10 VSS nch l=0.15 w=1 nf=1 m=1
MD1 net5 net6 VSS VSS nch l=0.15 w=1 nf=1 m=1
MD2 VY VB2 VSS VSS nch l=0.15 w=1 nf=1 m=1
MD3 net2 net5 VY VSS nch l=0.15 w=1 nf=1 m=1
MD4 net7 VB4 VY VSS nch l=0.15 w=1 nf=1 m=1
MD5 net5 net7 VIN VDD pch l=0.15 w=1 nf=1 m=1
MD6 net7 net7 VIN VDD pch l=0.15 w=1 nf=1 m=1
MD7 net2 net2 VIN VDD pch l=0.15 w=1 nf=1 m=1
MPT VOUT net4 VIN VDD pch l=0.15 w=1 nf=1 m=1
RF1 VOUT VFB 1k
RF2 VFB VSS 1k
X1 VDD VSS VIN VBN2 VBN1 bias
.ends dut
