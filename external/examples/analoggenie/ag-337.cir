* official Analog Canvas netlist; PDK X cards rewritten by convert.py
.model nch nmos
.model pch pmos

.subckt dut VDD VSS Vin Vout
C1 VSS net0 1.6pF
C2 Vout VSS 1pF
I1 net2 VSS DC 0.5mA
I2 Vout VSS DC 0.3mA
M1 net1 Vin net2 VSS nch l=0.15 w=1 nf=1 m=1
M2 net0 Vout net2 VSS nch l=0.15 w=1 nf=1 m=1
M3 net1 net1 VDD VDD pch l=0.15 w=1 nf=1 m=1
M4 net0 net1 VDD VDD pch l=0.15 w=1 nf=1 m=1
M5 VDD net0 Vout VSS nch l=0.15 w=1 nf=1 m=1
.ends dut
