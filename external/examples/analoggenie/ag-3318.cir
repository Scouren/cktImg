* official Analog Canvas netlist; PDK X cards rewritten by convert.py
.model nch nmos
.model pch pmos

.subckt dut VDD VSS vci phi1 phi2 vco
C1 net3 net2 1p
C2 net4 vco 1p
M1 vci phi1 net3 VSS nch l=0.15 w=1 nf=1 m=1
M10 net5 net1 VSS VSS nch l=0.15 w=1 nf=1 m=1
M11 net1 net5 VDD VDD pch l=0.15 w=1 nf=1 m=1
M12 net1 net1 VSS VSS nch l=0.15 w=1 nf=1 m=1
M13 VX net1 VSS VSS nch l=0.15 w=1 nf=1 m=1
M14 VX VX VDD VDD pch l=0.15 w=1 nf=1 m=1
M15 VB1 VX VDD VDD pch l=0.15 w=1 nf=1 m=1
M16 VB1 VB1 VSS VSS nch l=0.15 w=1 nf=1 m=1
M2 net3 phi2 VSS VSS nch l=0.15 w=1 nf=1 m=1
M3 net2 phi1 VSS VSS nch l=0.15 w=1 nf=1 m=1
M4 net2 phi2 net4 VSS nch l=0.15 w=1 nf=1 m=1
M5 VX net4 net0 VSS nch l=0.15 w=1 nf=1 m=1
M6 vco VSS net0 VSS nch l=0.15 w=1 nf=1 m=1
M7 net0 VB1 VSS VSS nch l=0.15 w=1 nf=1 m=1
M8 VX VX VDD VDD pch l=0.15 w=1 nf=1 m=1
M9 vco VX VDD VDD pch l=0.15 w=1 nf=1 m=1
R1 VDD net5 1k
R2 VDD net1 1k
.ends dut
