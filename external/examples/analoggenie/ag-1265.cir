* official Analog Canvas netlist; PDK X cards rewritten by convert.py
.model nch nmos
.model pch pmos

.subckt dut VDD VSS VIN VCONT1 VCONT2 VCONT3 VB2 VCONT4 VCONT5 VP VREF VB1
.model DIODE D(IS=1e-14 N=1)
CFLY VX1 VX2 1p
CO VP VN 1p
COP VP VSS 1p
D1 VN VX2 DIODE
L1 VX1 VX3 1n
M1 VIN VCONT2 VX1 VDD pch l=0.15 w=1 nf=1 m=1
M10 net2 net2 VSS VSS nch l=0.15 w=1 nf=1 m=1
M11 net2 VB2 VSS VSS nch l=0.15 w=1 nf=1 m=1
M12 VX net5 VDD VDD pch l=0.15 w=1 nf=1 m=1
M13 net5 net5 VDD VDD pch l=0.15 w=1 nf=1 m=1
M14 VX3 VX3 VDD VDD pch l=0.15 w=1 nf=1 m=1
M15 VCTRL VX3 VDD VDD pch l=0.15 w=1 nf=1 m=1
M16 net5 VFP1 net1 VSS nch l=0.15 w=1 nf=1 m=1
M17 VX3 VREF net1 VSS nch l=0.15 w=1 nf=1 m=1
M18 net1 VBN VSS VSS nch l=0.15 w=1 nf=1 m=1
M19 VX VX VSS VSS nch l=0.15 w=1 nf=1 m=1
M2 VIN VCONT3 VX2 VDD pch l=0.15 w=1 nf=1 m=1
M20 VCTRL VX VSS VSS nch l=0.15 w=1 nf=1 m=1
M21 VB1 VB1 VDD VDD pch l=0.15 w=1 nf=1 m=1
M22 VBN net0 VDD VDD pch l=0.15 w=1 nf=1 m=1
M23 net0 net0 VDD VDD pch l=0.15 w=1 nf=1 m=1
M24 net3 VX VDD VDD pch l=0.15 w=1 nf=1 m=1
M25 VX VX VDD VDD pch l=0.15 w=1 nf=1 m=1
M26 VB1 VBN VSS VSS nch l=0.15 w=1 nf=1 m=1
M27 VBN VBN VSS VSS nch l=0.15 w=1 nf=1 m=1
M28 net0 net3 VSS VSS nch l=0.15 w=1 nf=1 m=1
M29 net3 net3 VSS VSS nch l=0.15 w=1 nf=1 m=1
M3 VP VCONT5 VX3 VDD pch l=0.15 w=1 nf=1 m=1
M30 VX net3 VSS VSS nch l=0.15 w=1 nf=1 m=1
M4 VX3 VCONT4 VSS VSS nch l=0.15 w=1 nf=1 m=1
M5 VIN VCONT1 net6 VDD pch l=0.15 w=1 nf=1 m=1
M6 VX1 net4 net6 VDD pch l=0.15 w=1 nf=1 m=1
M7 net4 net4 net6 VDD pch l=0.15 w=1 nf=1 m=1
M8 net2 VCTRL net6 VDD pch l=0.15 w=1 nf=1 m=1
M9 net4 net2 VSS VSS nch l=0.15 w=1 nf=1 m=1
R1 VP VFP1 1k
R2 VFP1 VSS 1k
RBIAS VDD net3 1k
.ends dut
