* official Analog Canvas netlist; PDK X cards rewritten by convert.py
.model nch nmos

.subckt dut VDD VSS Vcont
ISS net0 VSS DC 1m
M1 X Y net0 VSS nch l=0.15 w=1 nf=1 m=1
M2 Y X net0 VSS nch l=0.15 w=1 nf=1 m=1
Mv1 Vcont X Vcont VSS nch l=0.15 w=1 nf=1 m=1
Mv2 Vcont Y Vcont VSS nch l=0.15 w=1 nf=1 m=1
RS1 VDD X 1k
RS2 VDD Y 1k
.ends dut
