* official Analog Canvas netlist; PDK X cards rewritten by convert.py
.model nch nmos

.subckt dut VDD VSS Vb
C1 net1 net0 1p
C2 net0 VSS 1p
I1 net0 VSS DC 1m
L1 Vb net1 1n
M1 VDD net1 net0 VSS nch l=0.15 w=1 nf=1 m=1
.ends dut
