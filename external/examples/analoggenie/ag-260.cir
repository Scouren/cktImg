* official Analog Canvas netlist; PDK X cards rewritten by convert.py
.model nch nmos

.subckt dut VDD VSS Vout
IN VSS net0 DC 1m
M1 Vout net0 VSS VSS nch l=0.15 w=1 nf=1 m=1
RD VDD Vout 1k
RF1 VSS net0 1k
RF2 VSS Vout 1k
RS net0 VSS 1k
.ends dut
