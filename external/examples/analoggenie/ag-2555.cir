* official Analog Canvas netlist; PDK X cards rewritten by convert.py
.model nch nmos
.model pch pmos

.subckt opamp VDD VSS INP INN VB1 VB2 OUT
M10 net1 INP net4 VDD pch l=0.15 w=1 nf=1 m=1
M11 net1 VBN net10 VSS nch l=0.15 w=1 nf=1 m=1
M12 net10 net1 VSS VSS nch l=0.15 w=1 nf=1 m=1
M13 net3 INN net4 VDD pch l=0.15 w=1 nf=1 m=1
M14 net3 VBN net9 VSS nch l=0.15 w=1 nf=1 m=1
M15 net9 net3 VSS VSS nch l=0.15 w=1 nf=1 m=1
M16 net7 VX VDD VDD pch l=0.15 w=1 nf=1 m=1
M17 OUT VB1 net7 VDD pch l=0.15 w=1 nf=1 m=1
M18 OUT VBN net5 VSS nch l=0.15 w=1 nf=1 m=1
M19 net5 net3 VSS VSS nch l=0.15 w=1 nf=1 m=1
M20 net4 VB2 VDD VDD pch l=0.15 w=1 nf=1 m=1
M21 VBN net2 VDD VDD pch l=0.15 w=1 nf=1 m=1
M22 net2 net2 VDD VDD pch l=0.15 w=1 nf=1 m=1
M23 net8 net2 VDD VDD pch l=0.15 w=1 nf=1 m=1
M24 VBN VBN net0 VSS nch l=0.15 w=1 nf=1 m=1
M25 net0 VBN VSS VSS nch l=0.15 w=1 nf=1 m=1
M26 net2 net8 net12 VSS nch l=0.15 w=1 nf=1 m=1
M27 net8 net8 VSS VSS nch l=0.15 w=1 nf=1 m=1
M6 net11 VX VDD VDD pch l=0.15 w=1 nf=1 m=1
M7 VX VB1 net11 VDD pch l=0.15 w=1 nf=1 m=1
M8 VX VBN net6 VSS nch l=0.15 w=1 nf=1 m=1
M9 net6 net1 VSS VSS nch l=0.15 w=1 nf=1 m=1
R3 net12 VSS 1k
.ends opamp

.subckt dut VDD VSS Vref Vout biasp biascas biasn VB1 VB2
C1 Vset VSS 1p
C2 n3 Vout 1p
M1 Vout n3 VDD VDD pch l=0.15 w=1 nf=1 m=1
M2 n1 Vset Vout VDD pch l=0.15 w=1 nf=1 m=1
M3 n1 biasn VSS VSS nch l=0.15 w=1 nf=1 m=1
M4 n3 biasp VDD VDD pch l=0.15 w=1 nf=1 m=1
M5 n3 biascas n1 VSS nch l=0.15 w=1 nf=1 m=1
R1 fb VSS 1k
R2 Vout fb 1k
X1 VDD VSS Vref fb VB1 VB2 Vset opamp
.ends dut
