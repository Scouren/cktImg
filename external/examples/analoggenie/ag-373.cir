* official Analog Canvas netlist; PDK X cards rewritten by convert.py
.model qnpn npn

.subckt dut VDD VSS Vout1 Vout2
I0 VDD Vout2 DC 1m
I1 VDD Vout1 DC 1m
Q1 Vout1 Vout1 VSS VSS qnpn m=1
Q2 Vout2 Vout2 VSS VSS qnpn m=1
Q3 Vout2 Vout2 VSS VSS qnpn m=1
.ends dut
