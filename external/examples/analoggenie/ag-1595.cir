* official Analog Canvas netlist; PDK X cards rewritten by convert.py
.model nch nmos
.model pch pmos
.model qpnp pnp

.subckt opamp VDD VSS VB1 VB2 INP INN OUT
M1 net2 VB1 VDD VDD pch l=0.15 w=1 nf=1 m=1
M10 OUT VB5 net4 VSS nch l=0.15 w=1 nf=1 m=1
M11 net0 VB6 VSS VSS nch l=0.15 w=1 nf=1 m=1
M12 net4 VB6 VSS VSS nch l=0.15 w=1 nf=1 m=1
M13 VP VP VDD VDD pch l=0.15 w=1 nf=1 m=1
M14 VP VB4 VB3 VSS nch l=0.15 w=1 nf=1 m=1
M15 VB3 VN VSS VSS nch l=0.15 w=1 nf=1 m=1
M16 VB4 VP VDD VDD pch l=0.15 w=1 nf=1 m=1
M17 VB4 VB3 VSS VSS nch l=0.15 w=1 nf=1 m=1
M18 VN VP VDD VDD pch l=0.15 w=1 nf=1 m=1
M19 VN VN VSS VSS nch l=0.15 w=1 nf=1 m=1
M2 net0 INP net2 VDD pch l=0.15 w=1 nf=1 m=1
M20 VB5 VP VDD VDD pch l=0.15 w=1 nf=1 m=1
M21 VB5 VB5 VB6 VSS nch l=0.15 w=1 nf=1 m=1
M22 VB6 VB6 VSS VSS nch l=0.15 w=1 nf=1 m=1
M3 net4 INN net2 VDD pch l=0.15 w=1 nf=1 m=1
M5 net3 VX VDD VDD pch l=0.15 w=1 nf=1 m=1
M6 net1 VX VDD VDD pch l=0.15 w=1 nf=1 m=1
M7 VX VB2 net3 VDD pch l=0.15 w=1 nf=1 m=1
M8 OUT VB2 net1 VDD pch l=0.15 w=1 nf=1 m=1
M9 VX VB5 net0 VSS nch l=0.15 w=1 nf=1 m=1
.ends opamp

.subckt dut VDD VSS Vout VB1 VB2
Q1 VSS VSS X qpnp m=1
Q2 VSS VSS net0 qpnp m=1
R1 Vout X 1k
R2 Vout Y 1k
R3 Y net0 1k
X1 VDD VSS VB1 VB2 X Y Vout opamp
.ends dut
