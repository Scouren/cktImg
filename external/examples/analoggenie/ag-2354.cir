* official Analog Canvas netlist; PDK X cards rewritten by convert.py
.model nch nmos
.model pch pmos

.subckt bias VDD VSS VB1 VB3
M10 net2 net1 VSS VSS nch l=0.15 w=1 nf=1 m=1
M11 net1 net1 VSS VSS nch l=0.15 w=1 nf=1 m=1
M12 net0 net1 VSS VSS nch l=0.15 w=1 nf=1 m=1
M22 net0 net0 VDD VDD pch l=0.15 w=1 nf=1 m=1
M23 VB3 net0 VDD VDD pch l=0.15 w=1 nf=1 m=1
M24 VB3 VB3 VSS VSS nch l=0.15 w=1 nf=1 m=1
M25 VB1 VB3 VSS VSS nch l=0.15 w=1 nf=1 m=1
M26 VB1 VB1 VDD VDD pch l=0.15 w=1 nf=1 m=1
R3 VDD net2 1k
R4 VDD net1 1k
R5 net2 net1 1k
.ends bias

.subckt dut VDD VSS VB1 VREF VB2 IBUF VIN VOUT
CL VOUT net3 1p
M1 net4 net4 VDD VDD pch l=0.15 w=1 nf=1 m=1
M13 net5 VB2 VDD VDD pch l=0.15 w=1 nf=1 m=1
M14 VX EAO net5 VDD pch l=0.15 w=1 nf=1 m=1
M15 VX VX VSS VSS nch l=0.15 w=1 nf=1 m=1
M16 GATE VX VSS VSS nch l=0.15 w=1 nf=1 m=1
M17 VDD net5 GATE VSS nch l=0.15 w=1 nf=1 m=1
M18 net0 EAO IBUF VSS nch l=0.15 w=1 nf=1 m=1
M19 net0 net0 VDD VDD pch l=0.15 w=1 nf=1 m=1
M2 net2 net2 VDD VDD pch l=0.15 w=1 nf=1 m=1
M20 GATE net0 VDD VDD pch l=0.15 w=1 nf=1 m=1
M21 VSS IBUF GATE VDD pch l=0.15 w=1 nf=1 m=1
M3 net4 FB VX VSS nch l=0.15 w=1 nf=1 m=1
M4 net2 VREF VX VSS nch l=0.15 w=1 nf=1 m=1
M5 net1 net4 VDD VDD pch l=0.15 w=1 nf=1 m=1
M6 EAO net2 VDD VDD pch l=0.15 w=1 nf=1 m=1
M7 net1 net1 VSS VSS nch l=0.15 w=1 nf=1 m=1
M8 EAO net1 VSS VSS nch l=0.15 w=1 nf=1 m=1
M9 VX VB3 VSS VSS nch l=0.15 w=1 nf=1 m=1
MNP VIN GATE VOUT VSS nch l=0.15 w=1 nf=1 m=1
R1 FB VSS 1k
R2 VOUT FB 1k
R6 net3 VSS 1k
RL VOUT VSS 1k
X1 VDD VSS VB1 VB3 bias
.ends dut
