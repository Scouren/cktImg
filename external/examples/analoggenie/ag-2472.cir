* official Analog Canvas netlist; PDK X cards rewritten by convert.py
.model nch nmos
.model pch pmos

.subckt dut VDD VSS VIN VOUT VB1 VB2 VREF VB4 VB5
CF1 VOUT VFB 1p
Cm1 VOUT VO1 1p
Cm2 VX VO1 1p
M1 net3 VB1 VIN VDD pch l=0.15 w=1 nf=1 m=1
M10 net1 net7 VSS VSS nch l=0.15 w=1 nf=1 m=1
M11 net2 VBN VSS VSS nch l=0.15 w=1 nf=1 m=1
M12 net3 VFB net2 VSS nch l=0.15 w=1 nf=1 m=1
M13 VF VREF net2 VSS nch l=0.15 w=1 nf=1 m=1
M16 VG VB4 VIN VDD pch l=0.15 w=1 nf=1 m=1
M17 VG VO1 VSS VSS nch l=0.15 w=1 nf=1 m=1
M18 VG VG VSS VSS nch l=0.15 w=1 nf=1 m=1
M2 VF VB1 VIN VDD pch l=0.15 w=1 nf=1 m=1
M21 net4 VO1 VSS VSS nch l=0.15 w=1 nf=1 m=1
M22 net10 VG VSS VSS nch l=0.15 w=1 nf=1 m=1
M23 net4 net4 VIN VDD pch l=0.15 w=1 nf=1 m=1
M24 net10 net4 VIN VDD pch l=0.15 w=1 nf=1 m=1
M25 net0 net0 net9 VDD pch l=0.15 w=1 nf=1 m=1
M26 VBC net0 VIN VDD pch l=0.15 w=1 nf=1 m=1
M27 VBC VBC VBN VSS nch l=0.15 w=1 nf=1 m=1
M28 VBN VBN VSS VSS nch l=0.15 w=1 nf=1 m=1
M5 VO1 VB2 net3 VDD pch l=0.15 w=1 nf=1 m=1
M6 net7 VB2 VF VDD pch l=0.15 w=1 nf=1 m=1
M7 VO1 VBC net5 VSS nch l=0.15 w=1 nf=1 m=1
M8 net7 VBC net1 VSS nch l=0.15 w=1 nf=1 m=1
M9 net5 net7 VSS VSS nch l=0.15 w=1 nf=1 m=1
MD1 VX VO1 VSS VSS nch l=0.15 w=1 nf=1 m=1
MD2 net6 VB5 VSS VSS nch l=0.15 w=1 nf=1 m=1
MD3 VF VX net6 VSS nch l=0.15 w=1 nf=1 m=1
MD4 net8 VB3 net6 VSS nch l=0.15 w=1 nf=1 m=1
MD5 VX net8 VIN VDD pch l=0.15 w=1 nf=1 m=1
MD6 VF VF VIN VDD pch l=0.15 w=1 nf=1 m=1
MD7 net8 net8 VIN VDD pch l=0.15 w=1 nf=1 m=1
MPT VOUT net10 VIN VDD pch l=0.15 w=1 nf=1 m=1
R1 VIN net9 1k
R2 net0 VSS 1k
RF1 VOUT VFB 1k
RF2 VFB VSS 1k
.ends dut
