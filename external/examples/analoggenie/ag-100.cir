* official Analog Canvas netlist; PDK X cards rewritten by convert.py
.model nch nmos

.subckt dut VDD VSS IOUT1
M1 IOUT1 net0 VSS VSS nch l=0.15 w=1 nf=1 m=1
R1 VDD net0 1k
R2 net0 VSS 1k
.ends dut
