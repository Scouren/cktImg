* official Analog Canvas netlist; PDK X cards rewritten by convert.py
.model nch nmos
.model pch pmos

.subckt dut VDD VSS Vin Vout phi2 phi1a phi1
C1 net1 net0 1pF
CL Vout VSS 1pF
M1 Vout phi1a net0 VSS nch l=0.15 w=1 nf=1 m=1
M2 net1 phi1 VSS VSS nch l=0.15 w=1 nf=1 m=1
M3 net1 phi2 Vin VSS nch l=0.15 w=1 nf=1 m=1
M4 Vout net0 VSS VSS nch l=0.15 w=1 nf=1 m=1
M5 Vout net0 VDD VDD pch l=0.15 w=1 nf=1 m=1
.ends dut
