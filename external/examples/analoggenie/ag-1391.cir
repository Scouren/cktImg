* official Analog Canvas netlist; PDK X cards rewritten by convert.py
.model nch nmos
.model pch pmos

.subckt comparator VDD VSS VB1 VB2 IN OUT
M1 net3 VX VDD VDD pch l=0.15 w=1 nf=1 m=1
M10 net0 VB5 VSS VSS nch l=0.15 w=1 nf=1 m=1
M11 net5 VB5 VSS VSS nch l=0.15 w=1 nf=1 m=1
M12 VB4 net2 VDD VDD pch l=0.15 w=1 nf=1 m=1
M13 net2 net2 VDD VDD pch l=0.15 w=1 nf=1 m=1
M14 VB3 net2 VDD VDD pch l=0.15 w=1 nf=1 m=1
M15 VB4 VB4 VB5 VSS nch l=0.15 w=1 nf=1 m=1
M16 net2 VB3 VSS VSS nch l=0.15 w=1 nf=1 m=1
M17 VB5 VB5 VSS VSS nch l=0.15 w=1 nf=1 m=1
M18 net1 VB3 VSS VSS nch l=0.15 w=1 nf=1 m=1
M2 net4 VB1 VDD VDD pch l=0.15 w=1 nf=1 m=1
M3 net6 VX VDD VDD pch l=0.15 w=1 nf=1 m=1
M4 VX VB2 net3 VDD pch l=0.15 w=1 nf=1 m=1
M5 net0 OUT net4 VDD pch l=0.15 w=1 nf=1 m=1
M6 net5 IN net4 VDD pch l=0.15 w=1 nf=1 m=1
M7 OUT VB2 net6 VDD pch l=0.15 w=1 nf=1 m=1
M8 VX VB4 net0 VSS nch l=0.15 w=1 nf=1 m=1
M9 OUT VB4 net5 VSS nch l=0.15 w=1 nf=1 m=1
R1 VB3 net1 1k
.ends comparator

.subckt dut VDD VSS VSTO VCONT1 VCONT2 VCONT3 VOUT VB1 VB2
CL VOUT VSS 1p
CSTO VSTO VSS 1p
LRX net1 net2 1n
MN1 net1 VCONT2 VSS VSS nch l=0.15 w=1 nf=1 m=1
MN2 net2 VCONT3 VSS VSS nch l=0.15 w=1 nf=1 m=1
MP2 net2 net0 VOUT VDD pch l=0.15 w=1 nf=1 m=1
MP3 net1 VCONT1 VSTO VDD pch l=0.15 w=1 nf=1 m=1
X1 VDD VSS VB1 VB2 net2 net0 comparator
.ends dut
