* official Analog Canvas netlist; PDK X cards rewritten by convert.py
.model nch nmos
.model pch pmos

.subckt CMFB Voutp Voutn Vcntrl
.ends CMFB

.subckt dut VDD VSS Vin- Vin+ VB1 VB2 VB3 Vout+ Vout-
Ibias net1 VSS DC 1m
M1 net0 Vin- net1 VSS nch l=0.15 w=1 nf=1 m=1
M10 Vout- VB3 net3 VSS nch l=0.15 w=1 nf=1 m=1
M11 VB1 VB1 net0 VSS nch l=0.15 w=1 nf=1 m=1
M12 VB1 VB1 net2 VSS nch l=0.15 w=1 nf=1 m=1
M2 net2 Vin+ net1 VSS nch l=0.15 w=1 nf=1 m=1
M3 net0 VB1 VDD VDD pch l=0.15 w=1 nf=1 m=1
M4 net2 VB1 VDD VDD pch l=0.15 w=1 nf=1 m=1
M5 Vout+ VB2 net2 VDD pch l=0.15 w=1 nf=1 m=1
M6 Vout- VB2 net0 VDD pch l=0.15 w=1 nf=1 m=1
M7 net4 Vcntrl VSS VSS nch l=0.15 w=1 nf=1 m=1
M8 Vout+ VB3 net4 VSS nch l=0.15 w=1 nf=1 m=1
M9 net3 Vcntrl VSS VSS nch l=0.15 w=1 nf=1 m=1
X1 Vout+ Vout- Vcntrl CMFB
.ends dut
