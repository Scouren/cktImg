* official Analog Canvas netlist; PDK X cards rewritten by convert.py
.model nch nmos

.subckt dut VDD VSS Vcont
.model DIODE D(IS=1e-14 N=1)
D1 Vcont X DIODE
D2 Vcont Y DIODE
I1 net0 VSS DC 1m
L1 VDD X 1n
L2 VDD Y 1n
M1 X Y net0 VSS nch l=0.15 w=1 nf=1 m=1
M2 Y X net0 VSS nch l=0.15 w=1 nf=1 m=1
.ends dut
