* official Analog Canvas netlist; PDK X cards rewritten by convert.py
.model nch nmos
.model pch pmos
.model qpnp pnp

.subckt A1 VDD VSS VB1 VB3 VB2 INP INN OUT
M1 VT VB1 VDD VDD pch l=0.15 w=1 nf=1 m=1
M10 net5 VB2 VSS VSS nch l=0.15 w=1 nf=1 m=1
M11 net6 VB2 VSS VSS nch l=0.15 w=1 nf=1 m=1
M12 VBN net7 VDD VDD pch l=0.15 w=1 nf=1 m=1
M13 VBN VBN net0 VSS nch l=0.15 w=1 nf=1 m=1
M14 net0 VBN VSS VSS nch l=0.15 w=1 nf=1 m=1
M15 net7 net7 VDD VDD pch l=0.15 w=1 nf=1 m=1
M16 VT net7 VDD VDD pch l=0.15 w=1 nf=1 m=1
M17 net7 VT net2 VSS nch l=0.15 w=1 nf=1 m=1
M18 VT net2 VSS VSS nch l=0.15 w=1 nf=1 m=1
M2 net5 INP VT VDD pch l=0.15 w=1 nf=1 m=1
M3 net6 INN VT VDD pch l=0.15 w=1 nf=1 m=1
M4 net4 net3 VDD VDD pch l=0.15 w=1 nf=1 m=1
M5 net1 net3 VDD VDD pch l=0.15 w=1 nf=1 m=1
M6 net3 VB3 net4 VDD pch l=0.15 w=1 nf=1 m=1
M7 OUT VB3 net1 VDD pch l=0.15 w=1 nf=1 m=1
M8 net3 VBN net5 VSS nch l=0.15 w=1 nf=1 m=1
M9 OUT VBN net6 VSS nch l=0.15 w=1 nf=1 m=1
R4 net2 VSS 1k
.ends A1

.subckt dut VDD VSS Vout VB1 VB2 VB3
Q1 VSS VSS X qpnp m=1
Q2 VSS VSS net0 qpnp m=1
R1 Vout X 1k
R2 Vout Y 1k
R3 Y net0 1k
X1 VDD VSS VB1 VB3 VB2 X Y Vout A1
.ends dut
