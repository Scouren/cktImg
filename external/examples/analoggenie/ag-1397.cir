* official Analog Canvas netlist; PDK X cards rewritten by convert.py
.model nch nmos
.model pch pmos

.subckt comparator VDD VSS VB1 INN VB2 OUT
M0 net1 VB1 VDD VDD pch l=0.15 w=1 nf=1 m=1
M1 net5 VX VDD VDD pch l=0.15 w=1 nf=1 m=1
M10 net2 VB6 VSS VSS nch l=0.15 w=1 nf=1 m=1
M13 VB6 VB6 VSS VSS nch l=0.15 w=1 nf=1 m=1
M14 VB5 VB4 VDD VDD pch l=0.15 w=1 nf=1 m=1
M15 VB5 VB5 VB6 VSS nch l=0.15 w=1 nf=1 m=1
M16 net7 VB4 VDD VDD pch l=0.15 w=1 nf=1 m=1
M17 VB4 VB4 VDD VDD pch l=0.15 w=1 nf=1 m=1
M18 VB3 VB4 VDD VDD pch l=0.15 w=1 nf=1 m=1
M19 VB4 VB3 net3 VSS nch l=0.15 w=1 nf=1 m=1
M2 net0 VX VDD VDD pch l=0.15 w=1 nf=1 m=1
M20 VB3 VB3 VSS VSS nch l=0.15 w=1 nf=1 m=1
M21 net7 net7 VSS VSS nch l=0.15 w=1 nf=1 m=1
M22 net3 net7 VSS VSS nch l=0.15 w=1 nf=1 m=1
M3 net2 OUT net1 net6 pch l=0.15 w=1 nf=1 m=1
M4 net4 INN net1 net6 pch l=0.15 w=1 nf=1 m=1
M5 OUT VB2 net5 VDD pch l=0.15 w=1 nf=1 m=1
M6 VX VB2 net0 VDD pch l=0.15 w=1 nf=1 m=1
M7 OUT VB5 net4 VSS nch l=0.15 w=1 nf=1 m=1
M8 VX VB5 net2 VSS nch l=0.15 w=1 nf=1 m=1
M9 net4 VB6 VSS VSS nch l=0.15 w=1 nf=1 m=1
.ends comparator

.subckt dut VDD VSS VSTO VOUT VCONT1 VCONT2 VCONT3 VB1 VB2
CL VOUT VSS 1p
CSTO VSTO VSS 1p
LRX net1 net0 1n
MN1 net1 VCONT2 VSS VSS nch l=0.15 w=1 nf=1 m=1
MN2 net0 VCONT3 VSS VSS nch l=0.15 w=1 nf=1 m=1
MP2 net0 net2 VOUT VOUT pch l=0.15 w=1 nf=1 m=1
MP3 net1 VCONT1 VSTO VSTO pch l=0.15 w=1 nf=1 m=1
X1 VDD VSS VB1 net0 VB2 net2 comparator
.ends dut
