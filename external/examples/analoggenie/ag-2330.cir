* official Analog Canvas netlist; PDK X cards rewritten by convert.py
.model nch nmos
.model pch pmos

.subckt dut VDD VSS VREF VB2 IBUF VIN VOUT
CL VOUT net7 1p
M1 net2 net2 VSS VSS nch l=0.15 w=1 nf=1 m=1
M10 EAO net6 VDD VDD pch l=0.15 w=1 nf=1 m=1
M11 net5 net3 VDD VDD pch l=0.15 w=1 nf=1 m=1
M12 net3 net3 VDD VDD pch l=0.15 w=1 nf=1 m=1
M13 net4 VB2 VDD VDD pch l=0.15 w=1 nf=1 m=1
M14 VX EAO net4 VDD pch l=0.15 w=1 nf=1 m=1
M15 VX VX VSS VSS nch l=0.15 w=1 nf=1 m=1
M16 GATE VX VSS VSS nch l=0.15 w=1 nf=1 m=1
M17 VDD net4 GATE VSS nch l=0.15 w=1 nf=1 m=1
M18 net1 EAO IBUF VSS nch l=0.15 w=1 nf=1 m=1
M19 net1 net1 VDD VDD pch l=0.15 w=1 nf=1 m=1
M2 VX net2 VSS VSS nch l=0.15 w=1 nf=1 m=1
M20 GATE net1 VDD VDD pch l=0.15 w=1 nf=1 m=1
M21 VSS IBUF GATE VDD pch l=0.15 w=1 nf=1 m=1
M22 net0 net0 VDD VDD pch l=0.15 w=1 nf=1 m=1
M23 VB1 net0 VDD VDD pch l=0.15 w=1 nf=1 m=1
M24 net2 net0 VDD VDD pch l=0.15 w=1 nf=1 m=1
M25 net0 VB1 net8 VSS nch l=0.15 w=1 nf=1 m=1
M26 VB1 VB1 VSS VSS nch l=0.15 w=1 nf=1 m=1
M3 net6 VREF VX VSS nch l=0.15 w=1 nf=1 m=1
M4 net3 FB VX VSS nch l=0.15 w=1 nf=1 m=1
M5 net5 net5 VSS VSS nch l=0.15 w=1 nf=1 m=1
M6 EAO net5 VSS VSS nch l=0.15 w=1 nf=1 m=1
M9 net6 net6 VDD VDD pch l=0.15 w=1 nf=1 m=1
MNP VIN GATE VOUT VSS nch l=0.15 w=1 nf=1 m=1
R1 FB VSS 1k
R2 VOUT FB 1k
R3 net8 VSS 1k
R4 net7 VSS 1k
RL VOUT VSS 1k
.ends dut
