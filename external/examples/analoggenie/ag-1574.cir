* official Analog Canvas netlist; PDK X cards rewritten by convert.py
.model nch nmos
.model pch pmos
.model qpnp pnp

.subckt A1 VDD VSS INN INP OUT VB1 VB2
M1 net6 INN net5 VSS nch l=0.15 w=1 nf=1 m=1
M10 net7 net4 VSS VSS nch l=0.15 w=1 nf=1 m=1
M11 net5 VB5 VSS VSS nch l=0.15 w=1 nf=1 m=1
M12 VB4 net0 VDD VDD pch l=0.15 w=1 nf=1 m=1
M13 net0 net0 VDD VDD pch l=0.15 w=1 nf=1 m=1
M14 VB3 net0 VDD VDD pch l=0.15 w=1 nf=1 m=1
M15 VB4 VB4 VB5 VSS nch l=0.15 w=1 nf=1 m=1
M16 VB5 VB5 VSS VSS nch l=0.15 w=1 nf=1 m=1
M17 net0 VB3 net3 VSS nch l=0.15 w=1 nf=1 m=1
M18 VB3 VB3 VSS VSS nch l=0.15 w=1 nf=1 m=1
M2 net1 INP net5 VSS nch l=0.15 w=1 nf=1 m=1
M3 net6 VB1 VDD VDD pch l=0.15 w=1 nf=1 m=1
M4 net1 VB1 VDD VDD pch l=0.15 w=1 nf=1 m=1
M5 net4 VB2 net6 VDD pch l=0.15 w=1 nf=1 m=1
M6 OUT VB2 net1 VDD pch l=0.15 w=1 nf=1 m=1
M7 net4 VB4 net2 VSS nch l=0.15 w=1 nf=1 m=1
M8 OUT VB4 net7 VSS nch l=0.15 w=1 nf=1 m=1
M9 net2 net4 VSS VSS nch l=0.15 w=1 nf=1 m=1
R1 net3 VSS 1k
.ends A1

.subckt dut VDD VSS Vout VB1 VB2
Q1 VSS VSS X qpnp m=1
Q2 VSS VSS net0 qpnp m=1
R1 Vout X 1k
R2 Vout Y 1k
R3 Y net0 1k
X1 VDD VSS Y X Vout VB1 VB2 A1
.ends dut
