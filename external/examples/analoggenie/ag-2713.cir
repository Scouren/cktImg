* official Analog Canvas netlist; PDK X cards rewritten by convert.py
.model nch nmos
.model pch pmos

.subckt opamp VDD VSS INN INP OUT vcx
M10 net0 net0 VSS VSS nch l=0.15 w=1 nf=1 m=1
M11 OUT net0 VSS VSS nch l=0.15 w=1 nf=1 m=1
M12 net2 net2 net4 VSS nch l=0.15 w=1 nf=1 m=1
M13 net1 net2 VSS VSS nch l=0.15 w=1 nf=1 m=1
M14 net1 net1 VDD VDD pch l=0.15 w=1 nf=1 m=1
M15 VB2 net1 VDD VDD pch l=0.15 w=1 nf=1 m=1
M16 VB2 VB2 VSS VSS nch l=0.15 w=1 nf=1 m=1
M17 VB1 VB1 VDD VDD pch l=0.15 w=1 nf=1 m=1
M18 VB1 VB2 VSS VSS nch l=0.15 w=1 nf=1 m=1
M3 vcx INN net5 VSS nch l=0.15 w=1 nf=1 m=1
M4 net3 INP net5 VSS nch l=0.15 w=1 nf=1 m=1
M5 net5 VB2 VSS VSS nch l=0.15 w=1 nf=1 m=1
M6 vcx vcx VDD VDD pch l=0.15 w=1 nf=1 m=1
M7 net3 net3 VDD VDD pch l=0.15 w=1 nf=1 m=1
M8 net0 vcx VDD VDD pch l=0.15 w=1 nf=1 m=1
M9 OUT net3 VDD VDD pch l=0.15 w=1 nf=1 m=1
R1 VDD net2 1k
R2 net4 VSS 1k
.ends opamp

.subckt dut VDD VSS vci phi1 phi2 vco
C1 vcx VSS 1p
C2 net0 vco 1p
M1 vci phi1 vcx VSS nch l=0.15 w=1 nf=1 m=1
M2 vcx phi2 net0 VSS nch l=0.15 w=1 nf=1 m=1
X1 VDD VSS net0 VSS vco vcx opamp
.ends dut
