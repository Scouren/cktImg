* official Analog Canvas netlist; PDK X cards rewritten by convert.py
.model nch nmos
.model pch pmos

.subckt comparator VDD VSS OUT VB1 VB2 INP INN
M1 net4 net8 VDD VDD pch l=0.15 w=1 nf=1 m=1
M10 net6 VB3 net3 VSS nch l=0.15 w=1 nf=1 m=1
M11 net3 net6 VSS VSS nch l=0.15 w=1 nf=1 m=1
M12 net0 INN net7 VDD pch l=0.15 w=1 nf=1 m=1
M13 net0 VB3 net5 VSS nch l=0.15 w=1 nf=1 m=1
M14 net5 net0 VSS VSS nch l=0.15 w=1 nf=1 m=1
M15 net7 VB2 VDD VDD pch l=0.15 w=1 nf=1 m=1
M16 net1 net1 VDD VDD pch l=0.15 w=1 nf=1 m=1
M17 VB3 net1 VDD VDD pch l=0.15 w=1 nf=1 m=1
M18 VB3 VB3 net11 VSS nch l=0.15 w=1 nf=1 m=1
M19 net11 VB3 VSS VSS nch l=0.15 w=1 nf=1 m=1
M2 OUT VB1 net4 VDD pch l=0.15 w=1 nf=1 m=1
M3 OUT VB3 net9 VSS nch l=0.15 w=1 nf=1 m=1
M4 net9 net0 VSS VSS nch l=0.15 w=1 nf=1 m=1
M5 net2 net8 VDD VDD pch l=0.15 w=1 nf=1 m=1
M6 net8 VB1 net2 VDD pch l=0.15 w=1 nf=1 m=1
M7 net8 VB3 net10 VSS nch l=0.15 w=1 nf=1 m=1
M8 net10 net6 VSS VSS nch l=0.15 w=1 nf=1 m=1
M9 net6 INP net7 VDD pch l=0.15 w=1 nf=1 m=1
R1 net1 VSS 1k
.ends comparator

.subckt dut VDD VSS VSTO VCONT1 VCONT2 VCONT3 VOUT
CL VOUT VSS 1p
CSTO VSTO VSS 1p
LRX net2 net1 1n
MN1 net2 VCONT2 VSS VSS nch l=0.15 w=1 nf=1 m=1
MN2 net1 VCONT3 VSS VSS nch l=0.15 w=1 nf=1 m=1
MP2 net1 net0 VOUT VDD pch l=0.15 w=1 nf=1 m=1
MP3 net2 VCONT1 VSTO VDD pch l=0.15 w=1 nf=1 m=1
X1 VDD VSS net0 VB1 VB2 net0 net1 comparator
.ends dut
