* official Analog Canvas netlist; PDK X cards rewritten by convert.py
.model nch nmos
.model pch pmos

.subckt dut VDD VSS VB1 Vref VB2 biasp biascas Vout biasn
C1 Vset VSS 1p
C2 n3 Vout 1p
M1 Vout n3 VDD VDD pch l=0.15 w=1 nf=1 m=1
M10 net4 net0 VDD VDD pch l=0.15 w=1 nf=1 m=1
M11 net0 VB2 net5 VDD pch l=0.15 w=1 nf=1 m=1
M12 Vset VB2 net4 VDD pch l=0.15 w=1 nf=1 m=1
M13 net0 VCN net6 VSS nch l=0.15 w=1 nf=1 m=1
M14 Vset VCN net2 VSS nch l=0.15 w=1 nf=1 m=1
M15 net6 VBN VSS VSS nch l=0.15 w=1 nf=1 m=1
M16 net2 VBN VSS VSS nch l=0.15 w=1 nf=1 m=1
M17 VB3 net3 VDD VDD pch l=0.15 w=1 nf=1 m=1
M18 net3 net3 VDD VDD pch l=0.15 w=1 nf=1 m=1
M19 VCN net3 VDD VDD pch l=0.15 w=1 nf=1 m=1
M2 n1 Vset Vout VDD pch l=0.15 w=1 nf=1 m=1
M20 VB3 VB3 VSS VSS nch l=0.15 w=1 nf=1 m=1
M21 net3 VB3 net1 VSS nch l=0.15 w=1 nf=1 m=1
M22 VCN VCN VBN VSS nch l=0.15 w=1 nf=1 m=1
M23 VBN VBN VSS VSS nch l=0.15 w=1 nf=1 m=1
M3 n1 biasn VSS VSS nch l=0.15 w=1 nf=1 m=1
M4 n3 biasp VDD VDD pch l=0.15 w=1 nf=1 m=1
M5 n3 biascas n1 VSS nch l=0.15 w=1 nf=1 m=1
M6 n3 VB1 VDD VDD pch l=0.15 w=1 nf=1 m=1
M7 net2 fb n3 VDD pch l=0.15 w=1 nf=1 m=1
M8 net6 Vref n3 VDD pch l=0.15 w=1 nf=1 m=1
M9 net5 net0 VDD VDD pch l=0.15 w=1 nf=1 m=1
R1 fb VSS 1k
R2 Vout fb 1k
R3 net1 VSS 1k
.ends dut
