* official Analog Canvas netlist; PDK X cards rewritten by convert.py
.model nch nmos
.model pch pmos

.subckt opamp VDD VSS INN INP OUT
M10 net1 VB3 net2 VDD pch l=0.15 w=1 nf=1 m=1
M11 OUT VB3 net5 VDD pch l=0.15 w=1 nf=1 m=1
M12 net0 net3 VDD VDD pch l=0.15 w=1 nf=1 m=1
M13 net3 net3 net0 VDD pch l=0.15 w=1 nf=1 m=1
M14 net0 net0 VSS VSS nch l=0.15 w=1 nf=1 m=1
M15 VB1 net0 VSS VSS nch l=0.15 w=1 nf=1 m=1
M16 VB1 VB1 VDD VDD pch l=0.15 w=1 nf=1 m=1
M17 VB2 VB1 VDD VDD pch l=0.15 w=1 nf=1 m=1
M18 VB2 VB2 VSS VSS nch l=0.15 w=1 nf=1 m=1
M5 net1 INN net4 VSS nch l=0.15 w=1 nf=1 m=1
M6 OUT INP net4 VSS nch l=0.15 w=1 nf=1 m=1
M7 net4 VB2 VSS VSS nch l=0.15 w=1 nf=1 m=1
M8 net2 net1 VDD VDD pch l=0.15 w=1 nf=1 m=1
M9 net5 net1 VDD VDD pch l=0.15 w=1 nf=1 m=1
R1 VDD net0 1k
R2 net3 VSS 1k
.ends opamp

.subckt dut VDD VSS vci phi1 phi2 vco
C1 net2 net0 1p
C2 net1 vco 1p
M1 vci phi1 net2 VSS nch l=0.15 w=1 nf=1 m=1
M2 net2 phi2 VSS VSS nch l=0.15 w=1 nf=1 m=1
M3 net0 phi1 VSS VSS nch l=0.15 w=1 nf=1 m=1
M4 net0 phi2 net1 VSS nch l=0.15 w=1 nf=1 m=1
X1 VDD VSS net1 VSS vco opamp
.ends dut
