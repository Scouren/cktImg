* official Analog Canvas netlist; PDK X cards rewritten by convert.py
.model nch nmos
.model pch pmos

.subckt dut VDD VSS vci phi1 phi2 vco
C1 net5 net8 1p
C2 net3 vco 1p
M1 vci phi1 net5 VSS nch l=0.15 w=1 nf=1 m=1
M10 net2 VB3 net4 VDD pch l=0.15 w=1 nf=1 m=1
M11 vco VB3 net6 VDD pch l=0.15 w=1 nf=1 m=1
M12 net7 net1 VSS VSS nch l=0.15 w=1 nf=1 m=1
M13 net1 net1 VSS VSS nch l=0.15 w=1 nf=1 m=1
M14 VB1 net1 VSS VSS nch l=0.15 w=1 nf=1 m=1
M15 VB1 VB1 VDD VDD pch l=0.15 w=1 nf=1 m=1
M16 VB2 VB1 VDD VDD pch l=0.15 w=1 nf=1 m=1
M17 VB2 VB2 VSS VSS nch l=0.15 w=1 nf=1 m=1
M2 net5 phi2 VSS VSS nch l=0.15 w=1 nf=1 m=1
M3 net8 phi1 VSS VSS nch l=0.15 w=1 nf=1 m=1
M4 net8 phi2 net3 VSS nch l=0.15 w=1 nf=1 m=1
M5 net2 net3 net0 VSS nch l=0.15 w=1 nf=1 m=1
M6 vco VSS net0 VSS nch l=0.15 w=1 nf=1 m=1
M7 net0 VB2 VSS VSS nch l=0.15 w=1 nf=1 m=1
M8 net4 net2 VDD VDD pch l=0.15 w=1 nf=1 m=1
M9 net6 net2 VDD VDD pch l=0.15 w=1 nf=1 m=1
R1 VDD net7 1k
R2 VDD net1 1k
R3 net7 net1 1k
.ends dut
