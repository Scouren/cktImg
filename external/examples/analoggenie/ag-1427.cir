* official Analog Canvas netlist; PDK X cards rewritten by convert.py
.model nch nmos
.model pch pmos

.subckt comp VDD VSS INN OUT VB1
M1 VX VX VDD VDD pch l=0.15 w=1 nf=1 m=1
M10 net1 net1 net2 VSS nch l=0.15 w=1 nf=1 m=1
M11 VB1 net1 VSS VSS nch l=0.15 w=1 nf=1 m=1
M12 VB1 VB1 VDD VDD pch l=0.15 w=1 nf=1 m=1
M13 VB2 VB1 VDD VDD pch l=0.15 w=1 nf=1 m=1
M14 VB2 VB2 VSS VSS nch l=0.15 w=1 nf=1 m=1
M2 VX INN net3 VSS nch l=0.15 w=1 nf=1 m=1
M3 OUT OUT VDD VDD pch l=0.15 w=1 nf=1 m=1
M4 OUT OUT net3 VSS nch l=0.15 w=1 nf=1 m=1
M5 OUT OUT VDD VDD pch l=0.15 w=1 nf=1 m=1
M6 OUT net0 VSS VSS nch l=0.15 w=1 nf=1 m=1
M7 net0 VX VDD VDD pch l=0.15 w=1 nf=1 m=1
M8 net0 net0 VSS VSS nch l=0.15 w=1 nf=1 m=1
M9 net3 VB2 VSS VSS nch l=0.15 w=1 nf=1 m=1
R1 VDD net1 1k
R2 net2 VSS 1k
.ends comp

.subckt dut VDD VSS VSTO VCONT1 VCONT2 VCONT3 VOUT VB1
CL VOUT VSS 1p
CSTO VSTO VSS 1p
LRX net1 net0 1n
MN1 net1 VCONT2 VSS VSS nch l=0.15 w=1 nf=1 m=1
MN2 net0 VCONT3 VSS VSS nch l=0.15 w=1 nf=1 m=1
MP2 net0 net2 VOUT VDD pch l=0.15 w=1 nf=1 m=1
MP3 net1 VCONT1 VSTO VDD pch l=0.15 w=1 nf=1 m=1
X1 VDD VSS net0 net2 VB1 comp
.ends dut
