* official Analog Canvas netlist; PDK X cards rewritten by convert.py
.model nch nmos

.subckt dut VDD VSS VLO VLO_bar X Y
C1 net0 P 1p
Ibeat net0 VSS DC 1m
ISS P VSS DC 1m
L1 VDD net0 1n
M2 X VLO P VSS nch l=0.15 w=1 nf=1 m=1
M3 Y VLO_bar P VSS nch l=0.15 w=1 nf=1 m=1
RD1 VDD X 1k
RD2 VDD Y 1k
.ends dut
