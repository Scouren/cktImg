* official Analog Canvas netlist; PDK X cards rewritten by convert.py
.model nch nmos
.model pch pmos

.subckt opamp VDD VSS IN- IN+ OUT
M1 net2 VB1 VDD VDD pch l=0.15 w=1 nf=1 m=1
M10 net0 IN+ OUT VSS nch l=0.15 w=1 nf=1 m=1
M11 OUT VB5 VSS VSS nch l=0.15 w=1 nf=1 m=1
M12 VB4 net1 VDD VDD pch l=0.15 w=1 nf=1 m=1
M13 VB4 VB4 VB5 VSS nch l=0.15 w=1 nf=1 m=1
M14 VB5 VB5 VSS VSS nch l=0.15 w=1 nf=1 m=1
M15 net1 net1 VDD VDD pch l=0.15 w=1 nf=1 m=1
M16 net1 VX VB3 VSS nch l=0.15 w=1 nf=1 m=1
M17 VX net1 VDD VDD pch l=0.15 w=1 nf=1 m=1
M18 VX VB3 VSS VSS nch l=0.15 w=1 nf=1 m=1
M2 net0 VB1 VDD VDD pch l=0.15 w=1 nf=1 m=1
M3 VX VB2 net2 VDD pch l=0.15 w=1 nf=1 m=1
M4 OUT VB2 net0 VDD pch l=0.15 w=1 nf=1 m=1
M5 VX VB4 net3 VSS nch l=0.15 w=1 nf=1 m=1
M6 OUT VB4 net4 VSS nch l=0.15 w=1 nf=1 m=1
M7 net3 VX VSS VSS nch l=0.15 w=1 nf=1 m=1
M8 net4 VX VSS VSS nch l=0.15 w=1 nf=1 m=1
M9 net2 IN- OUT VSS nch l=0.15 w=1 nf=1 m=1
R1 VB3 VSS 1k
.ends opamp

.subckt dut VDD VSS Vref VIN VOUT
CL VOUT net1 1p
MNP VIN net0 VOUT VSS nch l=0.15 w=1 nf=1 m=1
R1 VOUT FB 1k
R2 FB VSS 1k
R3 net1 VSS 1k
X1 VDD VSS FB Vref net0 opamp
.ends dut
