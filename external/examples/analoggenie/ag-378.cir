* official Analog Canvas netlist; PDK X cards rewritten by convert.py
.model nch nmos
.model pch pmos
.model qpnp pnp

.subckt dut VDD VSS
ISS net2 VSS DC 1m
M3 X net0 VDD VDD pch l=0.15 w=1 nf=1 m=1
M4 Y net0 VDD VDD pch l=0.15 w=1 nf=1 m=1
Ma net0 X net2 VSS nch l=0.15 w=1 nf=1 m=1
Mb P Y net2 VSS nch l=0.15 w=1 nf=1 m=1
Mc net0 P VDD VDD pch l=0.15 w=1 nf=1 m=1
Md P P VDD VDD pch l=0.15 w=1 nf=1 m=1
Q1 VSS VSS X qpnp m=1
Q2 VSS VSS net1 qpnp m=1
R1 Y net1 1k
R2 Y VSS 1k
R3 X VSS 1k
.ends dut
