* official Analog Canvas netlist; PDK X cards rewritten by convert.py
.model nch nmos
.model pch pmos

.subckt opamp VDD VSS VB1 Vp Vn VB2 Vo VB3
M1 VT VB1 VDD VDD pch l=0.15 w=1 nf=1 m=1
M10 net4 VBN2 VSS VSS nch l=0.15 w=1 nf=1 m=1
M11 net1 VBN2 VSS VSS nch l=0.15 w=1 nf=1 m=1
M12 VBN1 net0 VDD VDD pch l=0.15 w=1 nf=1 m=1
M13 VBN1 VBN1 VBN2 VSS nch l=0.15 w=1 nf=1 m=1
M14 VBN2 VBN2 VSS VSS nch l=0.15 w=1 nf=1 m=1
M15 net0 net0 VDD VDD pch l=0.15 w=1 nf=1 m=1
M16 VT net0 VDD VDD pch l=0.15 w=1 nf=1 m=1
M17 net0 VT VB3 VSS nch l=0.15 w=1 nf=1 m=1
M18 VT VB3 VSS VSS nch l=0.15 w=1 nf=1 m=1
M2 net4 Vp VT VDD pch l=0.15 w=1 nf=1 m=1
M3 net1 Vn VT VDD pch l=0.15 w=1 nf=1 m=1
M4 net3 VX VDD VDD pch l=0.15 w=1 nf=1 m=1
M5 net2 VX VDD VDD pch l=0.15 w=1 nf=1 m=1
M6 VX VB2 net3 VDD pch l=0.15 w=1 nf=1 m=1
M7 Vo VB2 net2 VDD pch l=0.15 w=1 nf=1 m=1
M8 VX VBN1 net4 VSS nch l=0.15 w=1 nf=1 m=1
M9 Vo VBN1 net1 VSS nch l=0.15 w=1 nf=1 m=1
RB VB3 VSS 1k
.ends opamp

.subckt dut VDD VSS Vref VIN VOUT VB1 VB2 VB3
CL VOUT net1 1p
MNP VIN net0 VOUT VSS nch l=0.15 w=1 nf=1 m=1
R1 VOUT FB 1k
R2 FB VSS 1k
R3 net1 VSS 1k
X1 VDD VSS VB1 Vref FB VB2 net0 VB3 opamp
.ends dut
