* official Analog Canvas netlist; PDK X cards rewritten by convert.py
.model nch nmos
.model pch pmos

.subckt dut VDD2 VDD VSS Vin1 Vin2 Vout
MN1 net0 Vin1 VSS VSS nch l=0.15 w=1 nf=1 m=1
MN2 Vout VDD net0 VSS nch l=0.15 w=1 nf=1 m=1
MN3 VDD VDD2 net2 VSS nch l=0.15 w=1 nf=1 m=1
MP1 net1 VDD2 VDD2 VDD2 pch l=0.15 w=1 nf=1 m=1
MP2 Vout VDD net1 VDD2 pch l=0.15 w=1 nf=1 m=1
MP3 Vout Vin2 net2 VDD2 pch l=0.15 w=1 nf=1 m=1
.ends dut
