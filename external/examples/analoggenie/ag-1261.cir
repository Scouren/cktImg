* official Analog Canvas netlist; PDK X cards rewritten by convert.py
.model nch nmos
.model pch pmos

.subckt dut VDD VSS VCONT1 VCONT2 VCONT3 VIN VCONT4 VCONT5 VP VB3 VREF
.model DIODE D(IS=1e-14 N=1)
CFLY VX1 VX2 1p
CO VP VN 1p
COP VP VSS 1p
D1 VN VX2 DIODE
L1 VX1 VX3 1n
M1 VX1 VCONT2 VIN VDD pch l=0.15 w=1 nf=1 m=1
M2 VX2 VCONT3 VIN VDD pch l=0.15 w=1 nf=1 m=1
M3 VP VCONT5 VX3 VDD pch l=0.15 w=1 nf=1 m=1
M4 VX3 VCONT4 VSS VSS nch l=0.15 w=1 nf=1 m=1
M5 VS VCONT1 VIN VDD pch l=0.15 w=1 nf=1 m=1
MB1 VB4 VB1 VDD VDD pch l=0.15 w=1 nf=1 m=1
MB10 net0 net0 net1 VSS nch l=0.15 w=1 nf=1 m=1
MB11 net1 net0 VY VSS nch l=0.15 w=1 nf=1 m=1
MB12 net4 VB2 VDD VDD pch l=0.15 w=1 nf=1 m=1
MB13 net4 net4 VX VSS nch l=0.15 w=1 nf=1 m=1
MB14 VX net4 net1 VSS nch l=0.15 w=1 nf=1 m=1
MB2 VB1 VB1 VDD VDD pch l=0.15 w=1 nf=1 m=1
MB3 VB4 VB4 VSS VSS nch l=0.15 w=1 nf=1 m=1
MB4 VB1 VY VSS VSS nch l=0.15 w=1 nf=1 m=1
MB5 VY VB2 VDD VDD pch l=0.15 w=1 nf=1 m=1
MB6 VY VY VSS VSS nch l=0.15 w=1 nf=1 m=1
MB7 VB2 VB2 VDD VDD pch l=0.15 w=1 nf=1 m=1
MB8 VB2 VX VSS VSS nch l=0.15 w=1 nf=1 m=1
MB9 net0 VB2 VDD VDD pch l=0.15 w=1 nf=1 m=1
MN1 net2 VFP1 net6 VSS nch l=0.15 w=1 nf=1 m=1
MN2 VX3 VREF net6 VSS nch l=0.15 w=1 nf=1 m=1
MN3 net5 net5 VSS VSS nch l=0.15 w=1 nf=1 m=1
MN4 VCTRL net5 VSS VSS nch l=0.15 w=1 nf=1 m=1
MN5 net6 VB4 VSS VSS nch l=0.15 w=1 nf=1 m=1
MN6 net3 VB3 VSS VSS nch l=0.15 w=1 nf=1 m=1
MN7 net3 net3 VSS VSS nch l=0.15 w=1 nf=1 m=1
MN8 VG net3 VSS VSS nch l=0.15 w=1 nf=1 m=1
MP1 net2 net2 VDD VDD pch l=0.15 w=1 nf=1 m=1
MP2 VX3 VX3 VDD VDD pch l=0.15 w=1 nf=1 m=1
MP3 VCTRL VX3 VDD VDD pch l=0.15 w=1 nf=1 m=1
MP4 VG VG VS VDD pch l=0.15 w=1 nf=1 m=1
MP5 VX1 VG VS VDD pch l=0.15 w=1 nf=1 m=1
MP6 net3 VCTRL VS VDD pch l=0.15 w=1 nf=1 m=1
MP7 net5 net2 VDD VDD pch l=0.15 w=1 nf=1 m=1
R1 VP VFP1 1k
R2 VFP1 VSS 1k
.ends dut
