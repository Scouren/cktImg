* official Analog Canvas netlist; PDK X cards rewritten by convert.py
.model nch nmos
.model pch pmos

.subckt dut VDD VSS inn inp Vo
I1 net9 VSS DC 1m
I2 net5 VSS DC 1m
M1 VDD inn net11 VSS nch l=0.15 w=1 nf=1 m=1
M10 net0 net0 net2 VDD pch l=0.15 w=1 nf=1 m=1
M11 net4 net4 net6 VSS nch l=0.15 w=1 nf=1 m=1
M12 net6 net6 VSS VSS nch l=0.15 w=1 nf=1 m=1
M13 net1 net2 VDD VDD pch l=0.15 w=1 nf=1 m=1
M14 Vo net0 net1 VDD pch l=0.15 w=1 nf=1 m=1
M15 Vo net4 net10 VSS nch l=0.15 w=1 nf=1 m=1
M16 net10 net6 VSS VSS nch l=0.15 w=1 nf=1 m=1
M2 VDD inn net3 VSS nch l=0.15 w=1 nf=1 m=1
M3 net0 inp net7 VSS nch l=0.15 w=1 nf=1 m=1
M4 VDD inp net8 VSS nch l=0.15 w=1 nf=1 m=1
M5 net9 net9 net11 VDD pch l=0.15 w=1 nf=1 m=1
M6 VSS net9 net7 VDD pch l=0.15 w=1 nf=1 m=1
M7 net4 net5 net3 VDD pch l=0.15 w=1 nf=1 m=1
M8 net5 net5 net8 VDD pch l=0.15 w=1 nf=1 m=1
M9 net2 net2 VDD VDD pch l=0.15 w=1 nf=1 m=1
.ends dut
