* official Analog Canvas netlist; PDK X cards rewritten by convert.py
.model nch nmos
.model pch pmos
.model qnpn npn

.subckt opamp VDD VSS INP INN OUT VB1 VB2 VQ
M1 net0 net8 VDD VDD pch l=0.15 w=1 nf=1 m=1
M10 net6 net2 VSS VSS nch l=0.15 w=1 nf=1 m=1
M11 net10 net8 VDD VDD pch l=0.15 w=1 nf=1 m=1
M12 OUT VB1 net10 VDD pch l=0.15 w=1 nf=1 m=1
M13 OUT VB3 net9 VSS nch l=0.15 w=1 nf=1 m=1
M14 net9 net2 VSS VSS nch l=0.15 w=1 nf=1 m=1
M15 net7 VB2 VDD VDD pch l=0.15 w=1 nf=1 m=1
M16 net1 net1 VDD VDD pch l=0.15 w=1 nf=1 m=1
M17 VB3 net1 VDD VDD pch l=0.15 w=1 nf=1 m=1
M18 VB3 VB3 VQ VSS nch l=0.15 w=1 nf=1 m=1
M19 VQ VB3 VSS VSS nch l=0.15 w=1 nf=1 m=1
M2 net8 VB1 net0 VDD pch l=0.15 w=1 nf=1 m=1
M3 net8 VB3 net5 VSS nch l=0.15 w=1 nf=1 m=1
M4 net5 net4 VSS VSS nch l=0.15 w=1 nf=1 m=1
M5 net4 INP net7 VDD pch l=0.15 w=1 nf=1 m=1
M6 net4 VB3 net3 VSS nch l=0.15 w=1 nf=1 m=1
M7 net3 net4 VSS VSS nch l=0.15 w=1 nf=1 m=1
M8 net2 INN net7 VDD pch l=0.15 w=1 nf=1 m=1
M9 net2 VB3 net6 VSS nch l=0.15 w=1 nf=1 m=1
R4 net1 VSS 1k
.ends opamp

.subckt dut VDD VSS VB1 VB2 Vout
Q1 X X VSS VSS qnpn m=1
Q2 net0 net0 VSS VSS qnpn m=1
R1 Vout X 1k
R2 Vout Y 1k
R3 Y net0 1k
X1 VDD VSS X Y Vout VB1 VB2 net0 opamp
.ends dut
