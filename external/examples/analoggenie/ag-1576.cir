* official Analog Canvas netlist; PDK X cards rewritten by convert.py
.model nch nmos
.model pch pmos
.model qpnp pnp

.subckt opamp VDD VSS INN INP OUT VB1 VB2
M1 net6 INN net5 VSS nch l=0.15 w=1 nf=1 m=1
M10 net7 net3 VSS VSS nch l=0.15 w=1 nf=1 m=1
M11 net1 net3 VSS VSS nch l=0.15 w=1 nf=1 m=1
M12 VB5 VB6 VDD VDD pch l=0.15 w=1 nf=1 m=1
M13 VB5 VB5 VB4 VSS nch l=0.15 w=1 nf=1 m=1
M14 VB4 VB4 VSS VSS nch l=0.15 w=1 nf=1 m=1
M15 VB3 VB6 VDD VDD pch l=0.15 w=1 nf=1 m=1
M16 VB3 VB3 VSS VSS nch l=0.15 w=1 nf=1 m=1
M17 VB6 VB6 VDD VDD pch l=0.15 w=1 nf=1 m=1
M18 VB6 VB3 net2 VSS nch l=0.15 w=1 nf=1 m=1
M19 net2 net4 VSS VSS nch l=0.15 w=1 nf=1 m=1
M2 net0 INP net5 VSS nch l=0.15 w=1 nf=1 m=1
M20 net4 VB6 VDD VDD pch l=0.15 w=1 nf=1 m=1
M21 net4 net4 VSS VSS nch l=0.15 w=1 nf=1 m=1
M3 net5 VB4 VSS VSS nch l=0.15 w=1 nf=1 m=1
M4 net6 VB1 VDD VDD pch l=0.15 w=1 nf=1 m=1
M5 net0 VB1 VDD VDD pch l=0.15 w=1 nf=1 m=1
M6 net3 VB2 net6 VDD pch l=0.15 w=1 nf=1 m=1
M7 OUT VB2 net0 VDD pch l=0.15 w=1 nf=1 m=1
M8 net3 VB5 net7 VSS nch l=0.15 w=1 nf=1 m=1
M9 OUT VB5 net1 VSS nch l=0.15 w=1 nf=1 m=1
.ends opamp

.subckt dut VDD VSS Vout VB1 VB2
Q1 VSS VSS X qpnp m=1
Q2 VSS VSS net0 qpnp m=1
R1 Vout X 1k
R2 Vout Y 1k
R3 Y net0 1k
X1 VDD VSS Y X Vout VB1 VB2 opamp
.ends dut
