* official Analog Canvas netlist; PDK X cards rewritten by convert.py
.model nch nmos

.subckt dut VDD VSS Vi Vo
I VDD net0 DC 1m
M1 net1 Vi VSS VSS nch l=0.15 w=1 nf=1 m=1
M2 Vo net0 net1 VSS nch l=0.15 w=1 nf=1 m=1
M3 net0 net1 VSS VSS nch l=0.15 w=1 nf=1 m=1
R VDD Vo 1k
.ends dut
