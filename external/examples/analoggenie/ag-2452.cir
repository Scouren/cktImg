* official Analog Canvas netlist; PDK X cards rewritten by convert.py
.model nch nmos
.model pch pmos

.subckt dut VDD VSS VB1 VREF VB2 VB4 VB6 VB5 VOUT VIN
CF1 VOUT VFB 1p
Cm1 VOUT net14 1p
Cm2 VX net14 1p
M11 VX VB2 VSS VSS nch l=0.15 w=1 nf=1 m=1
M12 net7 VFB VX VSS nch l=0.15 w=1 nf=1 m=1
M13 net12 VREF VX VSS nch l=0.15 w=1 nf=1 m=1
M14 VG net7 VIN VDD pch l=0.15 w=1 nf=1 m=1
M15 net2 net12 VIN VDD pch l=0.15 w=1 nf=1 m=1
M16 VY VB4 VIN VDD pch l=0.15 w=1 nf=1 m=1
M17 VY net14 VSS VSS nch l=0.15 w=1 nf=1 m=1
M18 VY VY VSS VSS nch l=0.15 w=1 nf=1 m=1
M21 VA net14 VSS VSS nch l=0.15 w=1 nf=1 m=1
M22 VG VY VSS VSS nch l=0.15 w=1 nf=1 m=1
M23 VA VA VIN VDD pch l=0.15 w=1 nf=1 m=1
M24 VG VA VIN VDD pch l=0.15 w=1 nf=1 m=1
M25 net7 VB1 VG VDD pch l=0.15 w=1 nf=1 m=1
M26 net12 VB1 net2 VDD pch l=0.15 w=1 nf=1 m=1
M27 VA net7 VIN VDD pch l=0.15 w=1 nf=1 m=1
M28 net14 VB1 VA VDD pch l=0.15 w=1 nf=1 m=1
M29 net10 net12 VIN VDD pch l=0.15 w=1 nf=1 m=1
M30 net4 VB1 net10 VDD pch l=0.15 w=1 nf=1 m=1
M31 net1 net4 VSS VSS nch l=0.15 w=1 nf=1 m=1
M32 net14 VZ net1 VSS nch l=0.15 w=1 nf=1 m=1
M33 net0 net4 VSS VSS nch l=0.15 w=1 nf=1 m=1
M34 net4 VZ net0 VSS nch l=0.15 w=1 nf=1 m=1
M35 net3 net5 VIN VDD pch l=0.15 w=1 nf=1 m=1
M36 net5 net5 VIN VDD pch l=0.15 w=1 nf=1 m=1
M37 VZ net5 VIN VDD pch l=0.15 w=1 nf=1 m=1
M38 net9 net3 VSS VSS nch l=0.15 w=1 nf=1 m=1
M39 net5 net3 VSS VSS nch l=0.15 w=1 nf=1 m=1
M40 VZ VZ net13 VSS nch l=0.15 w=1 nf=1 m=1
M41 net13 VZ VSS VSS nch l=0.15 w=1 nf=1 m=1
MD1 VX net14 VSS VSS nch l=0.15 w=1 nf=1 m=1
MD2 net6 VB5 VSS VSS nch l=0.15 w=1 nf=1 m=1
MD3 net8 VX net6 VSS nch l=0.15 w=1 nf=1 m=1
MD4 net11 VB6 net6 VSS nch l=0.15 w=1 nf=1 m=1
MD5 VX net11 VIN VDD pch l=0.15 w=1 nf=1 m=1
MD6 net11 net11 VIN VDD pch l=0.15 w=1 nf=1 m=1
MD7 net8 net8 VIN VDD pch l=0.15 w=1 nf=1 m=1
MPT VOUT VG VIN VDD pch l=0.15 w=1 nf=1 m=1
R1 net3 net9 1k
RF1 VOUT VFB 1k
RF2 VFB VSS 1k
.ends dut
