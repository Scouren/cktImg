* official Analog Canvas netlist; PDK X cards rewritten by convert.py
.model nch nmos
.model pch pmos
.model qpnp pnp

.global VDD

.subckt A1 VSS INN INP OUT
M1 net3 INN net4 VSS nch l=0.15 w=1 nf=1 m=1
M10 OUT net1 VSS VSS nch l=0.15 w=1 nf=1 m=1
M11 VB2 VB2 VSS VSS nch l=0.15 w=1 nf=1 m=1
M12 VB2 net0 VDD VDD pch l=0.15 w=1 nf=1 m=1
M13 net0 net0 VDD VDD pch l=0.15 w=1 nf=1 m=1
M14 VB1 VB1 VSS VSS nch l=0.15 w=1 nf=1 m=1
M15 VB1 net0 VDD VDD pch l=0.15 w=1 nf=1 m=1
M16 net0 VB1 net5 VSS nch l=0.15 w=1 nf=1 m=1
M2 net2 INP net4 VSS nch l=0.15 w=1 nf=1 m=1
M3 net3 net3 VDD VDD pch l=0.15 w=1 nf=1 m=1
M4 net2 net2 VDD VDD pch l=0.15 w=1 nf=1 m=1
M5 net4 VB2 VSS VSS nch l=0.15 w=1 nf=1 m=1
M7 net1 net3 VDD VDD pch l=0.15 w=1 nf=1 m=1
M8 OUT net2 VDD VDD pch l=0.15 w=1 nf=1 m=1
M9 net1 net1 VSS VSS nch l=0.15 w=1 nf=1 m=1
R4 net5 VSS 1k
.ends A1

.subckt dut VSS Vout
Q1 VSS VSS X qpnp m=1
Q2 VSS VSS net0 qpnp m=1
R1 Vout X 1k
R2 Vout Y 1k
R3 Y net0 1k
X1 VSS Y X Vout A1
.ends dut
