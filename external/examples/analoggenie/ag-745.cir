* official Analog Canvas netlist; PDK X cards rewritten by convert.py
.model nch nmos
.model pch pmos
.model qnpn npn

.subckt dut VEE VSS Vin+ Vin- phi1_bar phi1 Vout- Vout+
.model DIODE D(IS=1e-14 N=1)
D1 net1 Vout- DIODE
D2 net0 Vout+ DIODE
I1 net5 VEE DC 1m
I2 net4 VEE DC 1m
I3 net6 VEE DC 1m
I4 Vout- VEE DC 1m
I5 Vout+ VEE DC 1m
M1 Vin+ phi1_bar net2 VSS pch l=0.15 w=1 nf=1 m=1
M2 VEE phi1 net2 VSS pch l=0.15 w=1 nf=1 m=1
M3 VSS net2 net4 VEE nch l=0.15 w=1 nf=1 m=1
M4 net7 phi1_bar Vin- VSS pch l=0.15 w=1 nf=1 m=1
M5 VEE phi1 net7 VSS pch l=0.15 w=1 nf=1 m=1
M6 VSS net7 net6 VEE nch l=0.15 w=1 nf=1 m=1
Q1 net3 net4 net5 VEE qnpn m=1
Q2 net8 net6 net5 VEE qnpn m=1
Q3 VSS net3 net1 VEE qnpn m=1
Q4 VSS net8 net0 VEE qnpn m=1
R1 VSS net3 1k
R2 VSS net8 1k
.ends dut
