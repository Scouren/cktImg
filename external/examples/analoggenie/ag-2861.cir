* official Analog Canvas netlist; PDK X cards rewritten by convert.py
.model nch nmos
.model pch pmos

.subckt opamp VDD VSS INN VX INP OUT
M10 VR VR VSS VSS nch l=0.15 w=1 nf=1 m=1
M11 net0 VR VSS VSS nch l=0.15 w=1 nf=1 m=1
M12 net1 VR VSS VSS nch l=0.15 w=1 nf=1 m=1
M13 net1 net1 VDD VDD pch l=0.15 w=1 nf=1 m=1
M14 VBN net1 VDD VDD pch l=0.15 w=1 nf=1 m=1
M15 VBN VBN VSS VSS nch l=0.15 w=1 nf=1 m=1
M16 VB1 VB1 VDD VDD pch l=0.15 w=1 nf=1 m=1
M17 VB1 VBN VSS VSS nch l=0.15 w=1 nf=1 m=1
M3 VX INN net2 VSS nch l=0.15 w=1 nf=1 m=1
M4 OUT INP net2 VSS nch l=0.15 w=1 nf=1 m=1
M5 net2 VBN VSS VSS nch l=0.15 w=1 nf=1 m=1
M6 net4 VX VDD VDD pch l=0.15 w=1 nf=1 m=1
M7 net3 VX VDD VDD pch l=0.15 w=1 nf=1 m=1
M8 VX VB2 net4 VDD pch l=0.15 w=1 nf=1 m=1
M9 OUT VB2 net3 VDD pch l=0.15 w=1 nf=1 m=1
R1 VDD VR 1k
R2 VR net0 1k
R3 VDD net0 1k
.ends opamp

.subckt dut VDD VSS vci phi1 phi2 vco
C1 vcx VSS 1p
C2 net0 vco 1p
M1 vci phi1 vcx VSS nch l=0.15 w=1 nf=1 m=1
M2 vcx phi2 net0 VSS nch l=0.15 w=1 nf=1 m=1
X1 VDD VSS net0 vcx VSS vco opamp
.ends dut
