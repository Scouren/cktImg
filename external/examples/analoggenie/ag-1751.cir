* official Analog Canvas netlist; PDK X cards rewritten by convert.py
.model nch nmos
.model pch pmos
.model qpnp pnp

.subckt A1 VDD VSS INN INP OUT VB1 VB2 VZ
M10 net0 VZ VSS VSS nch l=0.15 w=1 nf=1 m=1
M11 OUT VB3 net4 VSS nch l=0.15 w=1 nf=1 m=1
M12 net4 VZ VSS VSS nch l=0.15 w=1 nf=1 m=1
M13 net3 INN INP VSS nch l=0.15 w=1 nf=1 m=1
M14 net2 INP INP VSS nch l=0.15 w=1 nf=1 m=1
M15 INP VB4 VSS VSS nch l=0.15 w=1 nf=1 m=1
M16 net1 net1 VDD VDD pch l=0.15 w=1 nf=1 m=1
M17 VB3 net1 VDD VDD pch l=0.15 w=1 nf=1 m=1
M18 VB3 VB3 VB4 VSS nch l=0.15 w=1 nf=1 m=1
M19 VB4 VB4 VSS VSS nch l=0.15 w=1 nf=1 m=1
M5 net3 VB1 VDD VDD pch l=0.15 w=1 nf=1 m=1
M6 VZ VB2 net3 VDD pch l=0.15 w=1 nf=1 m=1
M7 net2 VB1 VDD VDD pch l=0.15 w=1 nf=1 m=1
M8 OUT VB2 net2 VDD pch l=0.15 w=1 nf=1 m=1
M9 VZ VB3 net0 VSS nch l=0.15 w=1 nf=1 m=1
R3 net1 VSS 1k
.ends A1

.subckt dut VDD VSS Vout VB1 VB2
M1 X net0 VDD VDD pch l=0.15 w=1 nf=1 m=1
M2 Vout net0 VDD VDD pch l=0.15 w=1 nf=1 m=1
M3 net1 net0 VDD VDD pch l=0.15 w=1 nf=1 m=1
M4 VZ net0 VDD VDD pch l=0.15 w=1 nf=1 m=1
Q1 VSS VSS net1 qpnp m=1
Q2 VSS net1 X qpnp m=1
Q3 VSS VSS VZ qpnp m=1
Q4 VSS VZ net2 qpnp m=1
R1 Y net2 1k
R2 Vout Y 1k
X1 VDD VSS X Y net0 VB1 VB2 VZ A1
.ends dut
