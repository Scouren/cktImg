* official Analog Canvas netlist; PDK X cards rewritten by convert.py

.subckt dut Vin1 Vin2 Vin3 Vin4 Vout1 Vout2 Vout3 Vout4
C1 Vin1 net1 1p
C2 Vin2 net3 1p
C3 Vin3 net2 1p
C4 Vin4 net0 1p
C5 net0 Vout2 1p
C6 net1 Vout3 1p
C7 net3 Vout4 1p
C8 net2 Vout1 1p
R1 Vin1 net0 1k
R2 Vin2 net1 1k
R3 Vin3 net3 1k
R4 Vin4 net2 1k
R5 net0 Vout1 1k
R6 net1 Vout2 1k
R7 net3 Vout3 1k
R8 net2 Vout4 1k
.ends dut
