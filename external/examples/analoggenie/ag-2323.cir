* official Analog Canvas netlist; PDK X cards rewritten by convert.py
.model nch nmos
.model pch pmos

.subckt bias VDD VSS VC
M22 VC VP VDD VDD pch l=0.15 w=1 nf=1 m=1
M23 VC VC net2 VSS nch l=0.15 w=1 nf=1 m=1
M24 net2 VC VSS VSS nch l=0.15 w=1 nf=1 m=1
M25 VB4 VP VDD VDD pch l=0.15 w=1 nf=1 m=1
M26 VB4 VB4 VSS VSS nch l=0.15 w=1 nf=1 m=1
M27 VP VP VDD VDD pch l=0.15 w=1 nf=1 m=1
M28 VP VB4 net1 VSS nch l=0.15 w=1 nf=1 m=1
M29 net1 net0 VSS VSS nch l=0.15 w=1 nf=1 m=1
M30 net0 VP VDD VDD pch l=0.15 w=1 nf=1 m=1
M31 net0 net0 VSS VSS nch l=0.15 w=1 nf=1 m=1
.ends bias

.subckt dut VDD VSS VB1 VREF FB VB3 VB2 VB5 IBUF VIN VOUT
CL VOUT net2 1p
M10 EAO VB3 VY VDD pch l=0.15 w=1 nf=1 m=1
M11 net0 VX VDD VDD pch l=0.15 w=1 nf=1 m=1
M12 VY VX VDD VDD pch l=0.15 w=1 nf=1 m=1
M13 net1 VB5 VDD VDD pch l=0.15 w=1 nf=1 m=1
M14 VX EAO net1 VDD pch l=0.15 w=1 nf=1 m=1
M15 VX VX VSS VSS nch l=0.15 w=1 nf=1 m=1
M16 GATE VX VSS VSS nch l=0.15 w=1 nf=1 m=1
M17 VDD net1 GATE VSS nch l=0.15 w=1 nf=1 m=1
M18 VY EAO IBUF VSS nch l=0.15 w=1 nf=1 m=1
M19 VY VY VDD VDD pch l=0.15 w=1 nf=1 m=1
M2 net3 VB1 VDD VDD pch l=0.15 w=1 nf=1 m=1
M20 GATE VY VDD VDD pch l=0.15 w=1 nf=1 m=1
M21 VSS IBUF GATE VDD pch l=0.15 w=1 nf=1 m=1
M3 net4 VREF net3 VDD pch l=0.15 w=1 nf=1 m=1
M4 net5 FB net3 VDD pch l=0.15 w=1 nf=1 m=1
M5 net4 VB2 VSS VSS nch l=0.15 w=1 nf=1 m=1
M6 net5 VB2 VSS VSS nch l=0.15 w=1 nf=1 m=1
M7 VX VC net4 VSS nch l=0.15 w=1 nf=1 m=1
M8 EAO VC net5 VSS nch l=0.15 w=1 nf=1 m=1
M9 VX VB3 net0 VDD pch l=0.15 w=1 nf=1 m=1
MNP VIN GATE VOUT VSS nch l=0.15 w=1 nf=1 m=1
R1 FB VSS 1k
R2 VOUT FB 1k
RESR net2 VSS 1k
RL VOUT VSS 1k
X1 VDD VSS VC bias
.ends dut
