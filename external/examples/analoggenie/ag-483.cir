* official Analog Canvas netlist; PDK X cards rewritten by convert.py
.model nch nmos

.subckt dut VDD VSS Vb Vout1 Vout2 Vin1 Vin2
L1 VDD Vout1 1n
L2 VDD Vout2 1n
LB1 Vin1 VSS 1n
LB2 Vin2 VSS 1n
M1 net1 Vb Vin1 VSS nch l=0.15 w=1 nf=1 m=1
M2 net0 Vb Vin2 VSS nch l=0.15 w=1 nf=1 m=1
M3 Vout1 VDD net1 VSS nch l=0.15 w=1 nf=1 m=1
M4 Vout2 VDD net0 VSS nch l=0.15 w=1 nf=1 m=1
.ends dut
