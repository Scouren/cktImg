* official Analog Canvas netlist; PDK X cards rewritten by convert.py
.model nch nmos
.model pch pmos
.model qpnp pnp

.subckt dut VDD VSS VB1 Vout
M1 VT VB1 VDD VDD pch l=0.15 w=1 nf=1 m=1
M10 VZ VB5 VSS VSS nch l=0.15 w=1 nf=1 m=1
M11 net5 VB5 VSS VSS nch l=0.15 w=1 nf=1 m=1
M12 VB4 net1 VDD VDD pch l=0.15 w=1 nf=1 m=1
M13 net1 net1 VDD VDD pch l=0.15 w=1 nf=1 m=1
M14 VT net1 VDD VDD pch l=0.15 w=1 nf=1 m=1
M15 VB4 VB4 VB5 VSS nch l=0.15 w=1 nf=1 m=1
M16 VB5 VB5 VSS VSS nch l=0.15 w=1 nf=1 m=1
M17 net1 VT VB3 VSS nch l=0.15 w=1 nf=1 m=1
M18 VT VB3 VSS VSS nch l=0.15 w=1 nf=1 m=1
M2 VZ X VT VDD pch l=0.15 w=1 nf=1 m=1
M3 net5 Y VT VDD pch l=0.15 w=1 nf=1 m=1
M4 net2 net0 VDD VDD pch l=0.15 w=1 nf=1 m=1
M5 X net0 VDD VDD pch l=0.15 w=1 nf=1 m=1
M6 net0 VB2 net2 VDD pch l=0.15 w=1 nf=1 m=1
M7 Vout VB2 X VDD pch l=0.15 w=1 nf=1 m=1
M8 net0 VB4 VZ VSS nch l=0.15 w=1 nf=1 m=1
M9 Vout VB4 net5 VSS nch l=0.15 w=1 nf=1 m=1
Q1 VSS VSS VZ qpnp m=1
Q2 VZ VZ X qpnp m=1
Q3 VSS VSS net3 qpnp m=1
Q4 net3 net3 net4 qpnp m=1
R1 Vout X 1k
R2 Vout Y 1k
R3 Y net4 1k
R4 VB3 VSS 1k
.ends dut
