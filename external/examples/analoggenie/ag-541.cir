* official Analog Canvas netlist; PDK X cards rewritten by convert.py
.model nch nmos

.subckt dut VDD VSS Vin1 Vin2
I1 net0 VSS DC 1m
ISS net1 VSS DC 1m
L1 VDD net2 1n
L2 VDD net3 1n
M1 net2 net3 net1 VSS nch l=0.15 w=1 nf=1 m=1
M2 net3 net2 net1 VSS nch l=0.15 w=1 nf=1 m=1
M3 net3 Vin1 net0 VSS nch l=0.15 w=1 nf=1 m=1
M4 net2 Vin2 net0 VSS nch l=0.15 w=1 nf=1 m=1
.ends dut
