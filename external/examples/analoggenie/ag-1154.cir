* official Analog Canvas netlist; PDK X cards rewritten by convert.py
.model nch nmos
.model pch pmos

.subckt dut VDD VSS Vin2- Vin2+ Vin1+ Vin1- Vout- Vout+ Vcont
M1 Vout- Vin2- VDD VDD pch l=0.15 w=1 nf=1 m=1
M2 Vout- net0 VDD VDD pch l=0.15 w=1 nf=1 m=1
M3 Vout+ net1 VDD VDD pch l=0.15 w=1 nf=1 m=1
M4 Vout+ Vin2+ VDD VDD pch l=0.15 w=1 nf=1 m=1
M5 net1 Vcont Vout- VSS nch l=0.15 w=1 nf=1 m=1
M6 net0 Vcont Vout+ VSS nch l=0.15 w=1 nf=1 m=1
M7 Vout- Vin1+ VSS VSS nch l=0.15 w=1 nf=1 m=1
M8 Vout+ Vin1- VSS VSS nch l=0.15 w=1 nf=1 m=1
.ends dut
