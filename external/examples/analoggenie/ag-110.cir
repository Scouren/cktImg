* official Analog Canvas netlist; PDK X cards rewritten by convert.py
.model nch nmos

.subckt dut VDD VSS Vb Iout
IREF VDD net0 DC 1m
M1 net1 net0 VSS VSS nch l=0.15 w=1 nf=1 m=1
M2 net2 net0 VSS VSS nch l=0.15 w=1 nf=1 m=1
M3 Iout Vb net2 VSS nch l=0.15 w=1 nf=1 m=1
R1 net0 net1 1k
.ends dut
