* official Analog Canvas netlist; PDK X cards rewritten by convert.py
.model nch nmos
.model pch pmos

.subckt dut VDD VSS Vin Vout
C0 Y VSS 1p
C1 Vin X 1p
I0 VDD Y DC 1m
M0 Y Y VSS VSS nch l=0.15 w=1 nf=1 m=1
M1 Vout X VSS VSS nch l=0.15 w=1 nf=1 m=1
M2 Vout Vout VDD VDD pch l=0.15 w=1 nf=1 m=1
R1 X Y 1k
.ends dut
