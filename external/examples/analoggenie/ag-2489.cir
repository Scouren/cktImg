* official Analog Canvas netlist; PDK X cards rewritten by convert.py
.model nch nmos
.model pch pmos

.subckt dut VDD VSS VIN VB1 VREF VB3 VB5 VB2 VB4 VOUT
CF1 VOUT VFB 1p
Cm1 VOUT VO1 1p
Cm2 VO1 net8 1p
M11 net0 VB1 VIN VDD pch l=0.15 w=1 nf=1 m=1
M12 net7 VFB net0 VDD pch l=0.15 w=1 nf=1 m=1
M13 net2 VREF net0 VDD pch l=0.15 w=1 nf=1 m=1
M14 net7 VB6 VSS VSS nch l=0.15 w=1 nf=1 m=1
M15 net2 VB6 VSS VSS nch l=0.15 w=1 nf=1 m=1
M16 VC VB5 VIN VDD pch l=0.15 w=1 nf=1 m=1
M17 VC VO1 VSS VSS nch l=0.15 w=1 nf=1 m=1
M18 VC VC VSS VSS nch l=0.15 w=1 nf=1 m=1
M21 net6 VO1 VSS VSS nch l=0.15 w=1 nf=1 m=1
M22 net4 VC VSS VSS nch l=0.15 w=1 nf=1 m=1
M23 net6 net6 VIN VDD pch l=0.15 w=1 nf=1 m=1
M24 net4 net6 VIN VDD pch l=0.15 w=1 nf=1 m=1
M25 net3 VB7 net7 VSS nch l=0.15 w=1 nf=1 m=1
M26 VO1 VB7 net2 VSS nch l=0.15 w=1 nf=1 m=1
M27 net3 VB3 VX VDD pch l=0.15 w=1 nf=1 m=1
M28 VO1 VB3 net5 VDD pch l=0.15 w=1 nf=1 m=1
M29 VX net3 VIN VDD pch l=0.15 w=1 nf=1 m=1
M30 net5 net3 VIN VDD pch l=0.15 w=1 nf=1 m=1
M31 VB7 net1 VIN VDD pch l=0.15 w=1 nf=1 m=1
M32 net1 net1 VIN VDD pch l=0.15 w=1 nf=1 m=1
M33 VB7 VB7 VB6 VSS nch l=0.15 w=1 nf=1 m=1
M34 VB6 VB6 VSS VSS nch l=0.15 w=1 nf=1 m=1
MD1 net8 VO1 VSS VSS nch l=0.15 w=1 nf=1 m=1
MD2 VX VB2 VSS VSS nch l=0.15 w=1 nf=1 m=1
MD3 net9 net8 VX VSS nch l=0.15 w=1 nf=1 m=1
MD4 net10 VB4 VX VSS nch l=0.15 w=1 nf=1 m=1
MD5 net8 net10 VIN VDD pch l=0.15 w=1 nf=1 m=1
MD6 net10 net10 VIN VDD pch l=0.15 w=1 nf=1 m=1
MD7 net9 net9 VIN VDD pch l=0.15 w=1 nf=1 m=1
MPT VOUT net4 VIN VDD pch l=0.15 w=1 nf=1 m=1
R1 net1 VSS 1k
RF1 VOUT VFB 1k
RF2 VFB VSS 1k
.ends dut
