* official Analog Canvas netlist; PDK X cards rewritten by convert.py
.model nch nmos

.subckt dut VDD VSS
CB net1 VSS 1p
CT net3 VSS 1p
In net3 VSS DC 1m
ISS net3 VSS DC 1m
L1 VDD net2 1n
L2 VDD net0 1n
LT net1 net3 1n
M1 net2 net0 net1 VSS nch l=0.15 w=1 nf=1 m=1
M2 net0 net2 net1 VSS nch l=0.15 w=1 nf=1 m=1
.ends dut
