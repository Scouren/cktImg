* official Analog Canvas netlist; PDK X cards rewritten by convert.py
.model nch nmos
.model pch pmos

.subckt dut VDD VSS Vctrl Vo+ Vo-
.model DIODE D(IS=1e-14 N=1)
D1 Vctrl Vo+ DIODE
D2 Vctrl Vo- DIODE
L2 Vo+ Vo- 1n
M3 Vo+ Vo- net0 VSS nch l=0.15 w=1 nf=1 m=1
M4 Vo- Vo+ VDD VDD pch l=0.15 w=1 nf=1 m=1
Rs net0 VSS 1k
.ends dut
