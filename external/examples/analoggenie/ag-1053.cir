* official Analog Canvas netlist; PDK X cards rewritten by convert.py
.model nch nmos
.model pch pmos

.subckt dut VDD VSS CLKB CLK CINN CINP OUT OUTB
MN0 OUT OUTB net0 VSS nch l=0.15 w=1 nf=1 m=1
MN1 OUTB OUT net4 VSS nch l=0.15 w=1 nf=1 m=1
MN2 net0 CINN net2 VSS nch l=0.15 w=1 nf=1 m=1
MN3 net4 CINP net2 VSS nch l=0.15 w=1 nf=1 m=1
MN4 net3 CLKB VSS VSS nch l=0.15 w=1 nf=1 m=1
MN5 net1 CLKB VSS VSS nch l=0.15 w=1 nf=1 m=1
MN6 net2 CLK VSS VSS nch l=0.15 w=1 nf=1 m=1
MP0 OUT net1 VDD VDD pch l=0.15 w=1 nf=1 m=1
MP1 OUTB net3 VDD VDD pch l=0.15 w=1 nf=1 m=1
MP2 OUT CLK VDD VDD pch l=0.15 w=1 nf=1 m=1
MP3 OUTB CLK VDD VDD pch l=0.15 w=1 nf=1 m=1
MP4 net3 OUTB VDD VDD pch l=0.15 w=1 nf=1 m=1
MP5 net1 OUT VDD VDD pch l=0.15 w=1 nf=1 m=1
.ends dut
