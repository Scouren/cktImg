* official Analog Canvas netlist; PDK X cards rewritten by convert.py
.model nch nmos
.model pch pmos

.subckt dut VDD VSS VREF VB3 VB2 VB4 VIN VOUT
CF1 VOUT VFB 1p
Cm1 VOUT VO1 1p
Cm2 VO1 net10 1p
M11 net8 VB1 VSS VSS nch l=0.15 w=1 nf=1 m=1
M12 VY VFB net8 VSS nch l=0.15 w=1 nf=1 m=1
M13 VX VREF net8 VSS nch l=0.15 w=1 nf=1 m=1
M14 net0 net0 VSS VSS nch l=0.15 w=1 nf=1 m=1
M15 VO1 net0 VSS VSS nch l=0.15 w=1 nf=1 m=1
M16 VX VB3 VIN VDD pch l=0.15 w=1 nf=1 m=1
M17 VX VO1 VSS VSS nch l=0.15 w=1 nf=1 m=1
M18 VX VX VSS VSS nch l=0.15 w=1 nf=1 m=1
M19 VY VY VIN VDD pch l=0.15 w=1 nf=1 m=1
M20 VX VX VIN VDD pch l=0.15 w=1 nf=1 m=1
M21 net4 VO1 VSS VSS nch l=0.15 w=1 nf=1 m=1
M22 net2 VX VSS VSS nch l=0.15 w=1 nf=1 m=1
M23 net4 net4 VIN VDD pch l=0.15 w=1 nf=1 m=1
M24 net2 net4 VIN VDD pch l=0.15 w=1 nf=1 m=1
M25 VO1 VY VIN VDD pch l=0.15 w=1 nf=1 m=1
M26 net0 VX VIN VDD pch l=0.15 w=1 nf=1 m=1
MB1 net7 net7 VIN VDD pch l=0.15 w=1 nf=1 m=1
MB10 net6 net6 VSS VSS nch l=0.15 w=1 nf=1 m=1
MB11 net6 net1 VIN VDD pch l=0.15 w=1 nf=1 m=1
MB2 VB1 net7 VIN VDD pch l=0.15 w=1 nf=1 m=1
MB3 VB1 VB1 VSS VSS nch l=0.15 w=1 nf=1 m=1
MB4 net7 net5 VSS VSS nch l=0.15 w=1 nf=1 m=1
MB5 net5 net5 VSS VSS nch l=0.15 w=1 nf=1 m=1
MB6 net5 net1 VIN VDD pch l=0.15 w=1 nf=1 m=1
MB7 net1 net1 VIN VDD pch l=0.15 w=1 nf=1 m=1
MB8 net1 net5 net9 VSS nch l=0.15 w=1 nf=1 m=1
MB9 net9 net6 VSS VSS nch l=0.15 w=1 nf=1 m=1
MD1 net10 VO1 VSS VSS nch l=0.15 w=1 nf=1 m=1
MD2 net3 VB2 VSS VSS nch l=0.15 w=1 nf=1 m=1
MD3 net11 net10 net3 VSS nch l=0.15 w=1 nf=1 m=1
MD4 VY VB4 net3 VSS nch l=0.15 w=1 nf=1 m=1
MD5 net10 VY VIN VDD pch l=0.15 w=1 nf=1 m=1
MD6 VY VY VIN VDD pch l=0.15 w=1 nf=1 m=1
MD7 net11 net11 VIN VDD pch l=0.15 w=1 nf=1 m=1
MPT VOUT net2 VIN VDD pch l=0.15 w=1 nf=1 m=1
RF1 VOUT VFB 1k
RF2 VFB VSS 1k
.ends dut
