* official Analog Canvas netlist; PDK X cards rewritten by convert.py
.model nch nmos
.model pch pmos

.subckt dut VDD VSS VB5 VREF VB2 VB4 IBUF VIN VOUT
CL VOUT net8 1p
M10 EAO VB2 VX VDD pch l=0.15 w=1 nf=1 m=1
M11 net4 VB3 VDD VDD pch l=0.15 w=1 nf=1 m=1
M12 VX VB3 VDD VDD pch l=0.15 w=1 nf=1 m=1
M13 net2 VB4 VDD VDD pch l=0.15 w=1 nf=1 m=1
M14 VB3 EAO net2 VDD pch l=0.15 w=1 nf=1 m=1
M15 VB3 VB3 VSS VSS nch l=0.15 w=1 nf=1 m=1
M16 GATE VB3 VSS VSS nch l=0.15 w=1 nf=1 m=1
M17 VDD net2 GATE VSS nch l=0.15 w=1 nf=1 m=1
M18 VX EAO IBUF VSS nch l=0.15 w=1 nf=1 m=1
M19 VX VX VDD VDD pch l=0.15 w=1 nf=1 m=1
M2 net5 VB5 VDD VDD pch l=0.15 w=1 nf=1 m=1
M20 GATE VX VDD VDD pch l=0.15 w=1 nf=1 m=1
M21 VSS IBUF GATE VDD pch l=0.15 w=1 nf=1 m=1
M22 net7 net6 VDD VDD pch l=0.15 w=1 nf=1 m=1
M23 net7 net7 VSS VSS nch l=0.15 w=1 nf=1 m=1
M24 net6 net6 VDD VDD pch l=0.15 w=1 nf=1 m=1
M25 net6 net7 VSS VSS nch l=0.15 w=1 nf=1 m=1
M26 VB1 net6 VDD VDD pch l=0.15 w=1 nf=1 m=1
M27 VB1 VB1 net1 VSS nch l=0.15 w=1 nf=1 m=1
M28 net1 VB1 VSS VSS nch l=0.15 w=1 nf=1 m=1
M3 net0 VREF net5 VDD pch l=0.15 w=1 nf=1 m=1
M4 net3 FB net5 VDD pch l=0.15 w=1 nf=1 m=1
M5 net0 VB6 VSS VSS nch l=0.15 w=1 nf=1 m=1
M6 net3 VB6 VSS VSS nch l=0.15 w=1 nf=1 m=1
M7 VB3 VB1 net0 VSS nch l=0.15 w=1 nf=1 m=1
M8 EAO VB1 net3 VSS nch l=0.15 w=1 nf=1 m=1
M9 VB3 VB2 net4 VDD pch l=0.15 w=1 nf=1 m=1
MNP VIN GATE VOUT VSS nch l=0.15 w=1 nf=1 m=1
R1 FB VSS 1k
R2 VOUT FB 1k
R3 net8 VSS 1k
RL VOUT VSS 1k
.ends dut
