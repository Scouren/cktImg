* official Analog Canvas netlist; PDK X cards rewritten by convert.py
.model nch nmos
.model pch pmos

.subckt bias VDD VSS VB5
M10 VB1 VB1 VDD VDD pch l=0.15 w=1 nf=1 m=1
M11 VB1 VB5 VSS VSS nch l=0.15 w=1 nf=1 m=1
M12 VB5 net2 VDD VDD pch l=0.15 w=1 nf=1 m=1
M23 VB5 VB5 VSS VSS nch l=0.15 w=1 nf=1 m=1
M24 net2 net2 VDD VDD pch l=0.15 w=1 nf=1 m=1
M25 net2 net1 VSS VSS nch l=0.15 w=1 nf=1 m=1
M26 VB2 VB2 VDD VDD pch l=0.15 w=1 nf=1 m=1
M27 VB2 net0 net1 VSS nch l=0.15 w=1 nf=1 m=1
M28 net0 VB2 VDD VDD pch l=0.15 w=1 nf=1 m=1
M29 net0 net1 VSS VSS nch l=0.15 w=1 nf=1 m=1
R4 net1 VSS 1k
.ends bias

.subckt dut VDD VSS VB4 IBUF VIN FB VOUT
CL VOUT net3 1p
M1 net1 net1 VDD VDD pch l=0.15 w=1 nf=1 m=1
M13 net5 VB4 VDD VDD pch l=0.15 w=1 nf=1 m=1
M14 VX EAO net5 VDD pch l=0.15 w=1 nf=1 m=1
M15 VX VX VSS VSS nch l=0.15 w=1 nf=1 m=1
M16 GATE VX VSS VSS nch l=0.15 w=1 nf=1 m=1
M17 VDD net5 GATE VSS nch l=0.15 w=1 nf=1 m=1
M18 net2 EAO IBUF IBUF nch l=0.15 w=1 nf=1 m=1
M19 net2 net2 VDD VDD pch l=0.15 w=1 nf=1 m=1
M2 net0 net0 VDD VDD pch l=0.15 w=1 nf=1 m=1
M20 GATE net2 VDD VDD pch l=0.15 w=1 nf=1 m=1
M21 VSS IBUF GATE VSS pch l=0.15 w=1 nf=1 m=1
M3 net1 VREF VX VSS nch l=0.15 w=1 nf=1 m=1
M4 net0 FB VX VSS nch l=0.15 w=1 nf=1 m=1
M5 VX VB5 VSS VSS nch l=0.15 w=1 nf=1 m=1
M6 net4 net0 VDD VDD pch l=0.15 w=1 nf=1 m=1
M7 net4 net4 VSS VSS nch l=0.15 w=1 nf=1 m=1
M8 EAO net1 VDD VDD pch l=0.15 w=1 nf=1 m=1
M9 EAO net4 VSS VSS nch l=0.15 w=1 nf=1 m=1
MNP VIN GATE VOUT VOUT nch l=0.15 w=1 nf=1 m=1
R1 FB VSS 1k
R2 VOUT FB 1k
R3 net3 VSS 1k
RL VOUT VSS 1k
X1 VDD VSS VB5 bias
.ends dut
