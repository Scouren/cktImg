* official Analog Canvas netlist; PDK X cards rewritten by convert.py
.model nch nmos

.subckt dut VEE VDD VSS Vin Vout
Ibias net0 VEE DC 1m
M1 VDD net1 net0 VSS nch l=0.15 w=1 nf=1 m=1
M2 Vout VSS net0 VSS nch l=0.15 w=1 nf=1 m=1
RD VDD Vout 1k
RS net1 Vin 1k
.ends dut
