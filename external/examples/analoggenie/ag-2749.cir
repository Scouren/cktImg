* official Analog Canvas netlist; PDK X cards rewritten by convert.py
.model nch nmos
.model pch pmos

.subckt dut VDD VSS vci phi1 phi2 vco
C1 vcx VSS 1p
C2 net1 vco 1p
M1 vci phi1 vcx VSS nch l=0.15 w=1 nf=1 m=1
M10 vco net2 VDD VDD pch l=0.15 w=1 nf=1 m=1
M11 vco net3 VSS VSS nch l=0.15 w=1 nf=1 m=1
M12 VB3 VB3 VDD VDD pch l=0.15 w=1 nf=1 m=1
M13 VB3 VB1 VSS VSS nch l=0.15 w=1 nf=1 m=1
M14 VB1 net0 VDD VDD pch l=0.15 w=1 nf=1 m=1
M15 VB1 VB1 VSS VSS nch l=0.15 w=1 nf=1 m=1
M16 net0 net0 VDD VDD pch l=0.15 w=1 nf=1 m=1
M17 net0 net4 VSS VSS nch l=0.15 w=1 nf=1 m=1
M18 net4 VB2 VDD VDD pch l=0.15 w=1 nf=1 m=1
M19 net4 net4 VSS VSS nch l=0.15 w=1 nf=1 m=1
M2 vcx phi2 net1 VSS nch l=0.15 w=1 nf=1 m=1
M20 VB2 VB2 VDD VDD pch l=0.15 w=1 nf=1 m=1
M21 VB2 net4 VX VSS nch l=0.15 w=1 nf=1 m=1
M3 net5 VB3 VDD VDD pch l=0.15 w=1 nf=1 m=1
M4 net3 net1 net5 VDD pch l=0.15 w=1 nf=1 m=1
M5 VX VSS net5 VDD pch l=0.15 w=1 nf=1 m=1
M6 net3 net3 VSS VSS nch l=0.15 w=1 nf=1 m=1
M7 VX VX VSS VSS nch l=0.15 w=1 nf=1 m=1
M8 net2 net2 VDD VDD pch l=0.15 w=1 nf=1 m=1
M9 net2 VX VSS VSS nch l=0.15 w=1 nf=1 m=1
R1 VX VSS 1k
.ends dut
