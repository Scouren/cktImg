* official Analog Canvas netlist; PDK X cards rewritten by convert.py
.model nch nmos
.model pch pmos

.subckt dut SUB Out
I1 net0 SUB DC 100uA
I2 Out SUB DC 50uA
M1 net1 net2 net0 SUB nch l=2 w=10 nf=1 m=1
M2 net4 net5 net0 SUB nch l=2 w=10 nf=1 m=1
M3 net1 net1 net3 net3 pch l=2 w=20 nf=1 m=1
M4 net4 net1 net3 net3 pch l=2 w=20 nf=1 m=1
M5 Out net4 net3 net3 pch l=2 w=20 nf=1 m=1
Vcc net3 SUB DC 5V
Vin1 net2 SUB DC 1
Vin2 net5 SUB DC 2V
.ends dut
