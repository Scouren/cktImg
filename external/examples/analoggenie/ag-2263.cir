* official Analog Canvas netlist; PDK X cards rewritten by convert.py
.model nch nmos
.model pch pmos

.subckt opamp VDD VSS INP INN OUT VX
M10 VX INN net5 VSS nch l=0.15 w=1 nf=1 m=1
M11 net5 VB3 VSS VSS nch l=0.15 w=1 nf=1 m=1
M12 OUT net3 VSS VSS nch l=0.15 w=1 nf=1 m=1
M13 net3 net3 VSS VSS nch l=0.15 w=1 nf=1 m=1
M14 net2 net2 VDD VDD pch l=0.15 w=1 nf=1 m=1
M15 net2 VB4 VSS VSS nch l=0.15 w=1 nf=1 m=1
M16 VB3 net2 VDD VDD pch l=0.15 w=1 nf=1 m=1
M17 VB3 VB3 VSS VSS nch l=0.15 w=1 nf=1 m=1
M18 VB1 VB1 VDD VDD pch l=0.15 w=1 nf=1 m=1
M19 VB1 VB3 VSS VSS nch l=0.15 w=1 nf=1 m=1
M20 VB4 VB2 VDD VDD pch l=0.15 w=1 nf=1 m=1
M21 VB4 VB4 VSS VSS nch l=0.15 w=1 nf=1 m=1
M22 VB2 VB2 VDD VDD pch l=0.15 w=1 nf=1 m=1
M23 VB2 VB4 net4 VSS nch l=0.15 w=1 nf=1 m=1
M24 net4 net0 VSS VSS nch l=0.15 w=1 nf=1 m=1
M25 net0 VB2 VDD VDD pch l=0.15 w=1 nf=1 m=1
M26 net0 net0 VSS VSS nch l=0.15 w=1 nf=1 m=1
M5 OUT net1 VDD VDD pch l=0.15 w=1 nf=1 m=1
M6 net1 net1 VDD VDD pch l=0.15 w=1 nf=1 m=1
M7 VX VX VDD VDD pch l=0.15 w=1 nf=1 m=1
M8 net3 VX VDD VDD pch l=0.15 w=1 nf=1 m=1
M9 net1 INP net5 VSS nch l=0.15 w=1 nf=1 m=1
.ends opamp

.subckt dut VDD VSS VIN VOUT Vref
C1 VOUT VX 1p
M1 VIN net0 VOUT VSS nch l=0.15 w=1 nf=1 m=1
R1 VOUT FB 1k
R2 FB VSS 1k
R3 VX VSS 1k
X1 VDD VSS Vref FB net0 VX opamp
.ends dut
