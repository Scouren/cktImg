* official Analog Canvas netlist; PDK X cards rewritten by convert.py
.model qnpn npn

.subckt dut VCC VSS VOUT
I VCC net3 DC 1m
Q1 net1 net1 VSS VSS qnpn m=1
Q2 net2 net1 net0 VSS qnpn m=1
Q3 net3 net2 VSS VSS qnpn m=1
Q4 VCC net3 VOUT VSS qnpn m=1
R1 VOUT net1 1k
R2 VOUT net2 1k
R3 net0 VSS 1k
.ends dut
