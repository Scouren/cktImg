* official Analog Canvas netlist; PDK X cards rewritten by convert.py
.model nch nmos
.model pch pmos

.subckt dut VDD VSS Vref VIN VOUT VB2 VB1
CL VOUT VX 1p
M1 VX FB net4 VSS nch l=0.15 w=1 nf=1 m=1
M10 VB2 VB2 VDD VDD pch l=0.15 w=1 nf=1 m=1
M11 net0 VB2 VDD VDD pch l=0.15 w=1 nf=1 m=1
M12 VB2 net0 VSS VSS nch l=0.15 w=1 nf=1 m=1
M13 net5 net0 VSS VSS nch l=0.15 w=1 nf=1 m=1
M14 net6 net6 VDD VDD pch l=0.15 w=1 nf=1 m=1
M15 net6 net0 VSS VSS nch l=0.15 w=1 nf=1 m=1
M16 VB3 net6 VDD VDD pch l=0.15 w=1 nf=1 m=1
M17 VB3 VB3 VSS VSS nch l=0.15 w=1 nf=1 m=1
M18 VB1 VB1 VDD VDD pch l=0.15 w=1 nf=1 m=1
M19 VB1 VB3 VSS VSS nch l=0.15 w=1 nf=1 m=1
M2 net2 Vref net4 VSS nch l=0.15 w=1 nf=1 m=1
M3 VX VX VDD VDD pch l=0.15 w=1 nf=1 m=1
M4 net2 net2 VDD VDD pch l=0.15 w=1 nf=1 m=1
M5 net1 VX VDD VDD pch l=0.15 w=1 nf=1 m=1
M6 net3 net2 VDD VDD pch l=0.15 w=1 nf=1 m=1
M7 net1 net1 VSS VSS nch l=0.15 w=1 nf=1 m=1
M8 net3 net1 VSS VSS nch l=0.15 w=1 nf=1 m=1
M9 net4 VB3 VSS VSS nch l=0.15 w=1 nf=1 m=1
MNP VIN net3 VOUT VSS nch l=0.15 w=1 nf=1 m=1
R1 VOUT FB 1k
R2 FB VSS 1k
R3 VX VSS 1k
R4 net0 net5 1k
.ends dut
