* official Analog Canvas netlist; PDK X cards rewritten by convert.py
.model nch nmos

.subckt dut VDD VSS
I1A VDD net2 DC 50uA
I1B VDD net3 DC 50uA
M1 net2 net2 VSS VSS nch l=0.15 w=1 nf=1 m=1
M2 net3 net2 net1 VSS nch l=0.15 w=1 nf=1 m=1
M3 net1 net3 VSS VSS nch l=0.15 w=1 nf=1 m=1
M4 VDD net2 net0 VSS nch l=0.15 w=1 nf=1 m=1
M5 net0 net3 VSS VSS nch l=0.15 w=1 nf=1 m=1
.ends dut
