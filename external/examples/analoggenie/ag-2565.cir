* official Analog Canvas netlist; PDK X cards rewritten by convert.py
.model nch nmos
.model pch pmos

.subckt dut VDD VSS VB1 VB2 Vref biasp biascas biasn Vout VB3
C1 Vset VSS 1p
C2 n3 Vout 1p
M1 Vout n3 VDD VDD pch l=0.15 w=1 nf=1 m=1
M10 Vset VCN n1 VSS nch l=0.15 w=1 nf=1 m=1
M11 n3 VCN net2 VSS nch l=0.15 w=1 nf=1 m=1
M12 n1 n3 VSS VSS nch l=0.15 w=1 nf=1 m=1
M13 net2 n3 VSS VSS nch l=0.15 w=1 nf=1 m=1
M14 net4 fb net5 VSS nch l=0.15 w=1 nf=1 m=1
M15 net6 Vref net5 VSS nch l=0.15 w=1 nf=1 m=1
M16 net5 VTN VSS VSS nch l=0.15 w=1 nf=1 m=1
M17 VCN VBP VDD VDD pch l=0.15 w=1 nf=1 m=1
M18 VCN VCN VTN VSS nch l=0.15 w=1 nf=1 m=1
M19 VTN VTN VSS VSS nch l=0.15 w=1 nf=1 m=1
M2 n1 Vset Vout VDD pch l=0.15 w=1 nf=1 m=1
M20 VBP VBP VDD VDD pch l=0.15 w=1 nf=1 m=1
M21 VBP VX VSS VSS nch l=0.15 w=1 nf=1 m=1
M22 net1 VBP VDD VDD pch l=0.15 w=1 nf=1 m=1
M23 net1 net1 VX VSS nch l=0.15 w=1 nf=1 m=1
M24 VX net1 net0 VSS nch l=0.15 w=1 nf=1 m=1
M25 net3 VBP VDD VDD pch l=0.15 w=1 nf=1 m=1
M26 net3 net3 net0 VSS nch l=0.15 w=1 nf=1 m=1
M27 net0 net3 VB3 VSS nch l=0.15 w=1 nf=1 m=1
M28 VB3 VBP VDD VDD pch l=0.15 w=1 nf=1 m=1
M29 VB3 VB3 VSS VSS nch l=0.15 w=1 nf=1 m=1
M3 n1 biasn VSS VSS nch l=0.15 w=1 nf=1 m=1
M4 n3 biasp VDD VDD pch l=0.15 w=1 nf=1 m=1
M5 n3 biascas n1 VSS nch l=0.15 w=1 nf=1 m=1
M6 net6 VB1 VDD VDD pch l=0.15 w=1 nf=1 m=1
M7 net4 VB1 VDD VDD pch l=0.15 w=1 nf=1 m=1
M8 Vset VB2 net6 VDD pch l=0.15 w=1 nf=1 m=1
M9 n3 VB2 net4 VDD pch l=0.15 w=1 nf=1 m=1
R1 fb VSS 1k
R2 Vout fb 1k
.ends dut
