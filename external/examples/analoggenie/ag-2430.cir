* official Analog Canvas netlist; PDK X cards rewritten by convert.py
.model nch nmos
.model pch pmos

.subckt Bias VDD VSS IB
M21 net1 net1 VDD VDD pch l=0.15 w=1 nf=1 m=1
M22 net0 net1 VDD VDD pch l=0.15 w=1 nf=1 m=1
M23 net3 net3 VDD VDD pch l=0.15 w=1 nf=1 m=1
M24 IB net3 VDD VDD pch l=0.15 w=1 nf=1 m=1
M25 net1 net0 net2 VSS nch l=0.15 w=1 nf=1 m=1
M26 net0 net0 VSS VSS nch l=0.15 w=1 nf=1 m=1
M27 net3 net0 VSS VSS nch l=0.15 w=1 nf=1 m=1
M28 IB IB VSS VSS nch l=0.15 w=1 nf=1 m=1
R1 net2 VSS 1k
.ends Bias

.subckt AEA VDD VSS VREF IB OUT
M10 net1 OUT net2 VSS nch l=0.15 w=1 nf=1 m=1
M11 net0 net0 VDD VDD pch l=0.15 w=1 nf=1 m=1
M12 net1 net1 VDD VDD pch l=0.15 w=1 nf=1 m=1
M13 net0 VREF net2 VSS nch l=0.15 w=1 nf=1 m=1
M14 net2 IB VSS VSS nch l=0.15 w=1 nf=1 m=1
M15 OUT net0 VDD VDD pch l=0.15 w=1 nf=1 m=1
M16 OUT net1 VDD VDD pch l=0.15 w=1 nf=1 m=1
M17 OUT OUT VSS VSS nch l=0.15 w=1 nf=1 m=1
M18 OUT OUT VSS VSS nch l=0.15 w=1 nf=1 m=1
.ends AEA

.subckt dut VDD VSS VIN VOUT VERR pb nb VREF
M1 net1 VEAOUT VIN VDD pch l=0.15 w=1 nf=1 m=1
M2 net2 net2 net1 VDD pch l=0.15 w=1 nf=1 m=1
M3 net2 nb VSS VSS nch l=0.15 w=1 nf=1 m=1
MBIAS VERR nb VSS VSS nch l=0.15 w=1 nf=1 m=1
MCHG net0 pb VIN VDD pch l=0.15 w=1 nf=1 m=1
MCTRL VERR net2 VOUT VDD pch l=0.15 w=1 nf=1 m=1
MGEN net3 net3 VSS VSS nch l=0.15 w=1 nf=1 m=1
MINJ VERR net3 VSS VSS nch l=0.15 w=1 nf=1 m=1
MRES VOUT VERR VIN VDD pch l=0.15 w=1 nf=1 m=1
MSEN net3 VEAOUT net0 VDD pch l=0.15 w=1 nf=1 m=1
X1 VDD VSS VREF net4 VEAOUT AEA
X2 VDD VSS net4 Bias
.ends dut
