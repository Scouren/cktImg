* official Analog Canvas netlist; PDK X cards rewritten by convert.py
.model nch nmos
.model pch pmos
.model qpnp pnp

.subckt A1 VDD VSS VB1 VB3 INN INP VB2 Z OUT
M10 OUT VB4 net4 VSS nch l=0.15 w=1 nf=1 m=1
M11 net0 Z VSS VSS nch l=0.15 w=1 nf=1 m=1
M12 net4 Z VSS VSS nch l=0.15 w=1 nf=1 m=1
M13 net5 INN INP VSS nch l=0.15 w=1 nf=1 m=1
M14 net1 INP INP VSS nch l=0.15 w=1 nf=1 m=1
M15 INP VB2 VSS VSS nch l=0.15 w=1 nf=1 m=1
M16 net2 net2 VDD VDD pch l=0.15 w=1 nf=1 m=1
M17 VB4 net2 VDD VDD pch l=0.15 w=1 nf=1 m=1
M18 VB4 VB4 net3 VSS nch l=0.15 w=1 nf=1 m=1
M19 net3 VB4 VSS VSS nch l=0.15 w=1 nf=1 m=1
M5 net5 VB1 VDD VDD pch l=0.15 w=1 nf=1 m=1
M6 net1 VB1 VDD VDD pch l=0.15 w=1 nf=1 m=1
M7 Z VB3 net5 VDD pch l=0.15 w=1 nf=1 m=1
M8 OUT VB3 net1 VDD pch l=0.15 w=1 nf=1 m=1
M9 Z VB4 net0 VSS nch l=0.15 w=1 nf=1 m=1
R3 net2 VSS 1k
.ends A1

.subckt dut VDD VSS Vout VB1 VB2 VB3
M1 X net1 VDD VDD pch l=0.15 w=1 nf=1 m=1
M2 Vout net1 VDD VDD pch l=0.15 w=1 nf=1 m=1
M3 net2 net1 VDD VDD pch l=0.15 w=1 nf=1 m=1
M4 Z net1 VDD VDD pch l=0.15 w=1 nf=1 m=1
Q1 VSS VSS net2 qpnp m=1
Q2 VSS net2 X qpnp m=1
Q3 VSS VSS Z qpnp m=1
Q4 VSS Z net0 qpnp m=1
R1 Y net0 1k
R2 Vout Y 1k
X1 VDD VSS VB1 VB3 X Y VB2 Z net1 A1
.ends dut
