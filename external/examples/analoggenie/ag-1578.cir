* official Analog Canvas netlist; PDK X cards rewritten by convert.py
.model nch nmos
.model pch pmos
.model qpnp pnp

.subckt opamp VDD VSS OUT INN INP
M1 VP INN net1 VSS nch l=0.15 w=1 nf=1 m=1
M10 net5 net0 VSS VSS nch l=0.15 w=1 nf=1 m=1
M11 net2 net0 VSS VSS nch l=0.15 w=1 nf=1 m=1
M12 VB4 net3 VDD VDD pch l=0.15 w=1 nf=1 m=1
M13 net3 net3 VDD VDD pch l=0.15 w=1 nf=1 m=1
M14 VB5 net3 VDD VDD pch l=0.15 w=1 nf=1 m=1
M15 VB4 VB4 VSS VSS nch l=0.15 w=1 nf=1 m=1
M16 net3 VB4 VSS VSS nch l=0.15 w=1 nf=1 m=1
M17 VB5 VB5 net4 VSS nch l=0.15 w=1 nf=1 m=1
M18 net4 VB5 VSS VSS nch l=0.15 w=1 nf=1 m=1
M2 VQ INP net1 VSS nch l=0.15 w=1 nf=1 m=1
M3 net1 VB2 VSS VSS nch l=0.15 w=1 nf=1 m=1
M4 VP VB1 VDD VDD pch l=0.15 w=1 nf=1 m=1
M5 VQ VB1 VDD VDD pch l=0.15 w=1 nf=1 m=1
M6 net0 VB3 VP VDD pch l=0.15 w=1 nf=1 m=1
M7 OUT VB3 VQ VDD pch l=0.15 w=1 nf=1 m=1
M8 net0 VB5 net5 VSS nch l=0.15 w=1 nf=1 m=1
M9 OUT VB5 net2 VSS nch l=0.15 w=1 nf=1 m=1
.ends opamp

.subckt dut VDD VSS Vout
Q1 VSS VSS X qpnp m=1
Q2 VSS VSS net0 qpnp m=1
R1 Vout X 1k
R2 Vout Y 1k
R3 Y net0 1k
X1 VDD VSS Vout Y X opamp
.ends dut
