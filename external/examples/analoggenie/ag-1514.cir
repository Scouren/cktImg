* official Analog Canvas netlist; PDK X cards rewritten by convert.py
.model nch nmos
.model pch pmos
.model qnpn npn

.subckt A1 VDD VSS Vp Vn VB1 Vo VB3 VC VB2
M1 net1 Vp net3 VDD pch l=0.15 w=1 nf=1 m=1
M10 net2 VG VDD VDD pch l=0.15 w=1 nf=1 m=1
M11 net0 VG VDD VDD pch l=0.15 w=1 nf=1 m=1
M2 net4 Vn net3 VDD pch l=0.15 w=1 nf=1 m=1
M3 net3 VB1 VDD VDD pch l=0.15 w=1 nf=1 m=1
M4 net1 VB2 VSS VSS nch l=0.15 w=1 nf=1 m=1
M5 net4 VB2 VSS VSS nch l=0.15 w=1 nf=1 m=1
M6 VG VC net1 VSS nch l=0.15 w=1 nf=1 m=1
M7 Vo VC net4 VSS nch l=0.15 w=1 nf=1 m=1
M8 VG VB3 net2 VDD pch l=0.15 w=1 nf=1 m=1
M9 Vo VB3 net0 VDD pch l=0.15 w=1 nf=1 m=1
.ends A1

.subckt dut VDD VSS Vout VB1 VB2 VB3
M12 VC VBP VDD VDD pch l=0.15 w=1 nf=1 m=1
M13 VC VC Z VSS nch l=0.15 w=1 nf=1 m=1
M14 Z VC VSS VSS nch l=0.15 w=1 nf=1 m=1
M15 VBP VBP VDD VDD pch l=0.15 w=1 nf=1 m=1
M16 VBP VB5 VB4 VSS nch l=0.15 w=1 nf=1 m=1
M17 VB4 net0 VSS VSS nch l=0.15 w=1 nf=1 m=1
M18 VB5 VBP VDD VDD pch l=0.15 w=1 nf=1 m=1
M19 VB5 VB4 VSS VSS nch l=0.15 w=1 nf=1 m=1
M20 net0 VBP VDD VDD pch l=0.15 w=1 nf=1 m=1
M21 net0 net0 VSS VSS nch l=0.15 w=1 nf=1 m=1
Q1 X X VSS VSS qnpn m=1
Q2 Z Z VSS VSS qnpn m=1
R1 Vout X 1k
R2 Vout Y 1k
R3 Y Z 1k
X1 VDD VSS X Y VB1 Vout VB3 VC VB2 A1
.ends dut
