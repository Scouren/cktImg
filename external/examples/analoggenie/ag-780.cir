* official Analog Canvas netlist; PDK X cards rewritten by convert.py
.model qnpn npn

.subckt dut VCC VSS vi+ vi- io+ io-
I1 net3 VSS DC 1m
I2 VCC io- DC 1m
I3 VCC io+ DC 1m
I4 net4 VSS DC 1m
Q1 VCC vi+ net2 VSS qnpn m=1
Q2 VCC vi- net5 VSS qnpn m=1
Q3 net1 net1 net3 VSS qnpn m=1
Q4 net0 net0 net3 VSS qnpn m=1
Q5 io- net1 net4 VSS qnpn m=1
Q6 io+ net0 net4 VSS qnpn m=1
R1 net2 net1 1k
R2 net5 net0 1k
.ends dut
