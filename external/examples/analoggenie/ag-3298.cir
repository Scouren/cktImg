* official Analog Canvas netlist; PDK X cards rewritten by convert.py
.model nch nmos
.model pch pmos

.subckt opamp VDD VSS INP INN OUT
M10 net1 VX VSS VSS nch l=0.15 w=1 nf=1 m=1
M11 OUT net2 VSS VSS nch l=0.15 w=1 nf=1 m=1
M12 net1 net1 VDD VDD pch l=0.15 w=1 nf=1 m=1
M13 OUT net1 VDD VDD pch l=0.15 w=1 nf=1 m=1
M14 VX VB4 VSS VSS nch l=0.15 w=1 nf=1 m=1
M15 VB5 VB5 VDD VDD pch l=0.15 w=1 nf=1 m=1
M16 VB5 VB2 VX VSS nch l=0.15 w=1 nf=1 m=1
M17 VB2 VB5 VDD VDD pch l=0.15 w=1 nf=1 m=1
M18 VB2 VB2 VSS VSS nch l=0.15 w=1 nf=1 m=1
M19 VB4 VB5 VDD VDD pch l=0.15 w=1 nf=1 m=1
M20 VB4 VB4 VSS VSS nch l=0.15 w=1 nf=1 m=1
M21 VB1 VB5 VDD VDD pch l=0.15 w=1 nf=1 m=1
M22 VB1 VB1 VSS VSS nch l=0.15 w=1 nf=1 m=1
M23 VB3 VB3 VDD VDD pch l=0.15 w=1 nf=1 m=1
M24 VB3 VB1 VSS VSS nch l=0.15 w=1 nf=1 m=1
M5 net0 VB3 VDD VDD pch l=0.15 w=1 nf=1 m=1
M6 VX INP net0 VDD pch l=0.15 w=1 nf=1 m=1
M7 net2 INN net0 VDD pch l=0.15 w=1 nf=1 m=1
M8 VX VX VSS VSS nch l=0.15 w=1 nf=1 m=1
M9 net2 net2 VSS VSS nch l=0.15 w=1 nf=1 m=1
.ends opamp

.subckt dut VDD VSS vci phi1 phi2 vco
C1 net1 net2 1p
C2 net0 vco 1p
M1 vci phi1 net1 VSS nch l=0.15 w=1 nf=1 m=1
M2 net1 phi2 VSS VSS nch l=0.15 w=1 nf=1 m=1
M3 net2 phi1 VSS VSS nch l=0.15 w=1 nf=1 m=1
M4 net2 phi2 net0 VSS nch l=0.15 w=1 nf=1 m=1
X1 VDD VSS VSS net0 vco opamp
.ends dut
