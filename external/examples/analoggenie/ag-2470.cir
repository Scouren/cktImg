* official Analog Canvas netlist; PDK X cards rewritten by convert.py
.model nch nmos
.model pch pmos

.subckt dut VDD VSS VB1 VB2 VREF VB4 VB6 VB5 VOUT VIN
CF1 VOUT VFB 1p
Cm1 VOUT VO1 1p
Cm2 VO1 net4 1p
M11 net2 VB7 VSS VSS nch l=0.15 w=1 nf=1 m=1
M12 net7 VFB net2 VSS nch l=0.15 w=1 nf=1 m=1
M13 VX VREF net2 VSS nch l=0.15 w=1 nf=1 m=1
M14 net10 net0 VSS VSS nch l=0.15 w=1 nf=1 m=1
M15 net9 net0 VSS VSS nch l=0.15 w=1 nf=1 m=1
M16 VX1 VB4 VIN VDD pch l=0.15 w=1 nf=1 m=1
M17 VX1 VO1 VSS VSS nch l=0.15 w=1 nf=1 m=1
M18 VX1 VX1 VSS VSS nch l=0.15 w=1 nf=1 m=1
M19 net0 VB8 net10 VSS nch l=0.15 w=1 nf=1 m=1
M20 VO1 VB8 net9 VSS nch l=0.15 w=1 nf=1 m=1
M21 net3 VO1 VSS VSS nch l=0.15 w=1 nf=1 m=1
M22 net11 VX1 VSS VSS nch l=0.15 w=1 nf=1 m=1
M23 net3 net3 VIN VDD pch l=0.15 w=1 nf=1 m=1
M24 net11 net3 VIN VDD pch l=0.15 w=1 nf=1 m=1
M25 VX VB1 VIN VDD pch l=0.15 w=1 nf=1 m=1
M26 net7 VB1 VIN VDD pch l=0.15 w=1 nf=1 m=1
M27 net0 VB2 VX VDD pch l=0.15 w=1 nf=1 m=1
M28 VO1 VB2 net7 VDD pch l=0.15 w=1 nf=1 m=1
MB1 net5 net5 VIN VDD pch l=0.15 w=1 nf=1 m=1
MB2 net8 net5 VIN VDD pch l=0.15 w=1 nf=1 m=1
MB3 net5 net8 VSS VSS nch l=0.15 w=1 nf=1 m=1
MB4 net1 net8 VSS VSS nch l=0.15 w=1 nf=1 m=1
MB5 VB8 net5 VIN VDD pch l=0.15 w=1 nf=1 m=1
MB6 VB8 VB8 VB7 VSS nch l=0.15 w=1 nf=1 m=1
MB7 VB7 VB7 VSS VSS nch l=0.15 w=1 nf=1 m=1
MD1 net4 VO1 VSS VSS nch l=0.15 w=1 nf=1 m=1
MD2 net6 VB5 VSS VSS nch l=0.15 w=1 nf=1 m=1
MD3 VX net4 net6 VSS nch l=0.15 w=1 nf=1 m=1
MD4 VX2 VB6 net6 VSS nch l=0.15 w=1 nf=1 m=1
MD5 net4 VX2 VIN VDD pch l=0.15 w=1 nf=1 m=1
MD6 VX VX VIN VDD pch l=0.15 w=1 nf=1 m=1
MD7 VX2 VX2 VIN VDD pch l=0.15 w=1 nf=1 m=1
MPT VOUT net11 VIN VDD pch l=0.15 w=1 nf=1 m=1
RB1 net8 net1 1k
RF1 VOUT VFB 1k
RF2 VFB VSS 1k
.ends dut
