* official Analog Canvas netlist; PDK X cards rewritten by convert.py
.model nch nmos
.model pch pmos
.model qpnp pnp

.subckt A1 VDD VSS INP INN OUT Z
M10 net4 INN INP VSS nch l=0.15 w=1 nf=1 m=1
M11 INP VB4 VSS VSS nch l=0.15 w=1 nf=1 m=1
M12 OUT VB3 net1 VSS nch l=0.15 w=1 nf=1 m=1
M13 Z VB3 net0 VSS nch l=0.15 w=1 nf=1 m=1
M14 net1 Z VSS VSS nch l=0.15 w=1 nf=1 m=1
M15 net0 Z VSS VSS nch l=0.15 w=1 nf=1 m=1
M16 net2 net2 INN VDD pch l=0.15 w=1 nf=1 m=1
M17 VB3 net2 VDD VDD pch l=0.15 w=1 nf=1 m=1
M18 VB3 VB3 VB4 VSS nch l=0.15 w=1 nf=1 m=1
M19 VB4 VB4 VSS VSS nch l=0.15 w=1 nf=1 m=1
M5 net3 VB1 VDD VDD pch l=0.15 w=1 nf=1 m=1
M6 net4 VB1 VDD VDD pch l=0.15 w=1 nf=1 m=1
M7 OUT VB2 net3 VDD pch l=0.15 w=1 nf=1 m=1
M8 Z VB2 net4 VDD pch l=0.15 w=1 nf=1 m=1
M9 net3 INP INP VSS nch l=0.15 w=1 nf=1 m=1
R3 VDD INN 1k
R4 net2 VSS 1k
.ends A1

.subckt dut VSS Vout
M1 X net1 VDD VDD pch l=0.15 w=1 nf=1 m=1
M2 Vout net1 VDD VDD pch l=0.15 w=1 nf=1 m=1
M3 net0 net1 VDD VDD pch l=0.15 w=1 nf=1 m=1
M4 Z net1 VDD VDD pch l=0.15 w=1 nf=1 m=1
Q1 VSS VSS net0 qpnp m=1
Q2 VSS net0 X qpnp m=1
Q3 VSS VSS Z qpnp m=1
Q4 VSS Z net2 qpnp m=1
R1 Y net2 1k
R2 Vout Y 1k
X1 VDD VSS Y X net1 Z A1
.ends dut
