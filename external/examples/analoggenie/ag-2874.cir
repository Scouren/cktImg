* official Analog Canvas netlist; PDK X cards rewritten by convert.py
.model nch nmos
.model pch pmos

.subckt opamp VDD VSS INN vcx INP OUT
M10 VB2 VB4 VDD VDD pch l=0.15 w=1 nf=1 m=1
M11 VB4 VB4 VDD VDD pch l=0.15 w=1 nf=1 m=1
M12 net2 VB4 VDD VDD pch l=0.15 w=1 nf=1 m=1
M13 VB2 VB2 VSS VSS nch l=0.15 w=1 nf=1 m=1
M14 VB4 VB2 net5 VSS nch l=0.15 w=1 nf=1 m=1
M15 net5 net2 VSS VSS nch l=0.15 w=1 nf=1 m=1
M16 net2 net2 VSS VSS nch l=0.15 w=1 nf=1 m=1
M17 net0 VB4 VDD VDD pch l=0.15 w=1 nf=1 m=1
M18 VB1 VB1 VDD VDD pch l=0.15 w=1 nf=1 m=1
M19 VB3 VB1 VDD VDD pch l=0.15 w=1 nf=1 m=1
M20 net0 net0 VSS VSS nch l=0.15 w=1 nf=1 m=1
M21 VB1 net0 VSS VSS nch l=0.15 w=1 nf=1 m=1
M22 VB3 VB3 VSS VSS nch l=0.15 w=1 nf=1 m=1
M3 net4 vcx VDD VDD pch l=0.15 w=1 nf=1 m=1
M4 net1 vcx VDD VDD pch l=0.15 w=1 nf=1 m=1
M5 vcx VC net4 VDD pch l=0.15 w=1 nf=1 m=1
M6 OUT VC net1 VDD pch l=0.15 w=1 nf=1 m=1
M7 vcx INN net3 VSS nch l=0.15 w=1 nf=1 m=1
M8 OUT INP net3 VSS nch l=0.15 w=1 nf=1 m=1
M9 net3 VB3 VSS VSS nch l=0.15 w=1 nf=1 m=1
.ends opamp

.subckt dut VDD VSS vci phi1 phi2 vco
C1 vcx VSS 1p
C2 net0 vco 1p
M1 vci phi1 vcx VSS nch l=0.15 w=1 nf=1 m=1
M2 vcx phi2 net0 VSS nch l=0.15 w=1 nf=1 m=1
X1 VDD VSS net0 vcx VSS vco opamp
.ends dut
