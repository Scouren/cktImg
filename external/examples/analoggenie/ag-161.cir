* official Analog Canvas netlist; PDK X cards rewritten by convert.py
.model nch nmos

.subckt dut VDD VSS Vout
CL Vout VSS 1p
I1 Vout VSS DC 1m
M1 VDD X Vout VSS nch l=0.15 w=1 nf=1 m=1
M2 X Vout VSS VSS nch l=0.15 w=1 nf=1 m=1
RS net0 X 1k
Vin net0 VSS DC 1
.ends dut
