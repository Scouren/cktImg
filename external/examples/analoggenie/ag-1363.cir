* official Analog Canvas netlist; PDK X cards rewritten by convert.py
.model nch nmos
.model pch pmos

.subckt comp VDD VSS VB1 VB2 INN OUT
M10 net4 INN net11 net8 pch l=0.15 w=1 nf=1 m=1
M11 net2 OUT net11 net8 pch l=0.15 w=1 nf=1 m=1
M12 net2 VBN net0 VSS nch l=0.15 w=1 nf=1 m=1
M13 net0 net2 VSS VSS nch l=0.15 w=1 nf=1 m=1
M14 net1 VX VDD VDD pch l=0.15 w=1 nf=1 m=1
M15 VX VB1 net1 VDD pch l=0.15 w=1 nf=1 m=1
M16 VX VBN net5 VSS nch l=0.15 w=1 nf=1 m=1
M17 net5 net2 VSS VSS nch l=0.15 w=1 nf=1 m=1
M18 VBN net7 VDD VDD pch l=0.15 w=1 nf=1 m=1
M19 net7 net7 VDD VDD pch l=0.15 w=1 nf=1 m=1
M20 VB3 net7 VDD VDD pch l=0.15 w=1 nf=1 m=1
M21 net7 VB3 VSS VSS nch l=0.15 w=1 nf=1 m=1
M22 VB3 VB3 VSS VSS nch l=0.15 w=1 nf=1 m=1
M23 VBN VBN net6 VSS nch l=0.15 w=1 nf=1 m=1
M24 net6 VBN VSS VSS nch l=0.15 w=1 nf=1 m=1
M3 net3 VX VDD VDD pch l=0.15 w=1 nf=1 m=1
M4 OUT VB1 net3 VDD pch l=0.15 w=1 nf=1 m=1
M5 OUT VBN net9 VSS nch l=0.15 w=1 nf=1 m=1
M6 net9 net4 VSS VSS nch l=0.15 w=1 nf=1 m=1
M7 net4 VBN net10 VSS nch l=0.15 w=1 nf=1 m=1
M8 net10 net4 VSS VSS nch l=0.15 w=1 nf=1 m=1
M9 net11 VB2 VDD VDD pch l=0.15 w=1 nf=1 m=1
.ends comp

.subckt dut VDD VSS VSTO VCONT1 VCONT2 VCONT3 VOUT VB1 VB2
CL VOUT VSS 1p
CSTO VSTO VSS 1p
LRX net0 net1 1n
MN1 net0 VCONT2 VSS VSS nch l=0.15 w=1 nf=1 m=1
MN2 net1 VCONT3 VSS VSS nch l=0.15 w=1 nf=1 m=1
MP2 net1 net2 VOUT VOUT pch l=0.15 w=1 nf=1 m=1
MP3 net0 VCONT1 VSTO VSTO pch l=0.15 w=1 nf=1 m=1
X1 VDD VSS VB1 VB2 net1 net2 comp
.ends dut
