* official Analog Canvas netlist; PDK X cards rewritten by convert.py
.model qpnp pnp

.subckt icm_opamp_vdd_vss VDD VSS VIP VIN VOUT params: gain=1e6
Blin nlin 0 V={gain*(V(VIP)-V(VIN))}
Bcore VOUT 0 V={0.5*(V(VDD)+(0.5*(V(VSS)+V(nlin)+sqrt((V(nlin)-V(VSS))*(V(nlin)-V(VSS))+(1e-4*(V(VDD)-V(VSS)))*(1e-4*(V(VDD)-V(VSS)))+1e-12)))-sqrt((V(VDD)-(0.5*(V(VSS)+V(nlin)+sqrt((V(nlin)-V(VSS))*(V(nlin)-V(VSS))+(1e-4*(V(VDD)-V(VSS)))*(1e-4*(V(VDD)-V(VSS)))+1e-12))))*(V(VDD)-(0.5*(V(VSS)+V(nlin)+sqrt((V(nlin)-V(VSS))*(V(nlin)-V(VSS))+(1e-4*(V(VDD)-V(VSS)))*(1e-4*(V(VDD)-V(VSS)))+1e-12))))+(1e-4*(V(VDD)-V(VSS)))*(1e-4*(V(VDD)-V(VSS)))+1e-12))}
.ends icm_opamp_vdd_vss

.subckt dut VDD VSS Vref phi1 phi2
.model ideal_switch SW(RON=1 ROFF=1e12 VT=0.5 VH=0)
C1 net5 net0 1p
C2 net0 net1 1p
C3 net3 Vref 1p
C4 net6 net0 1p
I1 VDD net4 DC 1m
I2 VDD net2 DC 1m
Q1 VSS VSS net4 qpnp m=1
Q2 VSS VSS net2 qpnp m=1
S1 net4 net6 phi1 VSS ideal_switch
S2 net6 net2 phi2 VSS ideal_switch
S3 net4 net5 phi1 VSS ideal_switch
S4 net5 VSS phi2 VSS ideal_switch
S5 net1 VSS phi1 VSS ideal_switch
S6 net1 Vref phi2 VSS ideal_switch
S7 net0 net3 phi1 VSS ideal_switch
S8 net3 VSS phi2 VSS ideal_switch
X1 VDD VSS VSS net0 Vref icm_opamp_vdd_vss gain=1e6
.ends dut
