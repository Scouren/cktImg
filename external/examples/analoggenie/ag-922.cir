* official Analog Canvas netlist; PDK X cards rewritten by convert.py
.model nch nmos
.model pch pmos

.subckt dut VDD VSS Vo1 Vo2 Vi1 Vi2 VBIAS IB1 IB2 VB2 VCM1 IB3
M1 Vo1 Vi1 net2 VSS nch l=0.15 w=1 nf=1 m=1
M10 net3 net3 VSS VSS nch l=0.15 w=1 nf=1 m=1
M11 VDD Vo1 IB1 VSS nch l=0.15 w=1 nf=1 m=1
M12 VDD Vo2 IB2 VSS nch l=0.15 w=1 nf=1 m=1
M13 net1 VCM1 IB3 VSS nch l=0.15 w=1 nf=1 m=1
M2 Vo2 Vi2 net2 VSS nch l=0.15 w=1 nf=1 m=1
M3 Vo1 VBIAS VDD VDD pch l=0.15 w=1 nf=1 m=1
M4 Vo2 VBIAS VDD VDD pch l=0.15 w=1 nf=1 m=1
M5 net2 Vcmc VSS VSS nch l=0.15 w=1 nf=1 m=1
M6 net0 VB2 VDD VDD pch l=0.15 w=1 nf=1 m=1
M7 Vcmc IB3 net0 VDD pch l=0.15 w=1 nf=1 m=1
M8 net3 net1 net0 VDD pch l=0.15 w=1 nf=1 m=1
M9 Vcmc Vcmc VSS VSS nch l=0.15 w=1 nf=1 m=1
R1 VDD net1 1k
R2 VDD net1 1k
.ends dut
