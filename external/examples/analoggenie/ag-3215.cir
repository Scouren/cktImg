* official Analog Canvas netlist; PDK X cards rewritten by convert.py
.model nch nmos
.model pch pmos

.subckt opamp VDD VSS INN INP OUT
M10 net4 net3 VDD VDD pch l=0.15 w=1 nf=1 m=1
M11 OUT net1 VDD VDD pch l=0.15 w=1 nf=1 m=1
M12 net4 net4 VSS VSS nch l=0.15 w=1 nf=1 m=1
M13 OUT net4 VSS VSS nch l=0.15 w=1 nf=1 m=1
M14 VB1 net2 VDD VDD pch l=0.15 w=1 nf=1 m=1
M15 VB1 VB1 VSS VSS nch l=0.15 w=1 nf=1 m=1
M16 net2 net2 net0 VDD pch l=0.15 w=1 nf=1 m=1
M5 net3 INN net5 VSS nch l=0.15 w=1 nf=1 m=1
M6 net1 INP net5 VSS nch l=0.15 w=1 nf=1 m=1
M7 net5 VB1 VSS VSS nch l=0.15 w=1 nf=1 m=1
M8 net3 net3 VDD VDD pch l=0.15 w=1 nf=1 m=1
M9 net1 net1 VDD VDD pch l=0.15 w=1 nf=1 m=1
R1 VDD net0 1k
R2 net2 VSS 1k
.ends opamp

.subckt dut VDD VSS vci phi1 phi2 vco
C1 net0 net1 1p
C2 net2 vco 1p
M1 vci phi1 net0 VSS nch l=0.15 w=1 nf=1 m=1
M2 net0 phi2 VSS VSS nch l=0.15 w=1 nf=1 m=1
M3 net1 phi1 VSS VSS nch l=0.15 w=1 nf=1 m=1
M4 net1 phi2 net2 VSS nch l=0.15 w=1 nf=1 m=1
X1 VDD VSS net2 VSS vco opamp
.ends dut
