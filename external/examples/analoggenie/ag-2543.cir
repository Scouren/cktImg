* official Analog Canvas netlist; PDK X cards rewritten by convert.py
.model nch nmos
.model pch pmos

.subckt dut VDD VSS Vref biasp biascas biasn Vout VB2
C1 Vset VSS 1p
C2 n3 Vout 1p
M1 Vout n3 VDD VDD pch l=0.15 w=1 nf=1 m=1
M10 net3 VB1 net4 VDD pch l=0.15 w=1 nf=1 m=1
M11 n3 VB1 net7 VDD pch l=0.15 w=1 nf=1 m=1
M12 net8 VB1 net2 VDD pch l=0.15 w=1 nf=1 m=1
M13 Vset VB1 net1 VDD pch l=0.15 w=1 nf=1 m=1
M14 n3 fb net0 VSS nch l=0.15 w=1 nf=1 m=1
M15 net8 Vref net0 VSS nch l=0.15 w=1 nf=1 m=1
M16 net0 VB2 VSS VSS nch l=0.15 w=1 nf=1 m=1
M17 net3 VBN net9 VSS nch l=0.15 w=1 nf=1 m=1
M18 net9 net3 VSS VSS nch l=0.15 w=1 nf=1 m=1
M19 Vset VBN net6 VSS nch l=0.15 w=1 nf=1 m=1
M2 n1 Vset Vout VDD pch l=0.15 w=1 nf=1 m=1
M20 net6 net3 VSS VSS nch l=0.15 w=1 nf=1 m=1
M21 VBN net5 VDD VDD pch l=0.15 w=1 nf=1 m=1
M22 net5 net5 VDD VDD pch l=0.15 w=1 nf=1 m=1
M23 VBN VBN net10 VSS nch l=0.15 w=1 nf=1 m=1
M24 net10 VBN VSS VSS nch l=0.15 w=1 nf=1 m=1
M3 n1 biasn VSS VSS nch l=0.15 w=1 nf=1 m=1
M4 n3 biasp VDD VDD pch l=0.15 w=1 nf=1 m=1
M5 n3 biascas n1 VSS nch l=0.15 w=1 nf=1 m=1
M6 net4 n3 VDD VDD pch l=0.15 w=1 nf=1 m=1
M7 net7 n3 VDD VDD pch l=0.15 w=1 nf=1 m=1
M8 net2 net8 VDD VDD pch l=0.15 w=1 nf=1 m=1
M9 net1 net8 VDD VDD pch l=0.15 w=1 nf=1 m=1
R1 fb VSS 1k
R2 Vout fb 1k
R3 net5 VSS 1k
.ends dut
