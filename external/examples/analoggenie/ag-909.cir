* official Analog Canvas netlist; PDK X cards rewritten by convert.py
.model nch nmos
.model pch pmos

.subckt dut VDD VSS IB1 VIN1 VIN2 VOUT1
C net1 VOUT1 1p
CL VOUT1 VSS 1p
M1 net3 VIN1 net2 VDD pch l=0.15 w=1 nf=1 m=1
M2 net0 VIN2 net2 VDD pch l=0.15 w=1 nf=1 m=1
M3 net3 net3 VSS VSS nch l=0.15 w=1 nf=1 m=1
M4 net0 net3 VSS VSS nch l=0.15 w=1 nf=1 m=1
M5 net2 IB1 VDD VDD pch l=0.15 w=1 nf=1 m=1
M6 VOUT1 net0 VSS VSS nch l=0.15 w=1 nf=1 m=1
M7 VOUT1 IB1 VDD VDD pch l=0.15 w=1 nf=1 m=1
M8 IB1 IB1 VDD VDD pch l=0.15 w=1 nf=1 m=1
RZ net0 net1 1k
.ends dut
