* official Analog Canvas netlist; PDK X cards rewritten by convert.py
.model nch nmos
.model pch pmos

.subckt opamp VDD VSS IN- IN+ OUT
M10 net4 net2 VSS VSS nch l=0.15 w=1 nf=1 m=1
M11 OUT net5 VSS VSS nch l=0.15 w=1 nf=1 m=1
M12 net4 net4 VDD VDD pch l=0.15 w=1 nf=1 m=1
M13 OUT net4 VDD VDD pch l=0.15 w=1 nf=1 m=1
M14 VB1 VB1 VDD VDD pch l=0.15 w=1 nf=1 m=1
M15 VB1 net3 VSS VSS nch l=0.15 w=1 nf=1 m=1
M16 net3 net3 VSS VSS nch l=0.15 w=1 nf=1 m=1
M17 net1 net3 VSS VSS nch l=0.15 w=1 nf=1 m=1
M5 net0 VB1 VDD VDD pch l=0.15 w=1 nf=1 m=1
M6 net2 IN+ net0 VDD pch l=0.15 w=1 nf=1 m=1
M7 net5 IN- net0 VDD pch l=0.15 w=1 nf=1 m=1
M8 net2 net2 VSS VSS nch l=0.15 w=1 nf=1 m=1
M9 net5 net5 VSS VSS nch l=0.15 w=1 nf=1 m=1
R1 VDD net3 1k
R2 VDD net1 1k
R3 net3 net1 1k
.ends opamp

.subckt dut VDD VSS vci phi1 phi2 vco
C1 net1 net2 1p
C2 net0 vco 1p
M1 vci phi1 net1 VSS nch l=0.15 w=1 nf=1 m=1
M2 net1 phi2 VSS VSS nch l=0.15 w=1 nf=1 m=1
M3 net2 phi1 VSS VSS nch l=0.15 w=1 nf=1 m=1
M4 net2 phi2 net0 VSS nch l=0.15 w=1 nf=1 m=1
X1 VDD VSS net0 VSS vco opamp
.ends dut
