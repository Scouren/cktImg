* official Analog Canvas netlist; PDK X cards rewritten by convert.py
.model nch nmos
.model pch pmos

.subckt dut VDD VSS phi1 vin+ vin- vout+ vout-
VB1 net2 VSS DC 1
VB2 net3 VSS DC 1
M10 vout+ phi1 VDD VDD pch l=0.15 w=1 nf=1 m=1
M1A net5 vin+ VSS VSS nch l=0.15 w=1 nf=1 m=1
M1B net4 vin- VSS VSS nch l=0.15 w=1 nf=1 m=1
M2A net5 net2 VSS VSS nch l=0.15 w=1 nf=1 m=1
M2B net4 net3 VSS VSS nch l=0.15 w=1 nf=1 m=1
M3 net1 vout+ net5 VSS nch l=0.15 w=1 nf=1 m=1
M4 net0 vout- net4 VSS nch l=0.15 w=1 nf=1 m=1
M5 vout- phi1 net1 VSS nch l=0.15 w=1 nf=1 m=1
M6 vout+ phi1 net0 VSS nch l=0.15 w=1 nf=1 m=1
M7 vout- vout+ VDD VDD pch l=0.15 w=1 nf=1 m=1
M8 vout+ vout- VDD VDD pch l=0.15 w=1 nf=1 m=1
M9 vout- phi1 VDD VDD pch l=0.15 w=1 nf=1 m=1
.ends dut
