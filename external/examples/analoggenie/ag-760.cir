* official Analog Canvas netlist; PDK X cards rewritten by convert.py
.model nch nmos

.subckt opamp VDD VSS VIP VIN VOUT params: gain=1e6 vhigh=5 vlow=-5
Blin nlin 0 V={gain*(V(VIP)-V(VIN))}
Bcore VOUT 0 V={0.5*(vhigh+(0.5*(vlow+V(nlin)+sqrt((V(nlin)-vlow)*(V(nlin)-vlow)+(1e-4*(vhigh-vlow))*(1e-4*(vhigh-vlow))+1e-12)))-sqrt((vhigh-(0.5*(vlow+V(nlin)+sqrt((V(nlin)-vlow)*(V(nlin)-vlow)+(1e-4*(vhigh-vlow))*(1e-4*(vhigh-vlow))+1e-12))))*(vhigh-(0.5*(vlow+V(nlin)+sqrt((V(nlin)-vlow)*(V(nlin)-vlow)+(1e-4*(vhigh-vlow))*(1e-4*(vhigh-vlow))+1e-12))))+(1e-4*(vhigh-vlow))*(1e-4*(vhigh-vlow))+1e-12))}
.ends opamp

.subckt voltage_amplifier VDD VSS VIN VOUT params: gain=1
ECORE VOUT 0 VIN 0 {gain}
.ends voltage_amplifier

.subckt dut VSS Vin Vout phi1 phi2 phi1p
C1 net0 net5 1p
C2 net4 net2 1p
C3 net1 VSS 1p
M1 Vin phi1 net3 VSS nch l=0.15 w=1 nf=1 m=1
M2 net3 phi2 Vout VSS nch l=0.15 w=1 nf=1 m=1
M3 net0 phi1 net4 VSS nch l=0.15 w=1 nf=1 m=1
M4 net5 phi1p net2 VSS nch l=0.15 w=1 nf=1 m=1
M5 net1 phi1p VSS VSS nch l=0.15 w=1 nf=1 m=1
X1 0 VSS net3 net0 voltage_amplifier gain=1
X2 0 VSS net4 Vout voltage_amplifier gain=1
X3 0 VSS net1 net5 net2 opamp gain=1e6
.ends dut
