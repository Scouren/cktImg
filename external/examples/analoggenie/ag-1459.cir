* official Analog Canvas netlist; PDK X cards rewritten by convert.py
.model nch nmos
.model pch pmos

.subckt dut VDD VSS VSTO VC1 VC2 VC3 VOUT VB1 VB2
CL VOUT VSS 1p
CSTO VSTO VSS 1p
LRX net0 VX 1n
M10 net4 net1 VSS VSS nch l=0.15 w=1 nf=1 m=1
M11 VB1 net3 VDD VDD pch l=0.15 w=1 nf=1 m=1
M12 net3 net3 VDD VDD pch l=0.15 w=1 nf=1 m=1
M13 VX net3 VDD VDD pch l=0.15 w=1 nf=1 m=1
M14 net2 VB2 VDD VDD pch l=0.15 w=1 nf=1 m=1
M15 VB2 VB2 VDD VDD pch l=0.15 w=1 nf=1 m=1
M16 VB1 VB1 VSS VSS nch l=0.15 w=1 nf=1 m=1
M17 net3 net2 VSS VSS nch l=0.15 w=1 nf=1 m=1
M18 net2 net2 VSS VSS nch l=0.15 w=1 nf=1 m=1
M19 VB2 net2 VSS VSS nch l=0.15 w=1 nf=1 m=1
M3 VG2 net4 VDD VDD pch l=0.15 w=1 nf=1 m=1
M4 net4 net4 VDD VDD pch l=0.15 w=1 nf=1 m=1
M5 net5 VX VX VDD pch l=0.15 w=1 nf=1 m=1
M6 net1 VG2 VX VDD pch l=0.15 w=1 nf=1 m=1
M7 VG2 net5 VSS VSS nch l=0.15 w=1 nf=1 m=1
M8 net5 net5 VSS VSS nch l=0.15 w=1 nf=1 m=1
M9 net1 net1 VSS VSS nch l=0.15 w=1 nf=1 m=1
MN1 net0 VC2 VSS VSS nch l=0.15 w=1 nf=1 m=1
MN2 VX VC3 VSS VSS nch l=0.15 w=1 nf=1 m=1
MP2 VX VG2 VOUT VDD pch l=0.15 w=1 nf=1 m=1
MP3 net0 VC1 VSTO VDD pch l=0.15 w=1 nf=1 m=1
.ends dut
