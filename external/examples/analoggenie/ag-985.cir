* official Analog Canvas netlist; PDK X cards rewritten by convert.py
.model nch nmos
.model pch pmos

.subckt dut VDD VSS GND Vinn Vinp VNB1 VPB2 VNB2 vout
CL vout GND 1p
M1 net1 Vinn net0 VSS nch l=0.15 w=1 nf=1 m=1
M10 net2 net3 VSS VSS nch l=0.15 w=1 nf=1 m=1
M11 net4 net3 VSS VSS nch l=0.15 w=1 nf=1 m=1
M12 vout VNB2 net4 VSS nch l=0.15 w=1 nf=1 m=1
M2 net6 Vinp net0 VSS nch l=0.15 w=1 nf=1 m=1
M3 net1 net1 VDD VDD pch l=0.15 w=1 nf=1 m=1
M4 net6 net6 VDD VDD pch l=0.15 w=1 nf=1 m=1
M5 net0 VNB1 VSS VSS nch l=0.15 w=1 nf=1 m=1
M6 net5 net6 VDD VDD pch l=0.15 w=1 nf=1 m=1
M7 vout VPB2 net5 VDD pch l=0.15 w=1 nf=1 m=1
M8 net3 net1 VDD VDD pch l=0.15 w=1 nf=1 m=1
M9 net3 VNB2 net2 VSS nch l=0.15 w=1 nf=1 m=1
.ends dut
