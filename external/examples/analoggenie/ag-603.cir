* official Analog Canvas netlist; PDK X cards rewritten by convert.py
.model nch nmos
.model pch pmos

.subckt dut VDD VSS VCONT1 VCONT2 VCONT3 VCONT4
C0 VDD net4 2pF
C1 net3 VSS 1pF
I1 VDD net3 DC 0.4mA
I2 net4 VSS DC 0.4mA
M1 net1 net0 VDD VDD pch l=0.15 w=1 nf=1 m=1
M2 net1 net2 VSS VSS nch l=0.15 w=1 nf=1 m=1
M3 net0 VCONT1 net4 VDD pch l=0.15 w=1 nf=1 m=1
M4 net3 VCONT3 net2 VSS nch l=0.15 w=1 nf=1 m=1
MD net2 VCONT4 VSS VSS nch l=0.15 w=1 nf=1 m=1
MN4 net3 net3 VSS VSS nch l=0.15 w=1 nf=1 m=1
MP0 net4 net4 VDD VDD pch l=0.15 w=1 nf=1 m=1
MU net0 VCONT2 VDD VDD pch l=0.15 w=1 nf=1 m=1
.ends dut
