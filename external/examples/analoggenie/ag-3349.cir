* official Analog Canvas netlist; PDK X cards rewritten by convert.py
.model nch nmos
.model pch pmos

.subckt dut VDD VSS vci phi1 phi2 vco
C1 net3 net4 1p
C2 net1 vco 1p
M1 vci phi1 net3 VSS nch l=0.15 w=1 nf=1 m=1
M10 VB1 net0 VDD VDD pch l=0.15 w=1 nf=1 m=1
M11 net0 net0 VDD VDD pch l=0.15 w=1 nf=1 m=1
M12 net5 net0 VDD VDD pch l=0.15 w=1 nf=1 m=1
M13 VB3 VB3 VDD VDD pch l=0.15 w=1 nf=1 m=1
M14 VB2 VB3 VDD VDD pch l=0.15 w=1 nf=1 m=1
M15 net2 VB1 VSS VSS nch l=0.15 w=1 nf=1 m=1
M16 net0 VB1 VSS VSS nch l=0.15 w=1 nf=1 m=1
M17 net5 net5 VSS VSS nch l=0.15 w=1 nf=1 m=1
M18 VB3 net5 VSS VSS nch l=0.15 w=1 nf=1 m=1
M19 VB2 VB2 VSS VSS nch l=0.15 w=1 nf=1 m=1
M2 net3 phi2 VSS VSS nch l=0.15 w=1 nf=1 m=1
M3 net4 phi1 VSS VSS nch l=0.15 w=1 nf=1 m=1
M4 net4 phi2 net1 VSS nch l=0.15 w=1 nf=1 m=1
M5 VB3 net1 net6 VSS nch l=0.15 w=1 nf=1 m=1
M6 vco VSS net6 VSS nch l=0.15 w=1 nf=1 m=1
M7 VB3 VB3 VDD VDD pch l=0.15 w=1 nf=1 m=1
M8 vco VB3 VDD VDD pch l=0.15 w=1 nf=1 m=1
M9 net6 VB2 VSS VSS nch l=0.15 w=1 nf=1 m=1
R1 VB1 net2 1k
.ends dut
