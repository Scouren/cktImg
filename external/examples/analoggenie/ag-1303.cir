* official Analog Canvas netlist; PDK X cards rewritten by convert.py
.model nch nmos
.model pch pmos

.subckt EA1 VDD VSS INP INN OUT VX2
MN1 VX2 VX2 VSS VSS nch l=0.15 w=1 nf=1 m=1
MN2 net3 net3 VSS VSS nch l=0.15 w=1 nf=1 m=1
MN3 net2 VX2 VSS VSS nch l=0.15 w=1 nf=1 m=1
MN4 OUT net3 VSS VSS nch l=0.15 w=1 nf=1 m=1
MN5 VBP net1 VSS VSS nch l=0.15 w=1 nf=1 m=1
MN6 VB1 VB1 VSS VSS nch l=0.15 w=1 nf=1 m=1
MN7 net1 net1 VSS VSS nch l=0.15 w=1 nf=1 m=1
MN8 net4 net1 VSS VSS nch l=0.15 w=1 nf=1 m=1
MP1 net0 VBP VDD VDD pch l=0.15 w=1 nf=1 m=1
MP2 VX2 INP net0 VDD pch l=0.15 w=1 nf=1 m=1
MP3 net3 INN net0 VDD pch l=0.15 w=1 nf=1 m=1
MP4 net2 net2 VDD VDD pch l=0.15 w=1 nf=1 m=1
MP5 OUT net2 VDD VDD pch l=0.15 w=1 nf=1 m=1
MP6 VBP VBP VDD VDD pch l=0.15 w=1 nf=1 m=1
MP7 VB1 VBP VDD VDD pch l=0.15 w=1 nf=1 m=1
RB1 VDD net4 1k
RB2 net4 net1 1k
RBIAS VDD net1 1k
.ends EA1

.subckt dut VDD VSS VIN VP VCONT1 VCONT2 VCONT3 VCONT4 VCONT5 VB2 VREF
.model DIODE D(IS=1e-14 N=1)
CFLY VX1 VX2 1p
CO VP VN 1p
COP VP VSS 1p
D1 VN VX2 DIODE
L1 VX1 VX3 1n
M1 VX1 VCONT2 VIN VDD pch l=0.15 w=1 nf=1 m=1
M10 net0 net0 net3 VDD pch l=0.15 w=1 nf=1 m=1
M11 VX1 net0 net3 VDD pch l=0.15 w=1 nf=1 m=1
M2 VX2 VCONT3 VIN VDD pch l=0.15 w=1 nf=1 m=1
M3 VP VCONT5 VX3 VDD pch l=0.15 w=1 nf=1 m=1
M4 VX3 VCONT4 VSS VSS nch l=0.15 w=1 nf=1 m=1
M5 net3 VCONT1 VIN VDD pch l=0.15 w=1 nf=1 m=1
M6 net1 net2 net3 VDD pch l=0.15 w=1 nf=1 m=1
M7 net1 net1 VSS VSS nch l=0.15 w=1 nf=1 m=1
M8 net1 VB2 VSS VSS nch l=0.15 w=1 nf=1 m=1
M9 net0 net1 VSS VSS nch l=0.15 w=1 nf=1 m=1
R1 VP VFP1 1k
R2 VFP1 VSS 1k
X1 VDD VSS VREF VFP1 net2 VX2 EA1
.ends dut
