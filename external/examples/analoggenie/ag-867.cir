* official Analog Canvas netlist; PDK X cards rewritten by convert.py
.model nch nmos
.model pch pmos
.model qpnp pnp

.subckt dut VDD VSS
M1 net2 net2 net1 VSS nch l=0.15 w=1 nf=1 m=1
M2 net0 net2 net3 VSS nch l=0.15 w=1 nf=1 m=1
M3 net2 net0 VDD VDD pch l=0.15 w=1 nf=1 m=1
M4 net0 net0 VDD VDD pch l=0.15 w=1 nf=1 m=1
Q1 VSS VSS net3 qpnp m=10
Q2 VSS VSS net1 qpnp m=1
.ends dut
