* official Analog Canvas netlist; PDK X cards rewritten by convert.py
.model nch nmos
.model pch pmos

.subckt dut VDD VSS VIN VCONT1 VCONT2 VCONT3 VCONT4 VCONT5 VP VB2 VREF
.model DIODE D(IS=1e-14 N=1)
CFLY VX1 VX2 1p
CO VP VN 1p
COP VP VSS 1p
D1 VN VX2 DIODE
L1 VX1 VX3 1n
M1 VX1 VCONT2 VIN VDD pch l=0.15 w=1 nf=1 m=1
M2 VX2 VCONT3 VIN VDD pch l=0.15 w=1 nf=1 m=1
M3 VP VCONT5 VX3 VDD pch l=0.15 w=1 nf=1 m=1
M4 VX3 VCONT4 VSS VSS nch l=0.15 w=1 nf=1 m=1
M5 VA VCONT1 VIN VDD pch l=0.15 w=1 nf=1 m=1
MN1 net1 VFP1 net0 VSS nch l=0.15 w=1 nf=1 m=1
MN10 VBP VB1 VX2 VSS nch l=0.15 w=1 nf=1 m=1
MN11 VB1 VB1 VSS VSS nch l=0.15 w=1 nf=1 m=1
MN12 VA VA VSS VSS nch l=0.15 w=1 nf=1 m=1
MN13 VX2 VA VSS VSS nch l=0.15 w=1 nf=1 m=1
MN2 VX3 VREF net0 VSS nch l=0.15 w=1 nf=1 m=1
MN3 net0 VBN VSS VSS nch l=0.15 w=1 nf=1 m=1
MN4 net2 net2 VSS VSS nch l=0.15 w=1 nf=1 m=1
MN5 VEA net2 VSS VSS nch l=0.15 w=1 nf=1 m=1
MN6 VG net3 VSS VSS nch l=0.15 w=1 nf=1 m=1
MN7 net3 net3 VSS VSS nch l=0.15 w=1 nf=1 m=1
MN8 net3 VB2 VSS VSS nch l=0.15 w=1 nf=1 m=1
MN9 VBN VBN VSS VSS nch l=0.15 w=1 nf=1 m=1
MP1 net2 net1 VDD VDD pch l=0.15 w=1 nf=1 m=1
MP10 VB1 VBP VDD VDD pch l=0.15 w=1 nf=1 m=1
MP11 VA VBP VDD VDD pch l=0.15 w=1 nf=1 m=1
MP2 net1 net1 VDD VDD pch l=0.15 w=1 nf=1 m=1
MP3 VX3 VX3 VDD VDD pch l=0.15 w=1 nf=1 m=1
MP4 VEA VX3 VDD VDD pch l=0.15 w=1 nf=1 m=1
MP5 VG VG VA VDD pch l=0.15 w=1 nf=1 m=1
MP6 VX1 VG VA VDD pch l=0.15 w=1 nf=1 m=1
MP7 net3 VEA VA VDD pch l=0.15 w=1 nf=1 m=1
MP8 VBN VBP VDD VDD pch l=0.15 w=1 nf=1 m=1
MP9 VBP VBP VDD VDD pch l=0.15 w=1 nf=1 m=1
R1 VP VFP1 1k
R2 VFP1 VSS 1k
.ends dut
