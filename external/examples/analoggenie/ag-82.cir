* official Analog Canvas netlist; PDK X cards rewritten by convert.py
.model nch nmos

.subckt dut VDD VSS Vcont+ Vcont- Vin+ Vin- Vout1 Vout2
ISS net0 VSS DC 1m
M1 Vout1 Vcont+ net1 VSS nch l=0.15 w=1 nf=1 m=1
M2 Vout2 Vcont- net1 VSS nch l=0.15 w=1 nf=1 m=1
M3 Vout2 Vcont+ net2 VSS nch l=0.15 w=1 nf=1 m=1
M4 Vout1 Vcont- net2 VSS nch l=0.15 w=1 nf=1 m=1
M5 net1 Vin+ net0 VSS nch l=0.15 w=1 nf=1 m=1
M6 net2 Vin- net0 VSS nch l=0.15 w=1 nf=1 m=1
RD1 VDD Vout1 1k
RD2 VDD Vout2 1k
.ends dut
