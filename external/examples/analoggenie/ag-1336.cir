* official Analog Canvas netlist; PDK X cards rewritten by convert.py
.model nch nmos
.model pch pmos

.subckt dut VDD VSS VS5 VS1 VS2 VS4 VS3 VIN VP VB3 VREF VB1 VB2
.model DIODE D(IS=1e-14 N=1)
CFLY VX1 VX2 1p
CO VP VN 1p
COP VP VSS 1p
D1 VN VX2 DIODE
L1 VX1 VX3 1n
M1 VX1 VS1 VIN VDD pch l=0.15 w=1 nf=1 m=1
M10 VX2 VX2 VSS VSS nch l=0.15 w=1 nf=1 m=1
M11 VEA net3 VSS VSS nch l=0.15 w=1 nf=1 m=1
M12 net4 VX2 VSS VSS nch l=0.15 w=1 nf=1 m=1
M13 net4 net4 VDD VDD pch l=0.15 w=1 nf=1 m=1
M14 VEA net4 VDD VDD pch l=0.15 w=1 nf=1 m=1
M15 VB2 net0 VDD VDD pch l=0.15 w=1 nf=1 m=1
M16 VB2 VB2 VSS VSS nch l=0.15 w=1 nf=1 m=1
M17 net0 net0 VDD VDD pch l=0.15 w=1 nf=1 m=1
M18 net0 VB2 VSS VSS nch l=0.15 w=1 nf=1 m=1
M19 net5 net0 VDD VDD pch l=0.15 w=1 nf=1 m=1
M2 VX2 VS2 VIN VDD pch l=0.15 w=1 nf=1 m=1
M20 net5 net5 VSS VSS nch l=0.15 w=1 nf=1 m=1
M21 VBP VBP VDD VDD pch l=0.15 w=1 nf=1 m=1
M22 VBP net5 VSS VSS nch l=0.15 w=1 nf=1 m=1
M23 VB1 VBP VDD VDD pch l=0.15 w=1 nf=1 m=1
M24 VB1 VB1 VSS VSS nch l=0.15 w=1 nf=1 m=1
M25 VX1 net6 net7 VDD pch l=0.15 w=1 nf=1 m=1
M26 net6 net6 net7 VDD pch l=0.15 w=1 nf=1 m=1
M27 net6 net1 VSS VSS nch l=0.15 w=1 nf=1 m=1
M28 net1 net1 VSS VSS nch l=0.15 w=1 nf=1 m=1
M29 net1 VEA net7 VDD pch l=0.15 w=1 nf=1 m=1
M3 VX3 VS3 VP VDD pch l=0.15 w=1 nf=1 m=1
M30 net1 VB3 VSS VSS nch l=0.15 w=1 nf=1 m=1
M4 VX3 VS4 VSS VSS nch l=0.15 w=1 nf=1 m=1
M5 net7 VS5 VIN VDD pch l=0.15 w=1 nf=1 m=1
M6 net3 VFP1 net2 VDD pch l=0.15 w=1 nf=1 m=1
M7 VX2 VREF net2 VDD pch l=0.15 w=1 nf=1 m=1
M8 net2 VBP VDD VDD pch l=0.15 w=1 nf=1 m=1
M9 net3 net3 VSS VSS nch l=0.15 w=1 nf=1 m=1
R1 VP VFP1 1k
R2 VFP1 VSS 1k
.ends dut
