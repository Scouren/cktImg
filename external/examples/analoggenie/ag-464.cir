* official Analog Canvas netlist; PDK X cards rewritten by convert.py
.model nch nmos

.subckt dut VDD VSS Vin Vout
C1 Vout VSS 1p
CF Vin Vout 1p
L1 VDD Vout 1n
LF Vin Vout 1n
M1 Vout Vin VSS VSS nch l=0.15 w=1 nf=1 m=1
.ends dut
