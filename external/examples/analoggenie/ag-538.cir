* official Analog Canvas netlist; PDK X cards rewritten by convert.py
.model nch nmos

.subckt dut VDD VSS Vb
C1 net1 net4 1p
C2 net2 net3 1p
CT net0 VSS 1p
In net0 VSS DC 1m
ISS net0 VSS DC 1m
L1 VDD net1 1n
L2 VDD net3 1n
M1 net1 net2 net0 VSS nch l=0.15 w=1 nf=1 m=1
M2 net3 net4 net0 VSS nch l=0.15 w=1 nf=1 m=1
R1 net4 Vb 1k
R2 net2 Vb 1k
.ends dut
