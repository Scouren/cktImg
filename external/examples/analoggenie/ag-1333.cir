* official Analog Canvas netlist; PDK X cards rewritten by convert.py
.model nch nmos
.model pch pmos

.subckt EA VDD VSS INP INN VX2 OUT
MN1 net9 net9 VSS VSS nch l=0.15 w=1 nf=1 m=1
MN10 net3 net3 net8 VSS nch l=0.15 w=1 nf=1 m=1
MN11 net8 net3 net0 VSS nch l=0.15 w=1 nf=1 m=1
MN12 net0 net0 VSS VSS nch l=0.15 w=1 nf=1 m=1
MN2 VX2 VX2 VSS VSS nch l=0.15 w=1 nf=1 m=1
MN3 OUT net9 VSS VSS nch l=0.15 w=1 nf=1 m=1
MN4 net5 VX2 VSS VSS nch l=0.15 w=1 nf=1 m=1
MN5 VBP net1 VSS VSS nch l=0.15 w=1 nf=1 m=1
MN6 net1 net1 VSS VSS nch l=0.15 w=1 nf=1 m=1
MN7 VBN net7 VSS VSS nch l=0.15 w=1 nf=1 m=1
MN8 net2 net2 net7 VSS nch l=0.15 w=1 nf=1 m=1
MN9 net7 net2 net8 VSS nch l=0.15 w=1 nf=1 m=1
MP1 net4 VBP VDD VDD pch l=0.15 w=1 nf=1 m=1
MP10 net3 VBN VDD VDD pch l=0.15 w=1 nf=1 m=1
MP11 net0 VBN VDD VDD pch l=0.15 w=1 nf=1 m=1
MP2 net9 INN net4 net6 pch l=0.15 w=1 nf=1 m=1
MP3 VX2 INP net4 net6 pch l=0.15 w=1 nf=1 m=1
MP4 net5 net5 VDD VDD pch l=0.15 w=1 nf=1 m=1
MP5 OUT net5 VDD VDD pch l=0.15 w=1 nf=1 m=1
MP6 VBP VBP VDD VDD pch l=0.15 w=1 nf=1 m=1
MP7 net1 VBN VDD VDD pch l=0.15 w=1 nf=1 m=1
MP8 VBN VBN VDD VDD pch l=0.15 w=1 nf=1 m=1
MP9 net2 VBN VDD VDD pch l=0.15 w=1 nf=1 m=1
.ends EA

.subckt ISR VSS VS VCTRL VB3 IOUT
MN5 net0 VB3 VSS VSS nch l=0.15 w=1 nf=1 m=1
MN6 net1 net0 VSS VSS nch l=0.15 w=1 nf=1 m=1
MN7 net0 net0 VSS VSS nch l=0.15 w=1 nf=1 m=1
MP4 net1 net1 VS VS pch l=0.15 w=1 nf=1 m=1
MP5 IOUT net1 VS VS pch l=0.15 w=1 nf=1 m=1
MP6 net0 VCTRL VS VS pch l=0.15 w=1 nf=1 m=1
.ends ISR

.subckt dut VDD VSS VIN VCONT2 VCONT3 VP VCONT1 VCONT4 VCONT5 VREF VB3
.model DIODE D(IS=1e-14 N=1)
CFLY VX1 VX2 1p
CO VP VN 1p
COP VP VSS 1p
D1 VN VX2 DIODE
L1 VX1 VX3 1n
M1 VX1 VCONT2 VIN VIN pch l=0.15 w=1 nf=1 m=1
M2 VX2 VCONT3 VIN VIN pch l=0.15 w=1 nf=1 m=1
M3 VX3 VCONT5 VP VP pch l=0.15 w=1 nf=1 m=1
M4 VX3 VCONT4 VSS VSS nch l=0.15 w=1 nf=1 m=1
M5 net0 VCONT1 VIN VIN pch l=0.15 w=1 nf=1 m=1
R1 VP VFP1 1k
R2 VFP1 VSS 1k
X1 VDD VSS VREF VFP1 VX2 net1 EA
X2 VSS net0 net1 VB3 VX1 ISR
.ends dut
