* official Analog Canvas netlist; PDK X cards rewritten by convert.py
.model nch nmos
.model pch pmos

.subckt dut VDD VSS VSTO VCONT1 VCONT2 VCONT3 VOUT VB2 VB1
CL VOUT VSS 1p
CSTO VSTO VSS 1p
LRX net2 VLX 1n
M1 VX net5 VDD VDD pch l=0.15 w=1 nf=1 m=1
M10 VB2 VB2 VDD VDD pch l=0.15 w=1 nf=1 m=1
M11 net0 VB2 VDD VDD pch l=0.15 w=1 nf=1 m=1
M12 net1 net1 VDD VDD pch l=0.15 w=1 nf=1 m=1
M13 VB3 net1 VDD VDD pch l=0.15 w=1 nf=1 m=1
M14 VB1 VB1 VDD VDD pch l=0.15 w=1 nf=1 m=1
M15 VB2 net0 VSS VSS nch l=0.15 w=1 nf=1 m=1
M16 net3 net0 VSS VSS nch l=0.15 w=1 nf=1 m=1
M17 net1 net0 VSS VSS nch l=0.15 w=1 nf=1 m=1
M18 VB3 VB3 VSS VSS nch l=0.15 w=1 nf=1 m=1
M19 VB1 VB3 VSS VSS nch l=0.15 w=1 nf=1 m=1
M2 net5 net5 VDD VDD pch l=0.15 w=1 nf=1 m=1
M3 VG VG VDD VDD pch l=0.15 w=1 nf=1 m=1
M4 VG VG VDD VDD pch l=0.15 w=1 nf=1 m=1
M5 net5 VLX net4 VSS nch l=0.15 w=1 nf=1 m=1
M6 VG VG net4 VSS nch l=0.15 w=1 nf=1 m=1
M7 net4 VB3 VSS VSS nch l=0.15 w=1 nf=1 m=1
M8 VX VX VSS VSS nch l=0.15 w=1 nf=1 m=1
M9 VG VX VSS VSS nch l=0.15 w=1 nf=1 m=1
MN1 net2 VCONT2 VSS VSS nch l=0.15 w=1 nf=1 m=1
MN2 VLX VCONT3 VSS VSS nch l=0.15 w=1 nf=1 m=1
MP2 VLX VG VOUT VDD pch l=0.15 w=1 nf=1 m=1
MP3 net2 VCONT1 VSTO VDD pch l=0.15 w=1 nf=1 m=1
R1 net0 net3 1k
.ends dut
