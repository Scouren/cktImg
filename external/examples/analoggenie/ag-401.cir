* official Analog Canvas netlist; PDK X cards rewritten by convert.py
.model nch nmos

.subckt dut VSS Vb Iout1 Iout2
M1 Iout1 Vb net1 VSS nch l=0.15 w=1 nf=1 m=1
M2 Iout2 Vb net0 VSS nch l=0.15 w=1 nf=1 m=1
RS1 net1 VSS 1k
RS2 net0 VSS 1k
.ends dut
