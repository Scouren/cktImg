* official Analog Canvas netlist; PDK X cards rewritten by convert.py
.model nch nmos
.model pch pmos

.subckt dut VDD VSS vi Vo
I1 VDD net1 DC 1m
I2 net5 VSS DC 1m
M1 net3 net2 VSS VSS nch l=0.15 w=1 nf=1 m=1
M2 Vo net1 net3 VSS nch l=0.15 w=1 nf=1 m=1
M3 net0 vi VDD VDD pch l=0.15 w=1 nf=1 m=1
M4 net4 net4 VDD VDD pch l=0.15 w=1 nf=1 m=1
M5 net2 net2 VSS VSS nch l=0.15 w=1 nf=1 m=1
M6 net1 net1 net2 VSS nch l=0.15 w=1 nf=1 m=1
M7 Vo net5 net0 VDD pch l=0.15 w=1 nf=1 m=1
M8 net5 net5 net4 VDD pch l=0.15 w=1 nf=1 m=1
.ends dut
