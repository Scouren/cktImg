* official Analog Canvas netlist; PDK X cards rewritten by convert.py
.model nch nmos
.model pch pmos
.model qpnp pnp

.subckt opamp VDD VSS INP INN OUT
M1 net1 INP net4 VSS nch l=0.15 w=1 nf=1 m=1
M10 VB1 net3 VDD VDD pch l=0.15 w=1 nf=1 m=1
M11 net3 net3 net2 VDD pch l=0.15 w=1 nf=1 m=1
M12 VB1 VB1 VSS VSS nch l=0.15 w=1 nf=1 m=1
M2 net0 INN net4 VSS nch l=0.15 w=1 nf=1 m=1
M3 net1 net1 VDD VDD pch l=0.15 w=1 nf=1 m=1
M4 net0 net0 VDD VDD pch l=0.15 w=1 nf=1 m=1
M5 net5 net1 VDD VDD pch l=0.15 w=1 nf=1 m=1
M6 OUT net0 VDD VDD pch l=0.15 w=1 nf=1 m=1
M7 net5 net5 VSS VSS nch l=0.15 w=1 nf=1 m=1
M8 OUT net5 VSS VSS nch l=0.15 w=1 nf=1 m=1
M9 net4 VB1 VSS VSS nch l=0.15 w=1 nf=1 m=1
R4 VDD net2 1k
R5 net3 VSS 1k
.ends opamp

.subckt dut VDD VSS Vout
Q1 VSS VSS net0 qpnp m=1
Q2 net0 net0 net1 qpnp m=1
Q3 VSS VSS net2 qpnp m=1
Q4 net2 net2 Y qpnp m=1
R1 Vout X 1k
R2 Vout Y 1k
R3 X net1 1k
X1 VDD VSS X Y Vout opamp
.ends dut
