* official Analog Canvas netlist; PDK X cards rewritten by convert.py
.model nch nmos
.model pch pmos

.subckt opamp VDD VSS INN INP OUT
C3 net1 OUT 1p
M10 net3 net2 VDD VDD pch l=0.15 w=1 nf=1 m=1
M11 net2 net2 VDD VDD pch l=0.15 w=1 nf=1 m=1
M12 VB1 net2 VDD VDD pch l=0.15 w=1 nf=1 m=1
M13 net3 net3 VSS VSS nch l=0.15 w=1 nf=1 m=1
M14 net2 VB1 net5 VSS nch l=0.15 w=1 nf=1 m=1
M15 VB1 VB1 VSS VSS nch l=0.15 w=1 nf=1 m=1
M3 net0 INN net4 VSS nch l=0.15 w=1 nf=1 m=1
M4 net1 INP net4 VSS nch l=0.15 w=1 nf=1 m=1
M5 net0 net0 VDD VDD pch l=0.15 w=1 nf=1 m=1
M6 net1 net0 VDD VDD pch l=0.15 w=1 nf=1 m=1
M7 net4 net3 VSS VSS nch l=0.15 w=1 nf=1 m=1
M8 OUT net1 VDD VDD pch l=0.15 w=1 nf=1 m=1
M9 OUT net3 VSS VSS nch l=0.15 w=1 nf=1 m=1
R1 net5 VSS 1k
.ends opamp

.subckt dut VDD VSS vci phi1 phi2 vco
C1 vcx VSS 1p
C2 net0 vco 1p
M1 vci phi1 vcx VSS nch l=0.15 w=1 nf=1 m=1
M2 vcx phi2 net0 VSS nch l=0.15 w=1 nf=1 m=1
X1 VDD VSS net0 VSS vco opamp
.ends dut
