* official Analog Canvas netlist; PDK X cards rewritten by convert.py
.model nch nmos
.model pch pmos

.subckt Bias VDD VSS VBN VISR VX2
MN10 net0 VB4 VSS VSS nch l=0.15 w=1 nf=1 m=1
MN11 VB4 VB4 VSS VSS nch l=0.15 w=1 nf=1 m=1
MN12 net1 VB4 VX2 VSS nch l=0.15 w=1 nf=1 m=1
MN13 VISR VISR VSS VSS nch l=0.15 w=1 nf=1 m=1
MN14 VX2 VISR VSS VSS nch l=0.15 w=1 nf=1 m=1
MN9 VBN VBN VSS VSS nch l=0.15 w=1 nf=1 m=1
MP10 VBN net0 VDD VDD pch l=0.15 w=1 nf=1 m=1
MP11 net1 net1 VDD VDD pch l=0.15 w=1 nf=1 m=1
MP12 VB4 net1 VDD VDD pch l=0.15 w=1 nf=1 m=1
MP13 VISR net1 VDD VDD pch l=0.15 w=1 nf=1 m=1
MP9 net0 net0 VDD VDD pch l=0.15 w=1 nf=1 m=1
.ends Bias

.subckt EA VDD VSS VFP1 VREF VX3 VBN VCTRL
MN1 net2 VFP1 net0 VSS nch l=0.15 w=1 nf=1 m=1
MN2 VX3 VREF net0 VSS nch l=0.15 w=1 nf=1 m=1
MN3 net0 VBN VSS VSS nch l=0.15 w=1 nf=1 m=1
MN4 net1 net1 VSS VSS nch l=0.15 w=1 nf=1 m=1
MN5 VCTRL net1 VSS VSS nch l=0.15 w=1 nf=1 m=1
MP1 net2 net2 VDD VDD pch l=0.15 w=1 nf=1 m=1
MP2 VX3 VX3 VDD VDD pch l=0.15 w=1 nf=1 m=1
MP3 net1 net2 VDD VDD pch l=0.15 w=1 nf=1 m=1
MP4 VCTRL VX3 VDD VDD pch l=0.15 w=1 nf=1 m=1
.ends EA

.subckt ISR VDD VSS VISR VCTRL VB3 VX1
MN6 net1 net1 VSS VSS nch l=0.15 w=1 nf=1 m=1
MN7 net0 net1 VSS VSS nch l=0.15 w=1 nf=1 m=1
MN8 net1 VB3 VSS VSS nch l=0.15 w=1 nf=1 m=1
MP6 net1 VCTRL VISR VDD pch l=0.15 w=1 nf=1 m=1
MP7 net0 net0 VISR VDD pch l=0.15 w=1 nf=1 m=1
MP8 VX1 net0 VISR VDD pch l=0.15 w=1 nf=1 m=1
.ends ISR

.subckt dut VSS VIN VCONT1 VCONT2 VCONT3 VCONT4 VCONT5 VP VB3 VREF
.model DIODE D(IS=1e-14 N=1)
CFLY VX1 VX2 1p
CO VP VN 1p
COP VP VSS 1p
D1 VN VX2 DIODE
L1 VX1 VX3 1n
M1 VISR VCONT1 VIN VDD pch l=0.15 w=1 nf=1 m=1
M2 VX1 VCONT2 VIN VDD pch l=0.15 w=1 nf=1 m=1
M3 VX2 VCONT3 VIN VDD pch l=0.15 w=1 nf=1 m=1
M4 VX3 VCONT4 VSS VSS nch l=0.15 w=1 nf=1 m=1
M5 VP VCONT5 VX3 VDD pch l=0.15 w=1 nf=1 m=1
R1 VP VFP1 1k
R2 VFP1 VSS 1k
X1 VDD VSS VISR net0 VB3 VX1 ISR
X2 VDD VSS VFP1 VREF VX3 VBN net0 EA
X3 VDD VSS VBN VISR VX2 Bias
.ends dut
