* official Analog Canvas netlist; PDK X cards rewritten by convert.py
.model nch nmos
.model pch pmos
.model qpnp pnp

.subckt opamp VDD VSS INP INN OUT
M0 net3 VB1 VDD VDD pch l=0.15 w=1 nf=1 m=1
M1 net2 net4 VDD VDD pch l=0.15 w=1 nf=1 m=1
M10 net5 VB2 VSS VSS nch l=0.15 w=1 nf=1 m=1
M11 net0 net0 net7 VDD pch l=0.15 w=1 nf=1 m=1
M12 VB4 net0 VDD VDD pch l=0.15 w=1 nf=1 m=1
M13 VB4 VB4 net8 VSS nch l=0.15 w=1 nf=1 m=1
M14 net8 VB4 VSS VSS nch l=0.15 w=1 nf=1 m=1
M2 net1 net4 VDD VDD pch l=0.15 w=1 nf=1 m=1
M3 net5 INP net3 VDD pch l=0.15 w=1 nf=1 m=1
M4 net6 INN net3 VDD pch l=0.15 w=1 nf=1 m=1
M5 OUT VB3 net2 VDD pch l=0.15 w=1 nf=1 m=1
M6 net4 VB3 net1 VDD pch l=0.15 w=1 nf=1 m=1
M7 OUT VB4 net6 VSS nch l=0.15 w=1 nf=1 m=1
M8 net4 VB4 net5 VSS nch l=0.15 w=1 nf=1 m=1
M9 net6 VB2 VSS VSS nch l=0.15 w=1 nf=1 m=1
R1 VDD net7 1k
R2 net0 VSS 1k
.ends opamp

.subckt dut VDD VSS Vout
Q1 VSS VSS X qpnp m=1
Q2 VSS VSS net0 qpnp m=1
R1 Vout X 1k
R2 Vout Y 1k
R3 Y net0 1k
X1 VDD VSS X Y Vout opamp
.ends dut
