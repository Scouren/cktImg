* official Analog Canvas netlist; PDK X cards rewritten by convert.py
.model nch nmos
.model pch pmos

.subckt dut VDD VSS vci phi1 phi2 vco
C1 net5 net1 1p
C2 net7 vco 1p
M1 vci phi1 net5 VSS nch l=0.15 w=1 nf=1 m=1
M10 net4 net7 net0 VSS nch l=0.15 w=1 nf=1 m=1
M11 net2 VSS net0 VSS nch l=0.15 w=1 nf=1 m=1
M12 net0 VBN VSS VSS nch l=0.15 w=1 nf=1 m=1
M13 vco VX VSS VSS nch l=0.15 w=1 nf=1 m=1
M14 VB2 VB2 VDD VDD pch l=0.15 w=1 nf=1 m=1
M15 net3 VB2 VDD VDD pch l=0.15 w=1 nf=1 m=1
M16 VB1 VB1 VDD VDD pch l=0.15 w=1 nf=1 m=1
M17 VBN VB1 VDD VDD pch l=0.15 w=1 nf=1 m=1
M18 VB2 net3 net6 VSS nch l=0.15 w=1 nf=1 m=1
M19 net3 net3 VSS VSS nch l=0.15 w=1 nf=1 m=1
M2 net5 phi2 VSS VSS nch l=0.15 w=1 nf=1 m=1
M20 VB1 net3 VSS VSS nch l=0.15 w=1 nf=1 m=1
M21 VBN VBN VSS VSS nch l=0.15 w=1 nf=1 m=1
M3 net1 phi1 VSS VSS nch l=0.15 w=1 nf=1 m=1
M4 net1 phi2 net7 VSS nch l=0.15 w=1 nf=1 m=1
M5 VX net4 VDD VDD pch l=0.15 w=1 nf=1 m=1
M6 net4 net4 VDD VDD pch l=0.15 w=1 nf=1 m=1
M7 net2 net2 VDD VDD pch l=0.15 w=1 nf=1 m=1
M8 vco net2 VDD VDD pch l=0.15 w=1 nf=1 m=1
M9 VX VX VSS VSS nch l=0.15 w=1 nf=1 m=1
R1 net6 VSS 1k
.ends dut
