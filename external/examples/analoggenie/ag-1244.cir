* official Analog Canvas netlist; PDK X cards rewritten by convert.py
.model nch nmos
.model pch pmos

.subckt dut VDD VSS VIN VP VG5 VG1 VG2 VG4 VG3 VREF
.model DIODE D(IS=1e-14 N=1)
CFLY VX1 VX2 1p
CO VP VN 1p
COP VP VSS 1p
D1 VN VX2 DIODE
L1 VX1 VX3 1n
M1 net5 VB1 VDD VDD pch l=0.15 w=1 nf=1 m=1
M10 net1 VB2 VSS VSS nch l=0.15 w=1 nf=1 m=1
M11 net2 VB2 VSS VSS nch l=0.15 w=1 nf=1 m=1
M12 VBN VBP VDD VDD pch l=0.15 w=1 nf=1 m=1
M13 VBN VBN net0 VSS nch l=0.15 w=1 nf=1 m=1
M14 net0 VBN VSS VSS nch l=0.15 w=1 nf=1 m=1
M15 VBP VBP VDD VDD pch l=0.15 w=1 nf=1 m=1
M16 VB5 VBP VDD VDD pch l=0.15 w=1 nf=1 m=1
M17 VX2 VBP VDD VDD pch l=0.15 w=1 nf=1 m=1
M18 VBP VB5 VB4 VSS nch l=0.15 w=1 nf=1 m=1
M19 VB5 VB4 VSS VSS nch l=0.15 w=1 nf=1 m=1
M2 net1 VREF net5 VDD pch l=0.15 w=1 nf=1 m=1
M20 VB4 VX2 VSS VSS nch l=0.15 w=1 nf=1 m=1
M21 VX2 VX2 VSS VSS nch l=0.15 w=1 nf=1 m=1
M22 net3 VEA net7 VDD pch l=0.15 w=1 nf=1 m=1
M23 net4 net4 net7 VDD pch l=0.15 w=1 nf=1 m=1
M24 VX1 net4 net7 VDD pch l=0.15 w=1 nf=1 m=1
M25 net3 net3 VSS VSS nch l=0.15 w=1 nf=1 m=1
M26 net3 VB6 VSS VSS nch l=0.15 w=1 nf=1 m=1
M27 net4 net3 VSS VSS nch l=0.15 w=1 nf=1 m=1
M28 net7 VG5 VIN VDD pch l=0.15 w=1 nf=1 m=1
M29 VX1 VG1 VIN VDD pch l=0.15 w=1 nf=1 m=1
M3 net2 VFP1 net5 VDD pch l=0.15 w=1 nf=1 m=1
M30 VX2 VG2 VIN VDD pch l=0.15 w=1 nf=1 m=1
M31 VX3 VG4 VSS VSS nch l=0.15 w=1 nf=1 m=1
M32 VP VG3 VX3 VDD pch l=0.15 w=1 nf=1 m=1
M4 net8 VX VDD VDD pch l=0.15 w=1 nf=1 m=1
M5 net6 VX VDD VDD pch l=0.15 w=1 nf=1 m=1
M6 VX VB3 net8 VDD pch l=0.15 w=1 nf=1 m=1
M7 VEA VB3 net6 VDD pch l=0.15 w=1 nf=1 m=1
M8 VX VBN net1 VSS nch l=0.15 w=1 nf=1 m=1
M9 VEA VBN net2 VSS nch l=0.15 w=1 nf=1 m=1
R1 VP VFP1 1k
R2 VFP1 VSS 1k
.ends dut
