* official Analog Canvas netlist; PDK X cards rewritten by convert.py
.model nch nmos
.model pch pmos

.subckt Crystal A B
.ends Crystal

.subckt dut VDD VSS XIN XOUT OUT
C1 XIN VSS 10pF
C2 XOUT VSS 10pF
M1 XOUT XIN VDD VDD pch l=0.15 w=1 nf=1 m=1
M2 XOUT XIN VSS VSS nch l=0.15 w=1 nf=1 m=1
M3 net0 XOUT VDD VDD pch l=0.15 w=1 nf=1 m=1
M4 net0 XOUT VSS VSS nch l=0.15 w=1 nf=1 m=1
M5 OUT net0 VDD VDD pch l=0.15 w=1 nf=1 m=1
M6 OUT net0 VSS VSS nch l=0.15 w=1 nf=1 m=1
R1 XOUT XIN 1Meg
X1 XIN XOUT Crystal
.ends dut
