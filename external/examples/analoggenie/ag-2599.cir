* official Analog Canvas netlist; PDK X cards rewritten by convert.py
.model nch nmos
.model pch pmos

.subckt AMP1 VDD VSS INP INN VBN OUT
M10 net2 VBN VSS VSS nch l=0.15 w=1 nf=1 m=1
M11 net0 net1 VDD VDD pch l=0.15 w=1 nf=1 m=1
M12 net0 net0 VSS VSS nch l=0.15 w=1 nf=1 m=1
M13 OUT INN VDD VDD pch l=0.15 w=1 nf=1 m=1
M14 OUT net0 VSS VSS nch l=0.15 w=1 nf=1 m=1
M6 INN INN VDD VDD pch l=0.15 w=1 nf=1 m=1
M7 INN INP net2 VSS nch l=0.15 w=1 nf=1 m=1
M8 net1 net1 VDD VDD pch l=0.15 w=1 nf=1 m=1
M9 net1 INN net2 VSS nch l=0.15 w=1 nf=1 m=1
.ends AMP1

.subckt bias VDD VSS n3 VB1 VBN
M15 n3 net0 VDD VDD pch l=0.15 w=1 nf=1 m=1
M16 net0 net0 VDD VDD pch l=0.15 w=1 nf=1 m=1
M17 VBN net0 VDD VDD pch l=0.15 w=1 nf=1 m=1
M18 net0 n3 VB1 VSS nch l=0.15 w=1 nf=1 m=1
M19 VBN VBN VSS VSS nch l=0.15 w=1 nf=1 m=1
M20 n3 VB1 VSS VSS nch l=0.15 w=1 nf=1 m=1
R3 VB1 VSS 1k
.ends bias

.subckt dut VDD VSS Vref biasp biascas biasn Vout VB1
C1 Vset VSS 1p
C2 n3 Vout 1p
M1 Vout n3 VDD VDD pch l=0.15 w=1 nf=1 m=1
M2 n1 Vset Vout VDD pch l=0.15 w=1 nf=1 m=1
M3 n1 biasn VSS VSS nch l=0.15 w=1 nf=1 m=1
M4 n3 biasp VDD VDD pch l=0.15 w=1 nf=1 m=1
M5 n3 biascas n1 VSS nch l=0.15 w=1 nf=1 m=1
R1 fb VSS 1k
R2 Vout fb 1k
X1 VDD VSS Vref fb VBN Vset AMP1
X2 VDD VSS n3 VB1 VBN bias
.ends dut
