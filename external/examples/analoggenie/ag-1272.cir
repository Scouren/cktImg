* official Analog Canvas netlist; PDK X cards rewritten by convert.py
.model nch nmos
.model pch pmos

.subckt dut VDD VSS VC5 VC1 VC2 VC3 VC4 VIN VP VREF VB3 VB1 VB2
.model DIODE D(IS=1e-14 N=1)
CFLY VX1 VX2 1p
CO VP VN 1p
COP VP VSS 1p
D1 VN VX2 DIODE
L1 VX1 VX3 1n
M1 VX1 VC1 VIN VDD pch l=0.15 w=1 nf=1 m=1
M10 net0 VX3 VDD VDD pch l=0.15 w=1 nf=1 m=1
M11 net2 VFP1 net4 VSS nch l=0.15 w=1 nf=1 m=1
M12 VX3 VREF net4 VSS nch l=0.15 w=1 nf=1 m=1
M13 net4 VB4 VSS VSS nch l=0.15 w=1 nf=1 m=1
M14 net6 net6 VSS VSS nch l=0.15 w=1 nf=1 m=1
M15 net0 net6 VSS VSS nch l=0.15 w=1 nf=1 m=1
M16 net1 net0 VS5 VDD pch l=0.15 w=1 nf=1 m=1
M17 net1 net1 VSS VSS nch l=0.15 w=1 nf=1 m=1
M18 net1 VB3 VSS VSS nch l=0.15 w=1 nf=1 m=1
M19 VSR net1 VSS VSS nch l=0.15 w=1 nf=1 m=1
M2 VX2 VC2 VIN VDD pch l=0.15 w=1 nf=1 m=1
M20 VSR VSR VS5 VDD pch l=0.15 w=1 nf=1 m=1
M21 net3 net3 VDD VDD pch l=0.15 w=1 nf=1 m=1
M22 VB4 net3 VDD VDD pch l=0.15 w=1 nf=1 m=1
M23 VB1 VB1 VDD VDD pch l=0.15 w=1 nf=1 m=1
M24 net3 VB5 VSS VSS nch l=0.15 w=1 nf=1 m=1
M25 VB4 VB4 VSS VSS nch l=0.15 w=1 nf=1 m=1
M26 VB1 VB4 VSS VSS nch l=0.15 w=1 nf=1 m=1
M27 VB2 VB2 VDD VDD pch l=0.15 w=1 nf=1 m=1
M28 net7 VB2 VDD VDD pch l=0.15 w=1 nf=1 m=1
M29 net5 VB2 VDD VDD pch l=0.15 w=1 nf=1 m=1
M3 VP VC3 VX3 VDD pch l=0.15 w=1 nf=1 m=1
M30 VB5 VB2 VDD VDD pch l=0.15 w=1 nf=1 m=1
M31 VB2 net8 VSS VSS nch l=0.15 w=1 nf=1 m=1
M32 net7 net7 net8 VSS nch l=0.15 w=1 nf=1 m=1
M33 net8 net7 net9 VSS nch l=0.15 w=1 nf=1 m=1
M34 net5 net5 net9 VSS nch l=0.15 w=1 nf=1 m=1
M35 net9 net5 VB5 VSS nch l=0.15 w=1 nf=1 m=1
M36 VB5 VB5 VSS VSS nch l=0.15 w=1 nf=1 m=1
M4 VX3 VC4 VSS VSS nch l=0.15 w=1 nf=1 m=1
M5 VS5 VC5 VIN VDD pch l=0.15 w=1 nf=1 m=1
M6 VX1 VSR VS5 VDD pch l=0.15 w=1 nf=1 m=1
M7 net6 net2 VDD VDD pch l=0.15 w=1 nf=1 m=1
M8 net2 net2 VDD VDD pch l=0.15 w=1 nf=1 m=1
M9 VX3 VX3 VDD VDD pch l=0.15 w=1 nf=1 m=1
R1 VP VFP1 1k
R2 VFP1 VSS 1k
.ends dut
