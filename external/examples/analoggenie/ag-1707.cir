* official Analog Canvas netlist; PDK X cards rewritten by convert.py
.model nch nmos
.model pch pmos
.model qpnp pnp

.subckt opamp VDD VSS INN INP IB OUT
M1 net0 net0 VDD VDD pch l=0.15 w=1 nf=1 m=1
M10 net1 net1 VSS VSS nch l=0.15 w=1 nf=1 m=1
M11 OUT net1 VSS VSS nch l=0.15 w=1 nf=1 m=1
M2 net2 net2 VDD VDD pch l=0.15 w=1 nf=1 m=1
M5 OUT net0 VDD VDD pch l=0.15 w=1 nf=1 m=1
M6 net1 net2 VDD VDD pch l=0.15 w=1 nf=1 m=1
M7 net2 INN net3 VSS nch l=0.15 w=1 nf=1 m=1
M8 net0 INP net3 VSS nch l=0.15 w=1 nf=1 m=1
M9 net3 IB VSS VSS nch l=0.15 w=1 nf=1 m=1
.ends opamp

.subckt dut VDD VSS Vout
M12 VB2 VB2 VDD VDD pch l=0.15 w=1 nf=1 m=1
M13 VB2 net3 VSS VSS nch l=0.15 w=1 nf=1 m=1
M14 net3 VB2 VDD VDD pch l=0.15 w=1 nf=1 m=1
M15 net1 net3 VSS VSS nch l=0.15 w=1 nf=1 m=1
M16 VB1 VB1 VDD VDD pch l=0.15 w=1 nf=1 m=1
M17 VB1 net3 VSS VSS nch l=0.15 w=1 nf=1 m=1
M18 VB3 VB1 VDD VDD pch l=0.15 w=1 nf=1 m=1
M19 VB3 VB3 VSS VSS nch l=0.15 w=1 nf=1 m=1
Q1 VSS VSS net0 qpnp m=1
Q2 net0 net0 net4 qpnp m=1
Q3 VSS VSS net2 qpnp m=1
Q4 net2 net2 Y qpnp m=1
R1 Vout X 1k
R2 Vout Y 1k
R3 X net4 1k
R4 net3 net1 1k
X1 VDD VSS X Y VB3 Vout opamp
.ends dut
