* official Analog Canvas netlist; PDK X cards rewritten by convert.py
.model nch nmos
.model pch pmos
.model qnpn npn

.subckt A1 VDD VSS INN INP OUT VB1 VB2 VB4
M1 net4 net1 VDD VDD pch l=0.15 w=1 nf=1 m=1
M10 net3 INP net2 VSS nch l=0.15 w=1 nf=1 m=1
M11 net2 VB2 VSS VSS nch l=0.15 w=1 nf=1 m=1
M12 VN VB4 net5 VSS nch l=0.15 w=1 nf=1 m=1
M13 OUT VB4 net8 VSS nch l=0.15 w=1 nf=1 m=1
M14 net5 VN VSS VSS nch l=0.15 w=1 nf=1 m=1
M15 net8 VN VSS VSS nch l=0.15 w=1 nf=1 m=1
M2 net0 net1 VDD VDD pch l=0.15 w=1 nf=1 m=1
M3 net7 net3 VDD VDD pch l=0.15 w=1 nf=1 m=1
M4 net6 net3 VDD VDD pch l=0.15 w=1 nf=1 m=1
M5 VN VB1 net4 VDD pch l=0.15 w=1 nf=1 m=1
M6 net1 VB1 net0 VDD pch l=0.15 w=1 nf=1 m=1
M7 net3 VB1 net7 VDD pch l=0.15 w=1 nf=1 m=1
M8 OUT VB1 net6 VDD pch l=0.15 w=1 nf=1 m=1
M9 net1 INN net2 VSS nch l=0.15 w=1 nf=1 m=1
.ends A1

.subckt dut VDD VSS Vout VB1 VB2
M1 net3 net1 VDD VDD pch l=0.15 w=1 nf=1 m=1
M2 net1 net1 VDD VDD pch l=0.15 w=1 nf=1 m=1
M3 VB4 net1 VDD VDD pch l=0.15 w=1 nf=1 m=1
M4 net3 net3 VSS VSS nch l=0.15 w=1 nf=1 m=1
M5 net1 net3 net4 VSS nch l=0.15 w=1 nf=1 m=1
M6 VB4 VB4 VC2 VSS nch l=0.15 w=1 nf=1 m=1
M7 VC2 VB4 VSS VSS nch l=0.15 w=1 nf=1 m=1
Q1 net2 net2 VSS VSS qnpn m=1
Q2 VC2 VC2 VSS VSS qnpn m=1
R1 Vout net2 1k
R2 Vout net0 1k
R3 net0 VC2 1k
R4 net4 VSS 1k
X1 VDD VSS net0 net2 Vout VB1 VB2 VB4 A1
.ends dut
