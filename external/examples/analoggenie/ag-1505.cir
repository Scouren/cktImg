* official Analog Canvas netlist; PDK X cards rewritten by convert.py
.model nch nmos
.model pch pmos
.model qnpn npn

.subckt A1 VDD VSS VB1 INN INP OUT VB2
M1 net5 VB1 VDD VDD pch l=0.15 w=1 nf=1 m=1
M10 net0 VB7 VSS VSS nch l=0.15 w=1 nf=1 m=1
M11 net3 VB7 VSS VSS nch l=0.15 w=1 nf=1 m=1
M12 net2 VB5 VDD VDD pch l=0.15 w=1 nf=1 m=1
M13 net2 net2 VSS VSS nch l=0.15 w=1 nf=1 m=1
M14 VB5 VB5 VDD VDD pch l=0.15 w=1 nf=1 m=1
M15 VB5 VB4 VB3 VSS nch l=0.15 w=1 nf=1 m=1
M16 VB3 net2 VSS VSS nch l=0.15 w=1 nf=1 m=1
M17 VB4 VB5 VDD VDD pch l=0.15 w=1 nf=1 m=1
M18 VB4 VB3 VSS VSS nch l=0.15 w=1 nf=1 m=1
M19 VB6 VB5 VDD VDD pch l=0.15 w=1 nf=1 m=1
M2 net3 INN net5 VDD pch l=0.15 w=1 nf=1 m=1
M20 VB6 VB6 VB7 VSS nch l=0.15 w=1 nf=1 m=1
M21 VB7 VB7 VSS VSS nch l=0.15 w=1 nf=1 m=1
M3 net0 INP net5 VDD pch l=0.15 w=1 nf=1 m=1
M4 net6 net1 VDD VDD pch l=0.15 w=1 nf=1 m=1
M5 net4 net1 VDD VDD pch l=0.15 w=1 nf=1 m=1
M6 net1 VB2 net6 VDD pch l=0.15 w=1 nf=1 m=1
M7 OUT VB2 net4 VDD pch l=0.15 w=1 nf=1 m=1
M8 net1 VB6 net0 VSS nch l=0.15 w=1 nf=1 m=1
M9 OUT VB6 net3 VSS nch l=0.15 w=1 nf=1 m=1
.ends A1

.subckt dut VDD VSS Vout VB1 VB2
Q1 X X VSS VSS qnpn m=1
Q2 net0 net0 VSS VSS qnpn m=1
R1 Vout X 1k
R2 Vout Y 1k
R3 Y net0 1k
X1 VDD VSS VB1 Y X Vout VB2 A1
.ends dut
