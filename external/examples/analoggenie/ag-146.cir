* official Analog Canvas netlist; PDK X cards rewritten by convert.py
.model nch nmos

.subckt dut VDD VSS
M1 Y X VSS VSS nch l=0.15 w=1 nf=1 m=1
M2 X X net0 VSS nch l=0.15 w=1 nf=1 m=1
R1 VDD X 1k
R2 net0 VSS 1k
R3 VDD Y 1k
.ends dut
