* official Analog Canvas netlist; PDK X cards rewritten by convert.py
.model nch nmos
.model pch pmos

.subckt AMP1 VDD VSS INP INN N3 OUT
M10 net7 VX VDD VDD pch l=0.15 w=1 nf=1 m=1
M11 OUT VB3 net7 VDD pch l=0.15 w=1 nf=1 m=1
M12 OUT VBN net1 VSS nch l=0.15 w=1 nf=1 m=1
M13 net1 VB2 VSS VSS nch l=0.15 w=1 nf=1 m=1
M14 N3 VB1 VDD VDD pch l=0.15 w=1 nf=1 m=1
M15 net2 INP N3 VDD pch l=0.15 w=1 nf=1 m=1
M16 net1 INN N3 VDD pch l=0.15 w=1 nf=1 m=1
M17 VBN net0 VDD VDD pch l=0.15 w=1 nf=1 m=1
M18 VBN VBN net4 VSS nch l=0.15 w=1 nf=1 m=1
M19 net4 VBN VSS VSS nch l=0.15 w=1 nf=1 m=1
M20 net0 net0 VDD VDD pch l=0.15 w=1 nf=1 m=1
M21 net0 net3 net5 VSS nch l=0.15 w=1 nf=1 m=1
M22 net3 net0 VDD VDD pch l=0.15 w=1 nf=1 m=1
M23 net3 net3 VSS VSS nch l=0.15 w=1 nf=1 m=1
M6 net6 VX VDD VDD pch l=0.15 w=1 nf=1 m=1
M7 VX VB3 net6 VDD pch l=0.15 w=1 nf=1 m=1
M8 VX VBN net2 VSS nch l=0.15 w=1 nf=1 m=1
M9 net2 VB2 VSS VSS nch l=0.15 w=1 nf=1 m=1
R3 net5 VSS 1k
.ends AMP1

.subckt dut VDD VSS Vref Vout biasp biascas biasn
C1 Vset VSS 1p
C2 n3 Vout 1p
M1 Vout n3 VDD VDD pch l=0.15 w=1 nf=1 m=1
M2 n1 Vset Vout VDD pch l=0.15 w=1 nf=1 m=1
M3 n1 biasn VSS VSS nch l=0.15 w=1 nf=1 m=1
M4 n3 biasp VDD VDD pch l=0.15 w=1 nf=1 m=1
M5 n3 biascas n1 VSS nch l=0.15 w=1 nf=1 m=1
R1 fb VSS 1k
R2 Vout fb 1k
X1 VDD VSS Vref fb n3 Vset AMP1
.ends dut
