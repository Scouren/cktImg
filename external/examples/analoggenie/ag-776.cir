* official Analog Canvas netlist; PDK X cards rewritten by convert.py
.model nch nmos

.subckt dut VDD VSS VIN1 VIN2 VB1 IOUT1 IOUT2
ISS net1 VSS DC 1m
M1 IOUT1 VIN1 net1 VSS nch l=0.15 w=1 nf=1 m=1
M2 IOUT2 VIN2 net1 VSS nch l=0.15 w=1 nf=1 m=1
M3 IOUT2 net0 net1 VSS nch l=0.15 w=1 nf=1 m=1
M4 IOUT1 net2 net1 VSS nch l=0.15 w=1 nf=1 m=1
M5 VDD VIN1 net0 VSS nch l=0.15 w=1 nf=1 m=1
M6 VDD VIN2 net2 VSS nch l=0.15 w=1 nf=1 m=1
M7 net0 VB1 VSS VSS nch l=0.15 w=1 nf=1 m=1
M8 net2 VB1 VSS VSS nch l=0.15 w=1 nf=1 m=1
.ends dut
