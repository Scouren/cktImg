* official Analog Canvas netlist; PDK X cards rewritten by convert.py
.model nch nmos
.model pch pmos

.subckt opamp VDD VSS INP INN OUT
M10 net0 VX VSS VSS nch l=0.15 w=1 nf=1 m=1
M11 VB2 VX VSS VSS nch l=0.15 w=1 nf=1 m=1
M12 net1 VX VSS VSS nch l=0.15 w=1 nf=1 m=1
M13 VB1 VB1 VSS VSS nch l=0.15 w=1 nf=1 m=1
M14 net5 VB1 VSS VSS nch l=0.15 w=1 nf=1 m=1
M15 net4 net5 VDD VDD pch l=0.15 w=1 nf=1 m=1
M16 net2 INP net4 VDD pch l=0.15 w=1 nf=1 m=1
M17 OUT INN net4 VDD pch l=0.15 w=1 nf=1 m=1
M18 net2 VB3 net6 VSS nch l=0.15 w=1 nf=1 m=1
M19 OUT VB3 net3 VSS nch l=0.15 w=1 nf=1 m=1
M20 net6 net2 VSS VSS nch l=0.15 w=1 nf=1 m=1
M21 net3 net2 VSS VSS nch l=0.15 w=1 nf=1 m=1
M5 VX VB2 VDD VDD pch l=0.15 w=1 nf=1 m=1
M6 VB2 VB2 VDD VDD pch l=0.15 w=1 nf=1 m=1
M7 net1 net1 VDD VDD pch l=0.15 w=1 nf=1 m=1
M8 VB1 net1 VDD VDD pch l=0.15 w=1 nf=1 m=1
M9 net5 net5 VDD VDD pch l=0.15 w=1 nf=1 m=1
R1 VX net0 1k
.ends opamp

.subckt dut VDD VSS vci phi1 phi2 vco
C1 net1 net0 1p
C2 net2 vco 1p
M1 vci phi1 net1 VSS nch l=0.15 w=1 nf=1 m=1
M2 net1 phi2 VSS VSS nch l=0.15 w=1 nf=1 m=1
M3 net0 phi1 VSS VSS nch l=0.15 w=1 nf=1 m=1
M4 net0 phi2 net2 VSS nch l=0.15 w=1 nf=1 m=1
X1 VDD VSS VSS net2 vco opamp
.ends dut
