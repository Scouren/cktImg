* official Analog Canvas netlist; PDK X cards rewritten by convert.py
.model nch nmos
.model pch pmos

.subckt dut VDD VSS v1 v2 vout
I1 net3 VSS DC 100uA
M1 net2 v1 net1 VSS nch l=0.15 w=1 nf=1 m=1
M10 net0 net0 VSS VSS nch l=0.15 w=1 nf=1 m=1
M2 vout v2 net1 VSS nch l=0.15 w=1 nf=1 m=1
M3 net2 net2 VSS VSS nch l=0.15 w=1 nf=1 m=1
M4 vout net2 VSS VSS nch l=0.15 w=1 nf=1 m=1
M5 net1 net0 VSS VSS nch l=0.15 w=1 nf=1 m=1
M6 net2 net3 VDD VDD pch l=0.15 w=1 nf=1 m=1
M7 vout net3 VDD VDD pch l=0.15 w=1 nf=1 m=1
M8 net0 net3 VDD VDD pch l=0.15 w=1 nf=1 m=1
M9 net3 net3 VDD VDD pch l=0.15 w=1 nf=1 m=1
.ends dut
