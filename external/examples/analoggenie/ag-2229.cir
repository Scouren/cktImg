* official Analog Canvas netlist; PDK X cards rewritten by convert.py
.model nch nmos
.model pch pmos

.subckt opamp VDD VSS INP INN VB1 OUT VB3 VB2
M1 net6 VB1 VDD VDD pch l=0.15 w=1 nf=1 m=1
M10 OUT VB4 VY VSS nch l=0.15 w=1 nf=1 m=1
M11 VY VB2 VSS VSS nch l=0.15 w=1 nf=1 m=1
M12 net2 net2 net3 VDD pch l=0.15 w=1 nf=1 m=1
M13 VB4 net2 VDD VDD pch l=0.15 w=1 nf=1 m=1
M14 VB4 VB4 net4 VSS nch l=0.15 w=1 nf=1 m=1
M15 net4 VB4 VSS VSS nch l=0.15 w=1 nf=1 m=1
M2 net7 INP net6 VDD pch l=0.15 w=1 nf=1 m=1
M3 VY INN net6 VDD pch l=0.15 w=1 nf=1 m=1
M4 net5 net0 VDD VDD pch l=0.15 w=1 nf=1 m=1
M5 net0 VB3 net5 VDD pch l=0.15 w=1 nf=1 m=1
M6 net0 VB4 net7 VSS nch l=0.15 w=1 nf=1 m=1
M7 net7 VB2 VSS VSS nch l=0.15 w=1 nf=1 m=1
M8 net1 net0 VDD VDD pch l=0.15 w=1 nf=1 m=1
M9 OUT VB3 net1 VDD pch l=0.15 w=1 nf=1 m=1
R1 VDD net3 1k
R2 net2 VSS 1k
.ends opamp

.subckt dut VDD VSS VIN Vref VOUT VB1 VB2 VB3
CL VOUT net1 1p
MNP VIN net0 VOUT VSS nch l=0.15 w=1 nf=1 m=1
R1 VOUT FB 1k
R2 FB VSS 1k
R3 net1 VSS 1k
X1 VDD VSS Vref FB VB1 net0 VB3 VB2 opamp
.ends dut
