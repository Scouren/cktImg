* official Analog Canvas netlist; PDK X cards rewritten by convert.py
.model nch nmos
.model pch pmos
.model qnpn npn

.subckt opamp VDD VSS VB1 VB2 OUT INP INN VB3
M1 net9 INP net4 VSS nch l=0.15 w=1 nf=1 m=1
M10 net7 net0 VSS VSS nch l=0.15 w=1 nf=1 m=1
M11 net4 VB5 VSS VSS nch l=0.15 w=1 nf=1 m=1
M12 VB4 VP VDD VDD pch l=0.15 w=1 nf=1 m=1
M13 VB4 VB4 VB5 VSS nch l=0.15 w=1 nf=1 m=1
M14 VB5 VB5 VSS VSS nch l=0.15 w=1 nf=1 m=1
M15 VP VP VDD VDD pch l=0.15 w=1 nf=1 m=1
M16 VP net3 VSS VSS nch l=0.15 w=1 nf=1 m=1
M17 net5 VP VDD VDD pch l=0.15 w=1 nf=1 m=1
M18 net5 net5 net3 VSS nch l=0.15 w=1 nf=1 m=1
M19 net3 net5 net2 VSS nch l=0.15 w=1 nf=1 m=1
M2 net1 INN net4 VSS nch l=0.15 w=1 nf=1 m=1
M20 net8 VP VDD VDD pch l=0.15 w=1 nf=1 m=1
M21 net8 net8 net2 VSS nch l=0.15 w=1 nf=1 m=1
M22 net2 net8 VB3 VSS nch l=0.15 w=1 nf=1 m=1
M23 VB3 VP VDD VDD pch l=0.15 w=1 nf=1 m=1
M24 VB3 VB3 VSS VSS nch l=0.15 w=1 nf=1 m=1
M3 net9 VB1 VDD VDD pch l=0.15 w=1 nf=1 m=1
M4 net1 VB1 VDD VDD pch l=0.15 w=1 nf=1 m=1
M5 OUT VB2 net9 VDD pch l=0.15 w=1 nf=1 m=1
M6 net0 VB2 net1 VDD pch l=0.15 w=1 nf=1 m=1
M7 OUT VB4 net6 VSS nch l=0.15 w=1 nf=1 m=1
M8 net0 VB4 net7 VSS nch l=0.15 w=1 nf=1 m=1
M9 net6 net0 VSS VSS nch l=0.15 w=1 nf=1 m=1
.ends opamp

.subckt dut VDD VSS Vout VB1 VB2 VB3
Q1 X X VSS VSS qnpn m=1
Q2 net0 net0 VSS VSS qnpn m=1
R1 Vout X 1k
R2 Vout Y 1k
R3 Y net0 1k
X1 VDD VSS VB1 VB2 Vout X Y VB3 opamp
.ends dut
