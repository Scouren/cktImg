* official Analog Canvas netlist; PDK X cards rewritten by convert.py
.model nch nmos
.model pch pmos
.model qnpn npn

.subckt opamp VDD VSS inn inp out z
M1 net0 inn net3 VSS nch l=0.15 w=1 nf=1 m=1
M10 net4 net1 VSS VSS nch l=0.15 w=1 nf=1 m=1
M11 net1 net4 VDD VDD pch l=0.15 w=1 nf=1 m=1
M12 net1 net1 VSS VSS nch l=0.15 w=1 nf=1 m=1
M13 VB1 net1 VSS VSS nch l=0.15 w=1 nf=1 m=1
M14 VB1 VB1 VDD VDD pch l=0.15 w=1 nf=1 m=1
M15 VB2 VB1 VDD VDD pch l=0.15 w=1 nf=1 m=1
M16 VB2 VB2 VSS VSS nch l=0.15 w=1 nf=1 m=1
M2 net2 inp net3 VSS nch l=0.15 w=1 nf=1 m=1
M3 net3 VB2 VSS VSS nch l=0.15 w=1 nf=1 m=1
M4 net2 net2 VDD VDD pch l=0.15 w=1 nf=1 m=1
M5 net0 net0 VDD VDD pch l=0.15 w=1 nf=1 m=1
M6 z net0 VDD VDD pch l=0.15 w=1 nf=1 m=1
M7 out net2 VDD VDD pch l=0.15 w=1 nf=1 m=1
M8 z z VSS VSS nch l=0.15 w=1 nf=1 m=1
M9 out z VSS VSS nch l=0.15 w=1 nf=1 m=1
R4 VDD net1 1k
R5 VDD net4 1k
.ends opamp

.subckt dut VDD VSS Vout
Q1 X X VSS VSS qnpn m=1
Q2 net0 net0 VSS VSS qnpn m=1
R1 Vout X 1k
R2 Vout Y 1k
R3 Y net0 1k
X1 VDD VSS Y X Vout net0 opamp
.ends dut
