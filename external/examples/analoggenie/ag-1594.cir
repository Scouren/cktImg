* official Analog Canvas netlist; PDK X cards rewritten by convert.py
.model nch nmos
.model pch pmos
.model qpnp pnp

.subckt opamp VDD VSS IN+ IN- OUT VB1 VB2
M10 net2 VB5 VSS VSS nch l=0.15 w=1 nf=1 m=1
M11 net5 VB1 VDD VDD pch l=0.15 w=1 nf=1 m=1
M12 net6 IN+ net5 VDD pch l=0.15 w=1 nf=1 m=1
M13 net2 IN- net5 VDD pch l=0.15 w=1 nf=1 m=1
M14 VB4 VB6 VDD VDD pch l=0.15 w=1 nf=1 m=1
M15 VB4 VB4 VB5 VSS nch l=0.15 w=1 nf=1 m=1
M16 VB5 VB5 VSS VSS nch l=0.15 w=1 nf=1 m=1
M17 VB3 VB6 VDD VDD pch l=0.15 w=1 nf=1 m=1
M18 VB6 VB6 VDD VDD pch l=0.15 w=1 nf=1 m=1
M19 net0 VB6 VDD VDD pch l=0.15 w=1 nf=1 m=1
M20 VB3 VB3 VSS VSS nch l=0.15 w=1 nf=1 m=1
M21 VB6 VB3 net3 VSS nch l=0.15 w=1 nf=1 m=1
M22 net3 net0 VSS VSS nch l=0.15 w=1 nf=1 m=1
M23 net0 net0 VSS VSS nch l=0.15 w=1 nf=1 m=1
M3 net4 VX VDD VDD pch l=0.15 w=1 nf=1 m=1
M4 VX VB2 net4 VDD pch l=0.15 w=1 nf=1 m=1
M5 VX VB4 net6 VSS nch l=0.15 w=1 nf=1 m=1
M6 net6 VB5 VSS VSS nch l=0.15 w=1 nf=1 m=1
M7 net1 VX VDD VDD pch l=0.15 w=1 nf=1 m=1
M8 OUT VB2 net1 VDD pch l=0.15 w=1 nf=1 m=1
M9 OUT VB4 net2 VSS nch l=0.15 w=1 nf=1 m=1
.ends opamp

.subckt dut VDD VSS Vout VB1 VB2
Q1 VSS VSS X qpnp m=1
Q2 VSS VSS net0 qpnp m=1
R1 Vout X 1k
R2 Vout Y 1k
R3 Y net0 1k
X1 VDD VSS X Y Vout VB1 VB2 opamp
.ends dut
