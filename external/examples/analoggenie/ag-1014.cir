* official Analog Canvas netlist; PDK X cards rewritten by convert.py
.model nch nmos
.model pch pmos

.subckt dut VDD VSS vi1 vi2 Vout1 Vout2
IBIAS net2 net0 DC 1m
M1 Vout1 VDD net1 vi1 nch l=0.15 w=1 nf=1 m=1
M2 Vout2 VDD net1 vi2 nch l=0.15 w=1 nf=1 m=1
M3 Vout1 net2 VDD VDD pch l=0.15 w=1 nf=1 m=1
M4 Vout2 net2 VDD VDD pch l=0.15 w=1 nf=1 m=1
M5 net1 net0 VSS VSS nch l=0.15 w=1 nf=1 m=1
M6 net0 net0 VSS VSS nch l=0.15 w=1 nf=1 m=1
M7 net2 net2 VDD VDD pch l=0.15 w=1 nf=1 m=1
.ends dut
