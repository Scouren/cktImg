* official Analog Canvas netlist; PDK X cards rewritten by convert.py
.model nch nmos
.model pch pmos

.subckt opamp VDD VSS INP INN OUT
M10 net0 net5 VSS VSS nch l=0.15 w=1 nf=1 m=1
M11 net5 net5 VSS VSS nch l=0.15 w=1 nf=1 m=1
M12 net2 net2 VSS VSS nch l=0.15 w=1 nf=1 m=1
M13 OUT net2 VSS VSS nch l=0.15 w=1 nf=1 m=1
M14 VB2 net3 VDD VDD pch l=0.15 w=1 nf=1 m=1
M15 net3 net3 VDD VDD pch l=0.15 w=1 nf=1 m=1
M16 net4 net3 VDD VDD pch l=0.15 w=1 nf=1 m=1
M17 VB3 VB3 VDD VDD pch l=0.15 w=1 nf=1 m=1
M18 VB1 VB3 VDD VDD pch l=0.15 w=1 nf=1 m=1
M19 net1 VB2 VSS VSS nch l=0.15 w=1 nf=1 m=1
M20 net3 VB2 VSS VSS nch l=0.15 w=1 nf=1 m=1
M21 net4 net4 VSS VSS nch l=0.15 w=1 nf=1 m=1
M22 VB3 net4 VSS VSS nch l=0.15 w=1 nf=1 m=1
M23 VB1 VB1 VSS VSS nch l=0.15 w=1 nf=1 m=1
M5 net0 net0 VDD VDD pch l=0.15 w=1 nf=1 m=1
M6 OUT net0 VDD VDD pch l=0.15 w=1 nf=1 m=1
M7 net6 VB3 VDD VDD pch l=0.15 w=1 nf=1 m=1
M8 net5 INP net6 VDD pch l=0.15 w=1 nf=1 m=1
M9 net2 INN net6 VDD pch l=0.15 w=1 nf=1 m=1
R1 VB2 net1 1k
.ends opamp

.subckt dut VDD VSS vci phi1 phi2 vco
C1 net1 net2 1p
C2 net0 vco 1p
M1 vci phi1 net1 VSS nch l=0.15 w=1 nf=1 m=1
M2 net1 phi2 VSS VSS nch l=0.15 w=1 nf=1 m=1
M3 net2 phi1 VSS VSS nch l=0.15 w=1 nf=1 m=1
M4 net2 phi2 net0 VSS nch l=0.15 w=1 nf=1 m=1
X1 VDD VSS VSS net0 vco opamp
.ends dut
