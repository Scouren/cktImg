* official Analog Canvas netlist; PDK X cards rewritten by convert.py
.model nch nmos
.model pch pmos
.model qpnp pnp

.subckt opamp VDD VSS INN INP OUT
M1 net5 INN net4 VSS nch l=0.15 w=1 nf=1 m=1
M10 net0 VB3 VDD VDD pch l=0.15 w=1 nf=1 m=1
M11 VB3 VB3 VDD VDD pch l=0.15 w=1 nf=1 m=1
M12 net2 VB3 VDD VDD pch l=0.15 w=1 nf=1 m=1
M13 net1 VB3 VDD VDD pch l=0.15 w=1 nf=1 m=1
M14 VB3 net2 net6 VSS nch l=0.15 w=1 nf=1 m=1
M15 net0 net0 VSS VSS nch l=0.15 w=1 nf=1 m=1
M16 net6 net0 VSS VSS nch l=0.15 w=1 nf=1 m=1
M17 net2 net6 VSS VSS nch l=0.15 w=1 nf=1 m=1
M18 net1 net1 VSS VSS nch l=0.15 w=1 nf=1 m=1
M2 net7 INP net4 VSS nch l=0.15 w=1 nf=1 m=1
M3 net5 net5 VDD VDD pch l=0.15 w=1 nf=1 m=1
M4 net7 net7 VDD VDD pch l=0.15 w=1 nf=1 m=1
M5 net3 net5 VDD VDD pch l=0.15 w=1 nf=1 m=1
M6 OUT net7 VDD VDD pch l=0.15 w=1 nf=1 m=1
M7 net3 net3 VSS VSS nch l=0.15 w=1 nf=1 m=1
M8 OUT net3 VSS VSS nch l=0.15 w=1 nf=1 m=1
M9 net4 net1 VSS VSS nch l=0.15 w=1 nf=1 m=1
.ends opamp

.subckt dut VDD VSS Vout
Q1 VSS VSS net1 qpnp m=1
Q2 net1 net1 net4 qpnp m=1
Q3 VSS VSS net2 qpnp m=1
Q4 net2 net2 net0 qpnp m=1
R1 Vout net4 1k
R2 Vout net3 1k
R3 net3 net0 1k
X1 VDD VSS net3 net4 Vout opamp
.ends dut
