* official Analog Canvas netlist; PDK X cards rewritten by convert.py
.model nch nmos

.subckt dut VDD VSS Vin Vout
M1 VDD Vin Vout VSS nch l=0.15 w=1 nf=1 m=1
RF Vin Vout 1k
RS Vout VSS 1k
.ends dut
