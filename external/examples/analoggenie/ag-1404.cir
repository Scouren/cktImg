* official Analog Canvas netlist; PDK X cards rewritten by convert.py
.model nch nmos
.model pch pmos

.subckt dut VDD VSS VSTO VCONT1 VCONT2 VCONT3 VOUT VB1 VB2 VB4
CL VOUT VSS 1p
CSTO VSTO VSS 1p
LRX net8 VX 1n
M1 net10 net3 VDD VDD pch l=0.15 w=1 nf=1 m=1
M10 net0 VX net1 net4 pch l=0.15 w=1 nf=1 m=1
M11 net5 VG net1 net4 pch l=0.15 w=1 nf=1 m=1
M12 VB4 net2 VDD VDD pch l=0.15 w=1 nf=1 m=1
M13 net2 net2 VDD VDD pch l=0.15 w=1 nf=1 m=1
M14 VBN net2 VDD VDD pch l=0.15 w=1 nf=1 m=1
M15 VB4 VB4 VSS VSS nch l=0.15 w=1 nf=1 m=1
M16 net2 VB4 net6 VSS nch l=0.15 w=1 nf=1 m=1
M17 VBN VBN net9 VSS nch l=0.15 w=1 nf=1 m=1
M18 net9 VBN VSS VSS nch l=0.15 w=1 nf=1 m=1
M2 VG VB3 net10 VDD pch l=0.15 w=1 nf=1 m=1
M3 VG VBN net0 VSS nch l=0.15 w=1 nf=1 m=1
M4 net0 VB2 VSS VSS nch l=0.15 w=1 nf=1 m=1
M5 net7 net3 VDD VDD pch l=0.15 w=1 nf=1 m=1
M6 net3 VB3 net7 VDD pch l=0.15 w=1 nf=1 m=1
M7 net3 VBN net5 VSS nch l=0.15 w=1 nf=1 m=1
M8 net5 VB2 VSS VSS nch l=0.15 w=1 nf=1 m=1
M9 net1 VB1 VDD VDD pch l=0.15 w=1 nf=1 m=1
MN1 net8 VCONT2 VSS VSS nch l=0.15 w=1 nf=1 m=1
MN2 VX VCONT3 VSS VSS nch l=0.15 w=1 nf=1 m=1
MP2 VX VG VOUT VOUT pch l=0.15 w=1 nf=1 m=1
MP3 net8 VCONT1 VSTO VSTO pch l=0.15 w=1 nf=1 m=1
R1 net6 VSS 1k
.ends dut
