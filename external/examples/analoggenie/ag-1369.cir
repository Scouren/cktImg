* official Analog Canvas netlist; PDK X cards rewritten by convert.py
.model nch nmos
.model pch pmos

.subckt comp VDD VSS INN OUT VB1 VB2 VB3
M1 net8 VB2 VDD VDD pch l=0.15 w=1 nf=1 m=1
M10 net0 VB4 net3 VSS nch l=0.15 w=1 nf=1 m=1
M11 net2 VB4 net10 VSS nch l=0.15 w=1 nf=1 m=1
M12 net1 net5 VSS VSS nch l=0.15 w=1 nf=1 m=1
M13 net9 net5 VSS VSS nch l=0.15 w=1 nf=1 m=1
M14 net3 net2 VSS VSS nch l=0.15 w=1 nf=1 m=1
M15 net10 net2 VSS VSS nch l=0.15 w=1 nf=1 m=1
M16 VB4 VB5 VDD VDD pch l=0.15 w=1 nf=1 m=1
M17 VB4 VB4 net6 VSS nch l=0.15 w=1 nf=1 m=1
M18 net6 VB4 VSS VSS nch l=0.15 w=1 nf=1 m=1
M19 VB5 VB5 VDD VDD pch l=0.15 w=1 nf=1 m=1
M2 net5 INN net8 VDD pch l=0.15 w=1 nf=1 m=1
M20 VB5 VX VSS VSS nch l=0.15 w=1 nf=1 m=1
M21 net7 VB5 VDD VDD pch l=0.15 w=1 nf=1 m=1
M22 net7 net7 VX VSS nch l=0.15 w=1 nf=1 m=1
M23 VX net7 net4 VSS nch l=0.15 w=1 nf=1 m=1
M24 VY VB5 VDD VDD pch l=0.15 w=1 nf=1 m=1
M25 VY VY net4 VSS nch l=0.15 w=1 nf=1 m=1
M26 net4 VY VB3 VSS nch l=0.15 w=1 nf=1 m=1
M27 VB3 VB3 VSS VSS nch l=0.15 w=1 nf=1 m=1
M28 VB3 VB5 VDD VDD pch l=0.15 w=1 nf=1 m=1
M3 net2 OUT net8 VDD pch l=0.15 w=1 nf=1 m=1
M4 VX net0 VDD VDD pch l=0.15 w=1 nf=1 m=1
M5 VY net0 VDD VDD pch l=0.15 w=1 nf=1 m=1
M6 OUT VB1 VX VDD pch l=0.15 w=1 nf=1 m=1
M7 net0 VB1 VY VDD pch l=0.15 w=1 nf=1 m=1
M8 net5 VB4 net1 VSS nch l=0.15 w=1 nf=1 m=1
M9 OUT VB4 net9 VSS nch l=0.15 w=1 nf=1 m=1
.ends comp

.subckt dut VDD VSS VSTO VCONT1 VCONT2 VCONT3 VOUT VB1 VB2 VB3
CL VOUT VSS 1p
CSTO VSTO VSS 1p
LRX net2 net0 1n
MN1 net2 VCONT2 VSS VSS nch l=0.15 w=1 nf=1 m=1
MN2 net0 VCONT3 VSS VSS nch l=0.15 w=1 nf=1 m=1
MP2 net0 net1 VOUT VDD pch l=0.15 w=1 nf=1 m=1
MP3 net2 VCONT1 VSTO VDD pch l=0.15 w=1 nf=1 m=1
X1 VDD VSS net0 net1 VB1 VB2 VB3 comp
.ends dut
