* official Analog Canvas netlist; PDK X cards rewritten by convert.py
.model nch nmos
.model pch pmos

.subckt Comparator VDD VSS CLK INN INP OUT
M41 net2 CLK VDD VDD pch l=0.15 w=1 nf=1 m=1
M42 net0 CLK VDD VDD pch l=0.15 w=1 nf=1 m=1
M43 net0 OUT VDD VDD pch l=0.15 w=1 nf=1 m=1
M44 OUT net0 VDD VDD pch l=0.15 w=1 nf=1 m=1
M45 OUT CLK VDD VDD pch l=0.15 w=1 nf=1 m=1
M46 net3 CLK VDD VDD pch l=0.15 w=1 nf=1 m=1
M47 net0 OUT net2 VSS nch l=0.15 w=1 nf=1 m=1
M48 OUT net0 net3 VSS nch l=0.15 w=1 nf=1 m=1
M49 net2 INP net1 VSS nch l=0.15 w=1 nf=1 m=1
M50 net3 INN net1 VSS nch l=0.15 w=1 nf=1 m=1
M51 net1 CLK VSS VSS nch l=0.15 w=1 nf=1 m=1
.ends Comparator

.subckt Opamp VDD VSS INN INP OUT
M10 net5 INN net0 VSS nch l=0.15 w=1 nf=1 m=1
M11 net4 INP net0 VSS nch l=0.15 w=1 nf=1 m=1
M12 net0 VB3 VSS VSS nch l=0.15 w=1 nf=1 m=1
M13 net1 net1 VSS VSS nch l=0.15 w=1 nf=1 m=1
M14 OUT net1 VSS VSS nch l=0.15 w=1 nf=1 m=1
M15 net2 net2 VDD VDD pch l=0.15 w=1 nf=1 m=1
M16 VB3 net2 VDD VDD pch l=0.15 w=1 nf=1 m=1
M17 VB1 VB1 VDD VDD pch l=0.15 w=1 nf=1 m=1
M18 net2 VY VSS VSS nch l=0.15 w=1 nf=1 m=1
M19 VB3 VB3 VSS VSS nch l=0.15 w=1 nf=1 m=1
M20 VB1 VB3 VSS VSS nch l=0.15 w=1 nf=1 m=1
M21 VB2 VB2 VDD VDD pch l=0.15 w=1 nf=1 m=1
M22 VY VB2 VDD VDD pch l=0.15 w=1 nf=1 m=1
M23 net3 VB2 VDD VDD pch l=0.15 w=1 nf=1 m=1
M24 net7 VB2 VDD VDD pch l=0.15 w=1 nf=1 m=1
M25 VB2 VX VSS VSS nch l=0.15 w=1 nf=1 m=1
M26 VY VY VSS VSS nch l=0.15 w=1 nf=1 m=1
M27 net3 net3 VX VSS nch l=0.15 w=1 nf=1 m=1
M28 VX net3 net6 VSS nch l=0.15 w=1 nf=1 m=1
M29 net7 net7 net6 VSS nch l=0.15 w=1 nf=1 m=1
M30 net6 net7 VY VSS nch l=0.15 w=1 nf=1 m=1
M6 net1 net5 VDD VDD pch l=0.15 w=1 nf=1 m=1
M7 net5 net5 VDD VDD pch l=0.15 w=1 nf=1 m=1
M8 net4 net4 VDD VDD pch l=0.15 w=1 nf=1 m=1
M9 OUT net4 VDD VDD pch l=0.15 w=1 nf=1 m=1
.ends Opamp

.subckt dut VDD VSS phi2 phi1 vout clk
C1 net1 vout 1p
C2 net0 net2 1p
C3 net1 vx 1p
M1 net1 phi2 net0 VSS nch l=0.15 w=1 nf=1 m=1
M2 net0 phi1 VSS VSS nch l=0.15 w=1 nf=1 m=1
M3 net2 phi2 VSS VSS nch l=0.15 w=1 nf=1 m=1
M4 net2 phi1 vout VSS nch l=0.15 w=1 nf=1 m=1
X1 VDD VSS net1 VSS vx Opamp
X2 VDD VSS clk vx VSS vout Comparator
.ends dut
