* official Analog Canvas netlist; PDK X cards rewritten by convert.py
.model nch nmos
.model pch pmos
.model qnpn npn

.subckt opamp VDD VSS INN INP VB2 VB1 VB3 VC OUT
M1 net3 INN net0 VSS nch l=0.15 w=1 nf=1 m=1
M10 net5 net2 VSS VSS nch l=0.15 w=1 nf=1 m=1
M11 net4 net2 VSS VSS nch l=0.15 w=1 nf=1 m=1
M2 net1 INP net0 VSS nch l=0.15 w=1 nf=1 m=1
M3 net0 VB2 VSS VSS nch l=0.15 w=1 nf=1 m=1
M4 net3 VB1 VDD VDD pch l=0.15 w=1 nf=1 m=1
M5 net1 VB1 VDD VDD pch l=0.15 w=1 nf=1 m=1
M6 net2 VB3 net3 VDD pch l=0.15 w=1 nf=1 m=1
M7 OUT VB3 net1 VDD pch l=0.15 w=1 nf=1 m=1
M8 net2 VC net5 VSS nch l=0.15 w=1 nf=1 m=1
M9 OUT VC net4 VSS nch l=0.15 w=1 nf=1 m=1
.ends opamp

.subckt dut VDD VSS Vout VB4 VB1 VB2 VB3
M12 net0 net0 VDD VDD pch l=0.15 w=1 nf=1 m=1
M13 VB4 net0 VDD VDD pch l=0.15 w=1 nf=1 m=1
M14 VC net0 VDD VDD pch l=0.15 w=1 nf=1 m=1
M15 net0 VB4 VSS VSS nch l=0.15 w=1 nf=1 m=1
M16 net1 VB4 VSS VSS nch l=0.15 w=1 nf=1 m=1
M17 VC VC Z VSS nch l=0.15 w=1 nf=1 m=1
M18 Z VC VSS VSS nch l=0.15 w=1 nf=1 m=1
Q1 X X VSS VSS qnpn m=1
Q2 Z Z VSS VSS qnpn m=1
R1 Vout X 1k
R2 Vout Y 1k
R3 Y Z 1k
R4 VB4 net1 1k
X1 VDD VSS Y X VB2 VB1 VB3 VC Vout opamp
.ends dut
