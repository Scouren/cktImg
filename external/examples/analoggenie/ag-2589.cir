* official Analog Canvas netlist; PDK X cards rewritten by convert.py
.model nch nmos
.model pch pmos

.subckt AMP1 VDD VSS INP INN OUT TAIL VB1 VB3 VB2
M10 net0 net4 VDD VDD pch l=0.15 w=1 nf=1 m=1
M11 net4 VB3 net7 VDD pch l=0.15 w=1 nf=1 m=1
M12 OUT VB3 net0 VDD pch l=0.15 w=1 nf=1 m=1
M13 net4 VC net1 VSS nch l=0.15 w=1 nf=1 m=1
M14 OUT VC net5 VSS nch l=0.15 w=1 nf=1 m=1
M15 net1 VB2 VSS VSS nch l=0.15 w=1 nf=1 m=1
M16 net5 VB2 VSS VSS nch l=0.15 w=1 nf=1 m=1
M17 VC net3 VDD VDD pch l=0.15 w=1 nf=1 m=1
M18 VC VC net6 VSS nch l=0.15 w=1 nf=1 m=1
M19 net6 VC VSS VSS nch l=0.15 w=1 nf=1 m=1
M20 net3 net3 net2 VDD pch l=0.15 w=1 nf=1 m=1
M6 TAIL VB1 VDD VDD pch l=0.15 w=1 nf=1 m=1
M7 net1 INP TAIL VDD pch l=0.15 w=1 nf=1 m=1
M8 net5 INN TAIL VDD pch l=0.15 w=1 nf=1 m=1
M9 net7 net4 VDD VDD pch l=0.15 w=1 nf=1 m=1
R3 VDD net2 1k
R4 net3 VSS 1k
.ends AMP1

.subckt dut VDD VSS biasp biascas biasn Vref Vout VB1 VB2 VB3
C1 Vset VSS 1p
C2 n3 Vout 1p
M1 Vout n3 VDD VDD pch l=0.15 w=1 nf=1 m=1
M2 n1 Vset Vout VDD pch l=0.15 w=1 nf=1 m=1
M3 n1 biasn VSS VSS nch l=0.15 w=1 nf=1 m=1
M4 n3 biasp VDD VDD pch l=0.15 w=1 nf=1 m=1
M5 n3 biascas n1 VSS nch l=0.15 w=1 nf=1 m=1
R1 fb VSS 1k
R2 Vout fb 1k
X1 VDD VSS Vref fb Vset n3 VB1 VB3 VB2 AMP1
.ends dut
