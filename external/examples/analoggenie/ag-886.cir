* official Analog Canvas netlist; PDK X cards rewritten by convert.py
.model nch nmos
.model pch pmos

.subckt dut VDD VSS VINP VINN vo
CC net7 vo 1p
IBIAS net0 VSS DC 1m
IC net9 VSS DC 1m
M1 net1 VINP net8 VDD pch l=0.15 w=1 nf=1 m=1
M10 VDD net7 net4 VSS nch l=0.15 w=1 nf=1 m=1
M11 net4 net5 VSS VSS nch l=0.15 w=1 nf=1 m=1
M1A net2 net9 net1 VDD pch l=0.15 w=1 nf=1 m=1
M2 net3 VINN net8 VDD pch l=0.15 w=1 nf=1 m=1
M2A net7 net9 net3 VDD pch l=0.15 w=1 nf=1 m=1
M3 net5 net5 VSS VSS nch l=0.15 w=1 nf=1 m=1
M3A net2 net2 net5 VSS nch l=0.15 w=1 nf=1 m=1
M4 net6 net5 VSS VSS nch l=0.15 w=1 nf=1 m=1
M4A net7 net2 net6 VSS nch l=0.15 w=1 nf=1 m=1
M5 net8 net0 VDD VDD pch l=0.15 w=1 nf=1 m=1
M6 vo net4 VSS VSS nch l=0.15 w=1 nf=1 m=1
M7 vo net0 VDD VDD pch l=0.15 w=1 nf=1 m=1
M8 net0 net0 VDD VDD pch l=0.15 w=1 nf=1 m=1
M9 net9 net9 net8 VDD pch l=0.15 w=1 nf=1 m=1
.ends dut
