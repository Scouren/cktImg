* official Analog Canvas netlist; PDK X cards rewritten by convert.py
.model nch nmos
.model pch pmos

.subckt dut VDD VSS VBIASP vout- vout+ FB vin+ vin- Reset VBIASN
VB1 net1 VSS DC 1
M1 net0 vin+ net3 VSS nch l=0.15 w=1 nf=1 m=1
M10 vout- Reset vout+ VSS nch l=0.15 w=1 nf=1 m=1
M11 vout- FB vin+ VSS nch l=0.15 w=1 nf=1 m=1
M12 vout+ FB vin- VSS nch l=0.15 w=1 nf=1 m=1
M2 net2 vin- net3 VSS nch l=0.15 w=1 nf=1 m=1
M3 vout- vout- VDD VDD pch l=0.15 w=1 nf=1 m=1
M4 vout+ vout+ VDD VDD pch l=0.15 w=1 nf=1 m=1
M5 vout- VBIASP VDD VDD pch l=0.15 w=1 nf=1 m=1
M6 vout+ VBIASP VDD VDD pch l=0.15 w=1 nf=1 m=1
M7 vout- net1 net0 VSS nch l=0.15 w=1 nf=1 m=1
M8 vout+ net1 net2 VSS nch l=0.15 w=1 nf=1 m=1
M9 net3 VBIASN VSS VSS nch l=0.15 w=1 nf=1 m=1
.ends dut
