* official Analog Canvas netlist; PDK X cards rewritten by convert.py
.model nch nmos
.model pch pmos

.subckt Opamp VDD VSS VB1 INP INN VB2 OUT
M1 net1 VB1 VDD VDD pch l=0.15 w=1 nf=1 m=1
M10 OUT VB4 net3 VSS nch l=0.15 w=1 nf=1 m=1
M11 net3 VB5 VSS VSS nch l=0.15 w=1 nf=1 m=1
M12 VB4 VP VDD VDD pch l=0.15 w=1 nf=1 m=1
M13 VB4 VB4 VB5 VSS nch l=0.15 w=1 nf=1 m=1
M14 VB5 VB5 VSS VSS nch l=0.15 w=1 nf=1 m=1
M15 VB3 VP VDD VDD pch l=0.15 w=1 nf=1 m=1
M16 VB3 VB3 VSS VSS nch l=0.15 w=1 nf=1 m=1
M17 VP VP VDD VDD pch l=0.15 w=1 nf=1 m=1
M18 VP VB3 net0 VSS nch l=0.15 w=1 nf=1 m=1
M19 net0 net2 VSS VSS nch l=0.15 w=1 nf=1 m=1
M2 net4 INP net1 VDD pch l=0.15 w=1 nf=1 m=1
M20 net2 VP VDD VDD pch l=0.15 w=1 nf=1 m=1
M21 net2 net2 VSS VSS nch l=0.15 w=1 nf=1 m=1
M3 net3 INN net1 VDD pch l=0.15 w=1 nf=1 m=1
M4 net6 VX VDD VDD pch l=0.15 w=1 nf=1 m=1
M5 VX VB2 net6 VDD pch l=0.15 w=1 nf=1 m=1
M6 VX VB4 net4 VSS nch l=0.15 w=1 nf=1 m=1
M7 net4 VB5 VSS VSS nch l=0.15 w=1 nf=1 m=1
M8 net5 VX VDD VDD pch l=0.15 w=1 nf=1 m=1
M9 OUT VB2 net5 VDD pch l=0.15 w=1 nf=1 m=1
.ends Opamp

.subckt dut VDD VSS Vref VB1 VB2 VIN VOUT
CL VOUT net1 1p
M1 VIN net2 VOUT VSS nch l=0.15 w=1 nf=1 m=1
R1 VOUT net0 1k
R2 net0 VSS 1k
R3 net1 VSS 1k
X1 VDD VSS VB1 Vref net0 VB2 net2 Opamp
.ends dut
