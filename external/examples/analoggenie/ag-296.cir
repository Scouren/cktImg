* official Analog Canvas netlist; PDK X cards rewritten by convert.py
.model nch nmos
.model pch pmos

.subckt dut VDD VSS Vb Vin1 Vin2 Vout
ISS net1 VSS DC 1m
M1 net0 Vin1 net1 VSS nch l=0.15 w=1 nf=1 m=1
M2 net3 Vin2 net1 VSS nch l=0.15 w=1 nf=1 m=1
M3 X Vb net0 VSS nch l=0.15 w=1 nf=1 m=1
M4 Vout Vb net3 VSS nch l=0.15 w=1 nf=1 m=1
M5 X X net2 VDD pch l=0.15 w=1 nf=1 m=1
M6 Vout X net4 VDD pch l=0.15 w=1 nf=1 m=1
M7 net2 net2 VDD VDD pch l=0.15 w=1 nf=1 m=1
M8 net4 net2 VDD VDD pch l=0.15 w=1 nf=1 m=1
.ends dut
