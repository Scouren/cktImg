* official Analog Canvas netlist; PDK X cards rewritten by convert.py
.model nch nmos

.subckt dut VDD VSS Vout Vb2 Vb1
C1 VDD Vout 1p
L1 VDD Vout 1n
M1 X Vb1 net1 VSS nch l=0.15 w=1 nf=1 m=1
M2 Vout Vb2 X VSS nch l=0.15 w=1 nf=1 m=1
R1 VDD Vout 1k
RS net0 net1 1k
Vin net0 VSS DC 1
.ends dut
