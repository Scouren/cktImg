* official Analog Canvas netlist; PDK X cards rewritten by convert.py
.model nch nmos
.model pch pmos

.subckt bias VDD VSS VBN VB2 VB1
M12 VB2 VB2 VDD VDD pch l=0.15 w=1 nf=1 m=1
M13 VB2 net1 VSS VSS nch l=0.15 w=1 nf=1 m=1
M14 net4 VB2 VDD VDD pch l=0.15 w=1 nf=1 m=1
M15 net4 net4 net1 VSS nch l=0.15 w=1 nf=1 m=1
M16 net1 net4 net3 VSS nch l=0.15 w=1 nf=1 m=1
M17 net2 VB2 VDD VDD pch l=0.15 w=1 nf=1 m=1
M18 net2 net2 net3 VSS nch l=0.15 w=1 nf=1 m=1
M19 net3 net2 net0 VSS nch l=0.15 w=1 nf=1 m=1
M20 net0 net0 VSS VSS nch l=0.15 w=1 nf=1 m=1
M21 net0 VB2 VDD VDD pch l=0.15 w=1 nf=1 m=1
M22 net5 net0 VSS VSS nch l=0.15 w=1 nf=1 m=1
M23 net5 net5 VDD VDD pch l=0.15 w=1 nf=1 m=1
M24 VBN net5 VDD VDD pch l=0.15 w=1 nf=1 m=1
M25 VBN VBN VSS VSS nch l=0.15 w=1 nf=1 m=1
M26 VB1 VBN VSS VSS nch l=0.15 w=1 nf=1 m=1
M27 VB1 VB1 VDD VDD pch l=0.15 w=1 nf=1 m=1
.ends bias

.subckt erramp VDD VSS VREF VBN OUT
M10 net2 VREF net0 VSS nch l=0.15 w=1 nf=1 m=1
M11 net0 VBN VSS VSS nch l=0.15 w=1 nf=1 m=1
M3 net1 net1 VDD VDD pch l=0.15 w=1 nf=1 m=1
M4 OUT net1 VDD VDD pch l=0.15 w=1 nf=1 m=1
M5 OUT net2 VDD VDD pch l=0.15 w=1 nf=1 m=1
M6 net2 net2 VDD VDD pch l=0.15 w=1 nf=1 m=1
M7 net1 OUT net0 VSS nch l=0.15 w=1 nf=1 m=1
M8 OUT OUT VSS VSS nch l=0.15 w=1 nf=1 m=1
M9 OUT OUT VSS VSS nch l=0.15 w=1 nf=1 m=1
.ends erramp

.subckt dut VDD VSS VIN VREF pb nb VOUT VERR VB1 VB2
M1 net2 net3 VIN VDD pch l=0.15 w=1 nf=1 m=1
M10 VERR nb VSS VSS nch l=0.15 w=1 nf=1 m=1
M2 net0 net0 net2 VDD pch l=0.15 w=1 nf=1 m=1
M3 net0 nb VSS VSS nch l=0.15 w=1 nf=1 m=1
M4 net5 pb VIN VDD pch l=0.15 w=1 nf=1 m=1
M5 net1 net3 net5 VDD pch l=0.15 w=1 nf=1 m=1
M6 net1 net1 VSS VSS nch l=0.15 w=1 nf=1 m=1
M7 VERR net1 VSS VSS nch l=0.15 w=1 nf=1 m=1
M8 VOUT VERR VIN VDD pch l=0.15 w=1 nf=1 m=1
M9 VERR net0 VOUT VDD pch l=0.15 w=1 nf=1 m=1
X1 VDD VSS net4 VB2 VB1 bias
X2 VDD VSS VREF net4 net3 erramp
.ends dut
