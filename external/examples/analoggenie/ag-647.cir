* official Analog Canvas netlist; PDK X cards rewritten by convert.py
.model nch nmos

.subckt dut VDD VSS Vout1 Vout2 Vvco1 Vvco2 Vsig1 Vsig2
C1 Vout2 Vout1 1p
I1 net1 VSS DC 20uA
M1 Vout1 Vvco1 net0 VSS nch l=0.15 w=1 nf=1 m=1
M2 Vout2 Vvco2 net0 VSS nch l=0.15 w=1 nf=1 m=1
M3 Vout1 Vvco2 net2 VSS nch l=0.15 w=1 nf=1 m=1
M4 Vout2 Vvco1 net2 VSS nch l=0.15 w=1 nf=1 m=1
M5 net0 Vsig1 net1 VSS nch l=0.15 w=1 nf=1 m=1
M6 net2 Vsig2 net1 VSS nch l=0.15 w=1 nf=1 m=1
R1 VDD Vout1 20kΩ
R2 VDD Vout2 20kΩ
.ends dut
