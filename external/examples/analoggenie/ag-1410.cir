* official Analog Canvas netlist; PDK X cards rewritten by convert.py
.model nch nmos
.model pch pmos

.subckt dut VDD VSS VSTO VCONT1 VCONT2 VCONT3 VOUT
C1 VSTO VSS 1p
C2 VOUT VSS 1p
L1 net1 VX 1n
M1 net1 VCONT1 VSTO VDD pch l=0.15 w=1 nf=1 m=1
M10 VC VC VDD VDD pch l=0.15 w=1 nf=1 m=1
M11 VC net0 VSS VSS nch l=0.15 w=1 nf=1 m=1
M12 net0 VA VDD VDD pch l=0.15 w=1 nf=1 m=1
M13 net0 net0 VSS VSS nch l=0.15 w=1 nf=1 m=1
M14 VB1 net2 VDD VDD pch l=0.15 w=1 nf=1 m=1
M15 net2 net2 VDD VDD pch l=0.15 w=1 nf=1 m=1
M16 VB1 VB1 VSS VSS nch l=0.15 w=1 nf=1 m=1
M2 net1 VCONT2 VSS VSS nch l=0.15 w=1 nf=1 m=1
M3 VX VCONT3 VSS VSS nch l=0.15 w=1 nf=1 m=1
M4 VX VC VOUT VDD pch l=0.15 w=1 nf=1 m=1
M5 VA VA VDD VDD pch l=0.15 w=1 nf=1 m=1
M6 VA VX net3 VSS nch l=0.15 w=1 nf=1 m=1
M7 VC VC VDD VDD pch l=0.15 w=1 nf=1 m=1
M8 VC VC net3 VSS nch l=0.15 w=1 nf=1 m=1
M9 net3 VB1 VSS VSS nch l=0.15 w=1 nf=1 m=1
R1 net2 VSS 1k
.ends dut
