* official Analog Canvas netlist; PDK X cards rewritten by convert.py
.model nch nmos

.subckt dut VCC VEE v1 v2 Iout1 Iout2
I1 VCC Iout1 DC 1m
I2 VCC Iout2 DC 1m
I3 vx VEE DC 1m
I4 vy VEE DC 1m
M1 Iout1 v1 vx VEE nch l=0.15 w=1 nf=1 m=1
M2 Iout2 v2 vy VEE nch l=0.15 w=1 nf=1 m=1
M3 vy v1 vx VEE nch l=0.15 w=1 nf=1 m=1
M4 vx v2 vy VEE nch l=0.15 w=1 nf=1 m=1
.ends dut
