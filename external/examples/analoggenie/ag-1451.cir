* official Analog Canvas netlist; PDK X cards rewritten by convert.py
.model nch nmos
.model pch pmos

.subckt dut VDD VSS VSTO VOUT VCONT1 VCONT2 VCONT3
CL VOUT VSS 1p
CSTO VSTO VSS 1p
LRX net5 VX 1n
M1 net2 VX net4 VSS nch l=0.15 w=1 nf=1 m=1
M10 VB1 net1 VSS VSS nch l=0.15 w=1 nf=1 m=1
M11 VB2 VB2 VSS VSS nch l=0.15 w=1 nf=1 m=1
M12 VB2 VB1 VDD VDD pch l=0.15 w=1 nf=1 m=1
M13 VB1 VB1 VDD VDD pch l=0.15 w=1 nf=1 m=1
M14 net1 net1 VSS VSS nch l=0.15 w=1 nf=1 m=1
M15 net1 net3 VDD VDD pch l=0.15 w=1 nf=1 m=1
M16 net3 net3 net1 VDD pch l=0.15 w=1 nf=1 m=1
M2 VCMP VCMP VDD VDD pch l=0.15 w=1 nf=1 m=1
M3 net2 net2 VDD VDD pch l=0.15 w=1 nf=1 m=1
M4 VCMP VCMP net4 VSS nch l=0.15 w=1 nf=1 m=1
M5 net4 VB2 VSS VSS nch l=0.15 w=1 nf=1 m=1
M6 VCMP VCMP VDD VDD pch l=0.15 w=1 nf=1 m=1
M7 net0 net2 VDD VDD pch l=0.15 w=1 nf=1 m=1
M8 VCMP net0 VSS VSS nch l=0.15 w=1 nf=1 m=1
M9 net0 net0 VSS VSS nch l=0.15 w=1 nf=1 m=1
MN1 net5 VCONT2 VSS VSS nch l=0.15 w=1 nf=1 m=1
MN2 VX VCONT3 VSS VSS nch l=0.15 w=1 nf=1 m=1
MP2 VX VCMP VOUT VDD pch l=0.15 w=1 nf=1 m=1
MP3 net5 VCONT1 VSTO VDD pch l=0.15 w=1 nf=1 m=1
R1 VDD net1 1k
R2 net3 VSS 1k
.ends dut
