* official Analog Canvas netlist; PDK X cards rewritten by convert.py
.model nch nmos
.model pch pmos

.subckt dut VDD VSS VIN VP VS5 VS1 VS2 VS3 VS4 VB3 VB1 VB2 VREF
.model DIODE D(IS=1e-14 N=1)
CFLY VX1 VX2 1p
CO VP VN 1p
COP VP VSS 1p
D1 VN VX2 DIODE
L1 VX1 VX3 1n
MN1 net7 VREF net9 VSS nch l=0.15 w=1 nf=1 m=1
MN10 VCTRL VBN net8 VSS nch l=0.15 w=1 nf=1 m=1
MN11 VX1 VX VSS VSS nch l=0.15 w=1 nf=1 m=1
MN12 net8 VX VSS VSS nch l=0.15 w=1 nf=1 m=1
MN13 net6 VBN VSS VSS nch l=0.15 w=1 nf=1 m=1
MN14 VBN VBN net6 VSS nch l=0.15 w=1 nf=1 m=1
MN2 net1 VFP1 net9 VSS nch l=0.15 w=1 nf=1 m=1
MN4 net9 VB2 VSS VSS nch l=0.15 w=1 nf=1 m=1
MN6 net2 net0 VSS VSS nch l=0.15 w=1 nf=1 m=1
MN7 net0 net0 VSS VSS nch l=0.15 w=1 nf=1 m=1
MN8 net0 VB3 VSS VSS nch l=0.15 w=1 nf=1 m=1
MN9 VX VBN VX1 VSS nch l=0.15 w=1 nf=1 m=1
MP1 net10 net1 VDD VDD pch l=0.15 w=1 nf=1 m=1
MP10 VX VB1 VFP1 VDD pch l=0.15 w=1 nf=1 m=1
MP11 VCTRL VB1 net3 VDD pch l=0.15 w=1 nf=1 m=1
MP12 VBN net5 VDD VDD pch l=0.15 w=1 nf=1 m=1
MP13 net5 net5 net4 VDD pch l=0.15 w=1 nf=1 m=1
MP2 VN net7 VDD VDD pch l=0.15 w=1 nf=1 m=1
MP3 VFP1 net1 VDD VDD pch l=0.15 w=1 nf=1 m=1
MP4 net2 net2 VA VDD pch l=0.15 w=1 nf=1 m=1
MP5 VX1 net2 VA VDD pch l=0.15 w=1 nf=1 m=1
MP6 net0 VCTRL VA VDD pch l=0.15 w=1 nf=1 m=1
MP7 net3 net7 VDD VDD pch l=0.15 w=1 nf=1 m=1
MP8 net1 VB1 net10 VDD pch l=0.15 w=1 nf=1 m=1
MP9 net7 VB1 VN VDD pch l=0.15 w=1 nf=1 m=1
MS1 VX1 VS1 VIN VDD pch l=0.15 w=1 nf=1 m=1
MS2 VX2 VS2 VIN VDD pch l=0.15 w=1 nf=1 m=1
MS3 VP VS3 VX3 VDD pch l=0.15 w=1 nf=1 m=1
MS4 VX3 VS4 VSS VSS nch l=0.15 w=1 nf=1 m=1
MS5 VA VS5 VIN VDD pch l=0.15 w=1 nf=1 m=1
R1 VP VFP1 1k
R2 VFP1 VSS 1k
R3 net5 VSS 1k
RBIAS VDD net4 1k
.ends dut
