* official Analog Canvas netlist; PDK X cards rewritten by convert.py
.model nch nmos
.model pch pmos

.subckt dut VDD VSS s+ s- Out- Out+ p+ p- Vcontrol
M1 Out- net0 VDD VDD pch l=0.15 w=1 nf=1 m=1
M2 Out+ net1 VDD VDD pch l=0.15 w=1 nf=1 m=1
M3 net0 Vcontrol Out+ VSS nch l=0.15 w=1 nf=1 m=1
M4 net1 Vcontrol Out- VSS nch l=0.15 w=1 nf=1 m=1
M5 Out- s+ VDD VDD pch l=0.15 w=1 nf=1 m=1
M6 Out+ s- VDD VDD pch l=0.15 w=1 nf=1 m=1
M7 Out- p+ VSS VSS nch l=0.15 w=1 nf=1 m=1
M8 Out+ p- VSS VSS nch l=0.15 w=1 nf=1 m=1
.ends dut
