* official Analog Canvas netlist; PDK X cards rewritten by convert.py
.model nch nmos
.model pch pmos

.subckt dut VDD SUB AC In Pulse
.model DIODE D(IS=1e-14 N=1)
D1 SUB In DIODE
I1 net8 SUB DC 10uA
M1 In In net9 SUB nch l=0.15 w=1 nf=1 m=1
M10 net7 net2 net5 VDD pch l=0.15 w=1 nf=1 m=1
M11 net7 net7 SUB SUB nch l=0.15 w=1 nf=1 m=1
M12 net10 net8 VDD VDD pch l=0.15 w=1 nf=1 m=1
M13 net10 net7 SUB SUB nch l=0.15 w=1 nf=1 m=2
M14 net1 net8 VDD VDD pch l=0.15 w=1 nf=1 m=1
M15 net1 net0 SUB SUB nch l=0.15 w=1 nf=1 m=2
M16 net6 net8 VDD VDD pch l=0.15 w=1 nf=1 m=1
M17 net6 net10 net4 SUB nch l=0.15 w=1 nf=1 m=2
M18 net4 net1 SUB SUB nch l=0.15 w=1 nf=1 m=2
M19 Pulse net6 VDD VDD pch l=0.15 w=1 nf=1 m=1
M2 net9 net9 SUB SUB nch l=0.15 w=1 nf=1 m=1
M20 Pulse net6 SUB SUB nch l=0.15 w=1 nf=1 m=1
M3 net8 net8 VDD VDD pch l=0.15 w=1 nf=1 m=1
M4 net3 net8 VDD VDD pch l=0.15 w=1 nf=1 m=1
M5 net0 In net3 VDD pch l=0.15 w=1 nf=1 m=1
M6 SUB SUB net3 VDD pch l=0.15 w=1 nf=1 m=1
M7 net0 net0 SUB SUB nch l=0.15 w=1 nf=1 m=1
M8 net5 net8 VDD VDD pch l=0.15 w=1 nf=1 m=1
M9 SUB In net5 VDD pch l=0.15 w=1 nf=1 m=1
Rext AC In 1MegΩ
V1 net2 SUB DC 200mV
.ends dut
