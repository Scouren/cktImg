* official Analog Canvas netlist; PDK X cards rewritten by convert.py
.model nch nmos
.model pch pmos
.model qpnp pnp

.subckt A1 VDD VSS INN INP VB2 VB1 OUT VP
M1 OUT VB3 VP VSS nch l=0.15 w=1 nf=1 m=1
M10 net0 VB3 net2 VSS nch l=0.15 w=1 nf=1 m=1
M11 net5 net4 VSS VSS nch l=0.15 w=1 nf=1 m=1
M12 VP net4 VSS VSS nch l=0.15 w=1 nf=1 m=1
M13 net1 net0 VDD VDD pch l=0.15 w=1 nf=1 m=1
M14 net10 net0 VDD VDD pch l=0.15 w=1 nf=1 m=1
M15 net2 net3 VSS VSS nch l=0.15 w=1 nf=1 m=1
M17 net6 net6 net8 VDD pch l=0.15 w=1 nf=1 m=1
M18 VB3 net6 VDD VDD pch l=0.15 w=1 nf=1 m=1
M19 VB3 VB3 net7 VSS nch l=0.15 w=1 nf=1 m=1
M2 net0 VB1 net1 VDD pch l=0.15 w=1 nf=1 m=1
M20 net7 VB3 VSS VSS nch l=0.15 w=1 nf=1 m=1
M3 OUT VB1 net10 VDD pch l=0.15 w=1 nf=1 m=1
M4 INN net3 VSS VSS nch l=0.15 w=1 nf=1 m=1
M5 net9 VB2 VDD VDD pch l=0.15 w=1 nf=1 m=1
M6 net3 INP net9 VDD pch l=0.15 w=1 nf=1 m=1
M7 net4 INN net9 VDD pch l=0.15 w=1 nf=1 m=1
M8 net3 VB3 INN VSS nch l=0.15 w=1 nf=1 m=1
M9 net4 VB3 net5 VSS nch l=0.15 w=1 nf=1 m=1
R4 VDD net8 1k
R5 net6 VSS 1k
.ends A1

.subckt dut VDD VSS Vout VB1 VB2
Q1 VSS VSS VP qpnp m=1
Q2 VP VP X qpnp m=1
Q3 VSS VSS net0 qpnp m=1
Q4 net0 net0 net1 qpnp m=1
R1 Vout X 1k
R2 Vout Y 1k
R3 Y net1 1k
X1 VDD VSS Y X VB2 VB1 Vout VP A1
.ends dut
