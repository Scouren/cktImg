* official Analog Canvas netlist; PDK X cards rewritten by convert.py
.model nch nmos

.subckt dut VDD VSS VOUT1 VB1 VIN1
L1 VDD VOUT1 1n
M1 Y VIN1 VSS VSS nch l=0.15 w=1 nf=1 m=1
M2 VOUT1 VB1 Y VSS nch l=0.15 w=1 nf=1 m=1
.ends dut
