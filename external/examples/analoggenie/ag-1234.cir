* official Analog Canvas netlist; PDK X cards rewritten by convert.py
.model nch nmos
.model pch pmos

.subckt dut VDD VSS VIN VS5 VS1 VS2 VS4 VS3 VP VB4 VB1 VREF VB2
.model DIODE D(IS=1e-14 N=1)
CFLY VX1 VX2 1p
CO VP VN 1p
COP VP VSS 1p
D1 VN VX2 DIODE
L1 VX1 VX3 1n
M1 VX1 VS1 VIN VDD pch l=0.15 w=1 nf=1 m=1
M2 VX2 VS2 VIN VDD pch l=0.15 w=1 nf=1 m=1
M3 VX3 VS3 VP VDD pch l=0.15 w=1 nf=1 m=1
M4 VX3 VS4 VSS VSS nch l=0.15 w=1 nf=1 m=1
M5 VX4 VS5 VIN VDD pch l=0.15 w=1 nf=1 m=1
MN1 net5 VB7 VSS VSS nch l=0.15 w=1 nf=1 m=1
MN10 net1 net1 VSS VSS nch l=0.15 w=1 nf=1 m=1
MN11 net0 VB4 VSS VSS nch l=0.15 w=1 nf=1 m=1
MN12 net2 net0 VSS VSS nch l=0.15 w=1 nf=1 m=1
MN13 net0 net0 VSS VSS nch l=0.15 w=1 nf=1 m=1
MN2 net6 VB7 VSS VSS nch l=0.15 w=1 nf=1 m=1
MN3 net3 VB6 net5 VSS nch l=0.15 w=1 nf=1 m=1
MN4 VEA1 VB6 net6 VSS nch l=0.15 w=1 nf=1 m=1
MN5 VB7 VB7 VSS VSS nch l=0.15 w=1 nf=1 m=1
MN6 VB6 VB6 VB7 VSS nch l=0.15 w=1 nf=1 m=1
MN7 VX4 VX4 VSS VSS nch l=0.15 w=1 nf=1 m=1
MN8 VX2 VX4 VSS VSS nch l=0.15 w=1 nf=1 m=1
MN9 VB5 net1 VX2 VSS nch l=0.15 w=1 nf=1 m=1
MP1 net4 VB1 VDD VDD pch l=0.15 w=1 nf=1 m=1
MP10 VB5 VB5 VDD VDD pch l=0.15 w=1 nf=1 m=1
MP11 net1 VB5 VDD VDD pch l=0.15 w=1 nf=1 m=1
MP12 VX1 net2 VX4 VDD pch l=0.15 w=1 nf=1 m=1
MP13 net2 net2 VX4 VDD pch l=0.15 w=1 nf=1 m=1
MP14 net0 VEA1 VX4 VDD pch l=0.15 w=1 nf=1 m=1
MP2 net5 VREF net4 VDD pch l=0.15 w=1 nf=1 m=1
MP3 net6 VFP1 net4 VDD pch l=0.15 w=1 nf=1 m=1
MP4 net8 net3 VDD VDD pch l=0.15 w=1 nf=1 m=1
MP5 net7 net3 VDD VDD pch l=0.15 w=1 nf=1 m=1
MP6 net3 VB2 net8 VDD pch l=0.15 w=1 nf=1 m=1
MP7 VEA1 VB2 net7 VDD pch l=0.15 w=1 nf=1 m=1
MP8 VB6 VB5 VDD VDD pch l=0.15 w=1 nf=1 m=1
MP9 VX4 VB5 VDD VDD pch l=0.15 w=1 nf=1 m=1
R1 VP VFP1 1k
R2 VFP1 VSS 1k
.ends dut
