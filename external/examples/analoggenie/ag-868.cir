* official Analog Canvas netlist; PDK X cards rewritten by convert.py
.model qnpn npn

.subckt dut VCC VEE VSS Vi
.model DIODE D(IS=1e-14 N=1)
D1 net0 net2 DIODE
Q1 VCC Vi Vo VSS qnpn m=1
Q2 Vo net0 net1 VSS qnpn m=1
R1 net2 VEE 1k
R2 net1 VEE 1k
R3 VSS net0 1k
RL Vo VSS 1k
.ends dut
