* official Analog Canvas netlist; PDK X cards rewritten by convert.py
.model nch nmos
.model pch pmos

.subckt opamp VDD VSS INP INN OUT
M10 net2 INP OUT VSS nch l=0.15 w=1 nf=1 m=1
M11 net6 INN OUT VSS nch l=0.15 w=1 nf=1 m=1
M12 OUT VB2 VSS VSS nch l=0.15 w=1 nf=1 m=1
M13 VC net5 VDD VDD pch l=0.15 w=1 nf=1 m=1
M14 VC VC net4 VSS nch l=0.15 w=1 nf=1 m=1
M15 net4 VC VSS VSS nch l=0.15 w=1 nf=1 m=1
M16 net5 net5 VDD VDD pch l=0.15 w=1 nf=1 m=1
M17 net5 VB4 VSS VSS nch l=0.15 w=1 nf=1 m=1
M18 VB4 net5 VDD VDD pch l=0.15 w=1 nf=1 m=1
M19 VB4 VB4 VSS VSS nch l=0.15 w=1 nf=1 m=1
M2 net2 VB1 VDD VDD pch l=0.15 w=1 nf=1 m=1
M3 OUT VB3 net2 VDD pch l=0.15 w=1 nf=1 m=1
M4 OUT VC net1 VSS nch l=0.15 w=1 nf=1 m=1
M5 net1 net3 VSS VSS nch l=0.15 w=1 nf=1 m=1
M6 net6 VB1 VDD VDD pch l=0.15 w=1 nf=1 m=1
M7 net3 VB3 net6 VDD pch l=0.15 w=1 nf=1 m=1
M8 net3 VC net0 VSS nch l=0.15 w=1 nf=1 m=1
M9 net0 net3 VSS VSS nch l=0.15 w=1 nf=1 m=1
.ends opamp

.subckt dut VDD VSS Vref VIN VOUT
CL VOUT net0 1p
MNP VIN net1 VOUT VSS nch l=0.15 w=1 nf=1 m=1
R1 VOUT FB 1k
R2 FB VSS 1k
R3 net0 VSS 1k
X1 VDD VSS Vref FB net1 opamp
.ends dut
