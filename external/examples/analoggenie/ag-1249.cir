* official Analog Canvas netlist; PDK X cards rewritten by convert.py
.model nch nmos
.model pch pmos

.subckt EA1 VDD VSS VCTRL VREF VFP1 VX3
MN1 VX3 VREF net1 VSS nch l=0.15 w=1 nf=1 m=1
MN10 net2 VB1 VSS VSS nch l=0.15 w=1 nf=1 m=1
MN11 VBN VBN VSS VSS nch l=0.15 w=1 nf=1 m=1
MN2 net0 VFP1 net1 VSS nch l=0.15 w=1 nf=1 m=1
MN3 net1 VBN VSS VSS nch l=0.15 w=1 nf=1 m=1
MN4 VCTRL VX VSS VSS nch l=0.15 w=1 nf=1 m=1
MN5 VX VX VSS VSS nch l=0.15 w=1 nf=1 m=1
MN9 net3 net2 VB1 VSS nch l=0.15 w=1 nf=1 m=1
MP1 VCTRL VX3 VDD VDD pch l=0.15 w=1 nf=1 m=1
MP10 VBN net3 VDD VDD pch l=0.15 w=1 nf=1 m=1
MP2 VX3 VX3 VDD VDD pch l=0.15 w=1 nf=1 m=1
MP3 net0 net0 VDD VDD pch l=0.15 w=1 nf=1 m=1
MP4 VX net0 VDD VDD pch l=0.15 w=1 nf=1 m=1
MP8 net2 net3 VDD VDD pch l=0.15 w=1 nf=1 m=1
MP9 net3 net3 VDD VDD pch l=0.15 w=1 nf=1 m=1
RBIAS VB1 VSS 1k
.ends EA1

.subckt dut VDD VSS VP VB2 VCONT1 VCONT2 VCONT4 VCONT5 VIN VCONT3 VREF
.model DIODE D(IS=1e-14 N=1)
CFLY VX1 VX2 1p
CO VP VN 1p
COP VP VSS 1p
D1 VN VX2 DIODE
L1 VX1 VX3 1n
M1 VX1 VCONT2 VIN VDD pch l=0.15 w=1 nf=1 m=1
M2 VX2 VCONT3 VIN VDD pch l=0.15 w=1 nf=1 m=1
M3 VX3 VCONT5 VP VDD pch l=0.15 w=1 nf=1 m=1
M4 VX3 VCONT4 VSS VSS nch l=0.15 w=1 nf=1 m=1
M5 net3 VCONT1 VIN VDD pch l=0.15 w=1 nf=1 m=1
MN6 net0 net2 VSS VSS nch l=0.15 w=1 nf=1 m=1
MN7 net2 net2 VSS VSS nch l=0.15 w=1 nf=1 m=1
MN8 net2 VB2 VSS VSS nch l=0.15 w=1 nf=1 m=1
MP5 net0 net0 net3 VDD pch l=0.15 w=1 nf=1 m=1
MP6 VX1 net0 net3 VDD pch l=0.15 w=1 nf=1 m=1
MP7 net2 net1 net3 VDD pch l=0.15 w=1 nf=1 m=1
R1 VP VFP1 1k
R2 VFP1 VSS 1k
X1 VDD VSS net1 VREF VFP1 VX3 EA1
.ends dut
