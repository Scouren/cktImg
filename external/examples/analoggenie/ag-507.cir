* official Analog Canvas netlist; PDK X cards rewritten by convert.py
.model nch nmos
.model pch pmos

.subckt dut VDD VSS VLO VLO_bar Vb VRF VIF1 VIF2
M1 P VRF VSS VSS nch l=0.15 w=1 nf=1 m=1
M2 VIF1 VLO P VSS nch l=0.15 w=1 nf=1 m=1
M3 VIF2 VLO_bar P VSS nch l=0.15 w=1 nf=1 m=1
M4 P Vb VDD VDD pch l=0.15 w=1 nf=1 m=1
R1 VDD VIF1 1k
R2 VDD VIF2 1k
.ends dut
