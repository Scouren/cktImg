* official Analog Canvas netlist; PDK X cards rewritten by convert.py
.model nch nmos
.model pch pmos
.model qpnp pnp

.subckt A1 VDD VSS INN INP OUT
M1 net6 net6 VDD VDD pch l=0.15 w=1 nf=1 m=1
M10 net1 net1 VSS VSS nch l=0.15 w=1 nf=1 m=1
M11 OUT net1 VSS VSS nch l=0.15 w=1 nf=1 m=1
M12 net5 net0 VSS VSS nch l=0.15 w=1 nf=1 m=1
M13 net0 net0 VSS VSS nch l=0.15 w=1 nf=1 m=1
M14 net4 net0 VSS VSS nch l=0.15 w=1 nf=1 m=1
M15 net4 net4 VDD VDD pch l=0.15 w=1 nf=1 m=1
M16 VB2 net4 VDD VDD pch l=0.15 w=1 nf=1 m=1
M17 VB2 VB2 VSS VSS nch l=0.15 w=1 nf=1 m=1
M18 VB1 VB2 VSS VSS nch l=0.15 w=1 nf=1 m=1
M19 VB1 VB1 VDD VDD pch l=0.15 w=1 nf=1 m=1
M2 net3 net3 VDD VDD pch l=0.15 w=1 nf=1 m=1
M5 OUT net6 VDD VDD pch l=0.15 w=1 nf=1 m=1
M6 net1 net3 VDD VDD pch l=0.15 w=1 nf=1 m=1
M7 net3 INN net2 VSS nch l=0.15 w=1 nf=1 m=1
M8 net6 INP net2 VSS nch l=0.15 w=1 nf=1 m=1
M9 net2 VB2 VSS VSS nch l=0.15 w=1 nf=1 m=1
R4 VDD net5 1k
R5 VDD net0 1k
R6 net5 net0 1k
.ends A1

.subckt dut VDD VSS Vout
Q1 VSS VSS net1 qpnp m=1
Q2 net1 net1 X qpnp m=1
Q3 VSS VSS net2 qpnp m=1
Q4 net2 net2 net0 qpnp m=1
R1 Vout X 1k
R2 Vout Y 1k
R3 Y net0 1k
X1 VDD VSS Y X Vout A1
.ends dut
