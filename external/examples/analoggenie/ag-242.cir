* official Analog Canvas netlist; PDK X cards rewritten by convert.py
.model nch nmos
.model pch pmos

.subckt dut VDD VSS Vin Vout Vb
C1 net1 Vout 1p
C2 Vin net1 1p
I1 net2 VSS DC 1m
M1 Vout net1 net2 VSS nch l=0.15 w=1 nf=1 m=1
M2 net0 Vb net2 VSS nch l=0.15 w=1 nf=1 m=1
M3 net0 net0 VDD VDD pch l=0.15 w=1 nf=1 m=1
M4 Vout net0 VDD VDD pch l=0.15 w=1 nf=1 m=1
.ends dut
