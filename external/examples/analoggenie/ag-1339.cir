* official Analog Canvas netlist; PDK X cards rewritten by convert.py
.model nch nmos
.model pch pmos

.subckt dut VDD VSS VCONT1 VCONT2 VCONT3 VIN VCONT5 VCONT4 VP VB2 VREF VB1
.model DIODE D(IS=1e-14 N=1)
CFLY VX1 VX2 1p
CO VP VN 1p
COP VP VSS 1p
D1 VN VX2 DIODE
L1 VX1 VX3 1n
M1 VX1 VCONT2 VIN VDD pch l=0.15 w=1 nf=1 m=1
M2 VX2 VCONT3 VIN VDD pch l=0.15 w=1 nf=1 m=1
M3 VP VCONT5 VX3 VDD pch l=0.15 w=1 nf=1 m=1
M4 VX3 VCONT4 VSS VSS nch l=0.15 w=1 nf=1 m=1
M5 net7 VCONT1 VIN VDD pch l=0.15 w=1 nf=1 m=1
MN1 net5 VX2 VSS VSS nch l=0.15 w=1 nf=1 m=1
MN10 VB1 VB1 VSS VSS nch l=0.15 w=1 nf=1 m=1
MN2 VCTRL net3 VSS VSS nch l=0.15 w=1 nf=1 m=1
MN3 net3 net3 VSS VSS nch l=0.15 w=1 nf=1 m=1
MN4 VX2 VX2 VSS VSS nch l=0.15 w=1 nf=1 m=1
MN5 net1 net1 VSS VSS nch l=0.15 w=1 nf=1 m=1
MN6 net4 net2 VSS VSS nch l=0.15 w=1 nf=1 m=1
MN7 net2 net2 VSS VSS nch l=0.15 w=1 nf=1 m=1
MN8 net2 VB2 VSS VSS nch l=0.15 w=1 nf=1 m=1
MN9 VBP net1 VSS VSS nch l=0.15 w=1 nf=1 m=1
MP1 net5 net5 VDD VDD pch l=0.15 w=1 nf=1 m=1
MP10 net1 net6 VDD VDD pch l=0.15 w=1 nf=1 m=1
MP11 VBP VBP VDD VDD pch l=0.15 w=1 nf=1 m=1
MP12 VB1 VBP VDD VDD pch l=0.15 w=1 nf=1 m=1
MP2 VCTRL net5 VDD VDD pch l=0.15 w=1 nf=1 m=1
MP3 net0 VBP VDD VDD pch l=0.15 w=1 nf=1 m=1
MP4 net4 net4 net7 VDD pch l=0.15 w=1 nf=1 m=1
MP5 VX1 net4 net7 VDD pch l=0.15 w=1 nf=1 m=1
MP6 net2 VCTRL net7 VDD pch l=0.15 w=1 nf=1 m=1
MP7 net3 VFP1 net0 VDD pch l=0.15 w=1 nf=1 m=1
MP8 VX2 VREF net0 VDD pch l=0.15 w=1 nf=1 m=1
MP9 net6 net6 VDD VDD pch l=0.15 w=1 nf=1 m=1
R1 VP VFP1 1k
R2 VFP1 VSS 1k
RBIAS net6 VSS 1k
.ends dut
