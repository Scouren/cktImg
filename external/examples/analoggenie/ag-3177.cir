* official Analog Canvas netlist; PDK X cards rewritten by convert.py
.model nch nmos
.model pch pmos

.subckt opamp VDD VSS INN INP OUT VX
M10 net2 VB2 net5 VDD pch l=0.15 w=1 nf=1 m=1
M11 OUT VB2 net6 VDD pch l=0.15 w=1 nf=1 m=1
M12 net2 VB4 net1 VSS nch l=0.15 w=1 nf=1 m=1
M13 OUT VB4 VX VSS nch l=0.15 w=1 nf=1 m=1
M14 net1 net2 VSS VSS nch l=0.15 w=1 nf=1 m=1
M15 VX net2 VSS VSS nch l=0.15 w=1 nf=1 m=1
M16 VB4 net0 VDD VDD pch l=0.15 w=1 nf=1 m=1
M17 VB4 VB4 VB5 VSS nch l=0.15 w=1 nf=1 m=1
M18 VB5 VB5 VSS VSS nch l=0.15 w=1 nf=1 m=1
M19 net0 net0 VDD VDD pch l=0.15 w=1 nf=1 m=1
M20 net0 VB3 VSS VSS nch l=0.15 w=1 nf=1 m=1
M21 VB3 net0 VDD VDD pch l=0.15 w=1 nf=1 m=1
M22 net4 VB3 VSS VSS nch l=0.15 w=1 nf=1 m=1
M5 net5 INN net3 VSS nch l=0.15 w=1 nf=1 m=1
M6 net6 INP net3 VSS nch l=0.15 w=1 nf=1 m=1
M7 net3 VB5 VSS VSS nch l=0.15 w=1 nf=1 m=1
M8 net5 VB1 VDD VDD pch l=0.15 w=1 nf=1 m=1
M9 net6 VB1 VDD VDD pch l=0.15 w=1 nf=1 m=1
R1 VB3 net4 1k
.ends opamp

.subckt dut VDD VSS vci phi1 phi2 vco
C1 VX net1 1p
C2 net0 vco 1p
M1 vci phi1 VX VSS nch l=0.15 w=1 nf=1 m=1
M2 VX phi2 VSS VSS nch l=0.15 w=1 nf=1 m=1
M3 net1 phi1 VSS VSS nch l=0.15 w=1 nf=1 m=1
M4 net1 phi2 net0 VSS nch l=0.15 w=1 nf=1 m=1
X1 VDD VSS net0 VSS vco VX opamp
.ends dut
