* official Analog Canvas netlist; PDK X cards rewritten by convert.py
.model nch nmos
.model pch pmos

.subckt dut VDD VSS vci phi1 phi2 vco VB1 VB2
C1 vcx VSS 1p
C2 net6 vco 1p
M1 vci phi1 vcx VSS nch l=0.15 w=1 nf=1 m=1
M10 net6 VB4 net5 VSS nch l=0.15 w=1 nf=1 m=1
M11 vco VB4 net3 VSS nch l=0.15 w=1 nf=1 m=1
M12 net5 net6 VSS VSS nch l=0.15 w=1 nf=1 m=1
M13 net3 net6 VSS VSS nch l=0.15 w=1 nf=1 m=1
M14 VB4 net0 VDD VDD pch l=0.15 w=1 nf=1 m=1
M15 VB4 VB4 VB5 VSS nch l=0.15 w=1 nf=1 m=1
M16 VB5 VB5 VSS VSS nch l=0.15 w=1 nf=1 m=1
M17 net0 net0 VDD VDD pch l=0.15 w=1 nf=1 m=1
M18 net0 VB3 net2 VSS nch l=0.15 w=1 nf=1 m=1
M19 VB3 net0 VDD VDD pch l=0.15 w=1 nf=1 m=1
M2 vcx phi2 net6 VSS nch l=0.15 w=1 nf=1 m=1
M20 VB3 VB3 VSS VSS nch l=0.15 w=1 nf=1 m=1
M3 net7 net6 net1 VSS nch l=0.15 w=1 nf=1 m=1
M4 net4 VSS net1 VSS nch l=0.15 w=1 nf=1 m=1
M5 net1 VB5 VSS VSS nch l=0.15 w=1 nf=1 m=1
M6 net7 VB1 VDD VDD pch l=0.15 w=1 nf=1 m=1
M7 net4 VB1 VDD VDD pch l=0.15 w=1 nf=1 m=1
M8 net6 VB2 net7 VDD pch l=0.15 w=1 nf=1 m=1
M9 vco VB2 net4 VDD pch l=0.15 w=1 nf=1 m=1
R1 net2 VSS 1k
.ends dut
