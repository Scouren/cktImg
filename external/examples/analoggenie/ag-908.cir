* official Analog Canvas netlist; PDK X cards rewritten by convert.py
.model nch nmos
.model pch pmos

.subckt dut VDD VSS VBB in- in+ Vo
C Vo net1 1p
I1 VDD net2 DC 1m
I3 VDD Vo DC 1m
M1 net0 in- net2 VDD pch l=0.15 w=1 nf=1 m=1
M2 Y in+ net2 VDD pch l=0.15 w=1 nf=1 m=1
M3 net0 VBB net3 VSS nch l=0.15 w=1 nf=1 m=1
M4 Y VBB net1 VSS nch l=0.15 w=1 nf=1 m=1
M5 net3 net0 VSS VSS nch l=0.15 w=1 nf=1 m=1
M6 net1 net0 VSS VSS nch l=0.15 w=1 nf=1 m=1
M7 Vo Y VSS VSS nch l=0.15 w=1 nf=1 m=1
.ends dut
