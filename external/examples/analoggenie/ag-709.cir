* official Analog Canvas netlist; PDK X cards rewritten by convert.py
.model nch nmos

.subckt dut VDD VSS Vout
Ibias VDD Vbias DC 1m
Iin VDD VX DC 1m
M1 Vout Vbias net0 VSS nch l=0.15 w=1 nf=1 m=1
M2 net0 VX VSS VSS nch l=0.15 w=1 nf=1 m=1
M3 net1 VX VSS VSS nch l=0.15 w=1 nf=1 m=1
M4 VX Vbias net1 VSS nch l=0.15 w=1 nf=1 m=1
M5 Vbias Vbias VSS VSS nch l=0.15 w=1 nf=1 m=1
.ends dut
