* official Analog Canvas netlist; PDK X cards rewritten by convert.py
.model nch nmos
.model pch pmos

.subckt dut VDD VEE VSS Vout+ Vout- VrefCM Vcntrl
I1 VDD net3 DC 1m
I2 VDD net4 DC 1m
I3 VDD net2 DC 1m
I4 VDD net1 DC 1m
M1 net0 Vout+ net3 VDD pch l=0.15 w=1 nf=1 m=1
M2 Vcntrl VrefCM net4 VDD pch l=0.15 w=1 nf=1 m=1
M3 Vcntrl VrefCM net2 VDD pch l=0.15 w=1 nf=1 m=1
M4 net0 Vout- net1 VDD pch l=0.15 w=1 nf=1 m=1
M5 Vcntrl Vcntrl VEE VSS nch l=0.15 w=1 nf=1 m=1
M6 net0 net0 VSS VSS nch l=0.15 w=1 nf=1 m=1
R1 net3 net4 1k
R2 net2 net1 1k
.ends dut
