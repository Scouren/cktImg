* official Analog Canvas netlist; PDK X cards rewritten by convert.py
.model nch nmos
.model pch pmos

.subckt comparator VDD VSS IN OUT VB1
M1 VX net1 VDD VDD pch l=0.15 w=1 nf=1 m=1
M10 net2 VBP VDD VDD pch l=0.15 w=1 nf=1 m=1
M11 net2 net2 VSS VSS nch l=0.15 w=1 nf=1 m=1
M12 VBP VBP VDD VDD pch l=0.15 w=1 nf=1 m=1
M13 VBP net4 VSS VSS nch l=0.15 w=1 nf=1 m=1
M14 net3 VBP VDD VDD pch l=0.15 w=1 nf=1 m=1
M15 net3 net3 net4 VSS nch l=0.15 w=1 nf=1 m=1
M16 net4 net3 net5 VSS nch l=0.15 w=1 nf=1 m=1
M17 net6 VBP VDD VDD pch l=0.15 w=1 nf=1 m=1
M18 net6 net6 net5 VSS nch l=0.15 w=1 nf=1 m=1
M19 net5 net6 VB1 VSS nch l=0.15 w=1 nf=1 m=1
M2 net1 net1 VDD VDD pch l=0.15 w=1 nf=1 m=1
M20 VB1 VBP VDD VDD pch l=0.15 w=1 nf=1 m=1
M21 VB1 VB1 VSS VSS nch l=0.15 w=1 nf=1 m=1
M3 net1 IN net0 VSS nch l=0.15 w=1 nf=1 m=1
M4 VX VX VSS VSS nch l=0.15 w=1 nf=1 m=1
M5 OUT OUT VDD VDD pch l=0.15 w=1 nf=1 m=1
M6 OUT OUT VDD VDD pch l=0.15 w=1 nf=1 m=1
M7 OUT OUT net0 VSS nch l=0.15 w=1 nf=1 m=1
M8 OUT VX VSS VSS nch l=0.15 w=1 nf=1 m=1
M9 net0 net2 VSS VSS nch l=0.15 w=1 nf=1 m=1
.ends comparator

.subckt dut VDD VSS VSTO VCONT1 VOUT VB1 VCONT2 VCONT3
CL VOUT VSS 1p
CSTO VSTO VSS 1p
LRX net2 net1 1n
MN1 net2 VCONT2 VSS VSS nch l=0.15 w=1 nf=1 m=1
MN2 net1 VCONT3 VSS VSS nch l=0.15 w=1 nf=1 m=1
MP2 net1 net0 VOUT VDD pch l=0.15 w=1 nf=1 m=1
MP3 net2 VCONT1 VSTO VDD pch l=0.15 w=1 nf=1 m=1
X1 VDD VSS net1 net0 VB1 comparator
.ends dut
