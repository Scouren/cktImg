* official Analog Canvas netlist; PDK X cards rewritten by convert.py
.model nch nmos
.model pch pmos

.subckt AMP1 VDD VSS INN INP TAIL OUT VB1 VB3 VB2
M10 net3 VX VDD VDD pch l=0.15 w=1 nf=1 m=1
M11 VX VB3 net2 VDD pch l=0.15 w=1 nf=1 m=1
M12 OUT VB3 net3 VDD pch l=0.15 w=1 nf=1 m=1
M13 VX VC net6 VSS nch l=0.15 w=1 nf=1 m=1
M14 OUT VC net7 VSS nch l=0.15 w=1 nf=1 m=1
M15 net6 VB2 VSS VSS nch l=0.15 w=1 nf=1 m=1
M16 net7 VB2 VSS VSS nch l=0.15 w=1 nf=1 m=1
M17 VC net0 VDD VDD pch l=0.15 w=1 nf=1 m=1
M18 VC VC net8 VSS nch l=0.15 w=1 nf=1 m=1
M19 net8 VC VSS VSS nch l=0.15 w=1 nf=1 m=1
M20 net4 net0 VDD VDD pch l=0.15 w=1 nf=1 m=1
M21 net4 net4 VSS VSS nch l=0.15 w=1 nf=1 m=1
M22 net0 net0 VDD VDD pch l=0.15 w=1 nf=1 m=1
M23 net0 net5 net1 VSS nch l=0.15 w=1 nf=1 m=1
M24 net1 net4 VSS VSS nch l=0.15 w=1 nf=1 m=1
M25 net5 net0 VDD VDD pch l=0.15 w=1 nf=1 m=1
M26 net5 net5 VSS VSS nch l=0.15 w=1 nf=1 m=1
M6 TAIL VB1 VDD VDD pch l=0.15 w=1 nf=1 m=1
M7 net7 INN TAIL VDD pch l=0.15 w=1 nf=1 m=1
M8 net6 INP TAIL VDD pch l=0.15 w=1 nf=1 m=1
M9 net2 VX VDD VDD pch l=0.15 w=1 nf=1 m=1
.ends AMP1

.subckt dut VDD VSS Vout Vref biasp biascas biasn VB1 VB2 VB3
C1 Vset VSS 1p
C2 n3 Vout 1p
M1 Vout n3 VDD VDD pch l=0.15 w=1 nf=1 m=1
M2 n1 Vset Vout VDD pch l=0.15 w=1 nf=1 m=1
M3 n1 biasn VSS VSS nch l=0.15 w=1 nf=1 m=1
M4 n3 biasp VDD VDD pch l=0.15 w=1 nf=1 m=1
M5 n3 biascas n1 VSS nch l=0.15 w=1 nf=1 m=1
R1 fb VSS 1k
R2 Vout fb 1k
X1 VDD VSS fb Vref n3 Vset VB1 VB3 VB2 AMP1
.ends dut
