* official Analog Canvas netlist; PDK X cards rewritten by convert.py
.model nch nmos
.model pch pmos

.subckt dut VDD VSS VPB1 VPB2 VNB2 voutn voutp vinp vinn VNB1
VB1 net8 VSS DC 1
M1 net6 vinp net7 VSS nch l=0.15 w=1 nf=1 m=1
M10 net1 VCMFB VSS VSS nch l=0.15 w=1 nf=1 m=1
M11 net2 VCMFB VSS VSS nch l=0.15 w=1 nf=1 m=1
M12 net4 VPB1 VDD VDD pch l=0.15 w=1 nf=1 m=1
M13 net0 net3 net4 VDD pch l=0.15 w=1 nf=1 m=1
M14 VCMFB net8 net4 VDD pch l=0.15 w=1 nf=1 m=1
M15 net0 net0 VSS VSS nch l=0.15 w=1 nf=1 m=1
M16 VCMFB net0 VSS VSS nch l=0.15 w=1 nf=1 m=1
M2 net5 vinn net7 VSS nch l=0.15 w=1 nf=1 m=1
M3 net7 VNB1 VSS VSS nch l=0.15 w=1 nf=1 m=1
M4 net6 VPB1 VDD VDD pch l=0.15 w=1 nf=1 m=1
M5 net5 VPB1 VDD VDD pch l=0.15 w=1 nf=1 m=1
M6 voutn VPB2 net6 VDD pch l=0.15 w=1 nf=1 m=1
M7 voutp VPB2 net5 VDD pch l=0.15 w=1 nf=1 m=1
M8 voutn VNB2 net1 VSS nch l=0.15 w=1 nf=1 m=1
M9 voutp VNB2 net2 VSS nch l=0.15 w=1 nf=1 m=1
R1 voutn net3 1k
R2 net3 voutp 1k
.ends dut
