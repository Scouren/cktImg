* official Analog Canvas netlist; PDK X cards rewritten by convert.py
.model nch nmos
.model pch pmos

.subckt bias VDD VSS VBN2 VBN1
M22 VBP VBP VDD VDD pch l=0.15 w=1 nf=1 m=1
M23 net3 VBP VDD VDD pch l=0.15 w=1 nf=1 m=1
M24 VBP net0 VSS VSS nch l=0.15 w=1 nf=1 m=1
M25 net3 net3 net0 VSS nch l=0.15 w=1 nf=1 m=1
M26 net0 net3 net2 VSS nch l=0.15 w=1 nf=1 m=1
M27 net1 VBP VDD VDD pch l=0.15 w=1 nf=1 m=1
M28 VB3 VBP VDD VDD pch l=0.15 w=1 nf=1 m=1
M29 net1 net1 net2 VSS nch l=0.15 w=1 nf=1 m=1
M30 net2 net1 VB3 VSS nch l=0.15 w=1 nf=1 m=1
M31 VB3 VB3 VSS VSS nch l=0.15 w=1 nf=1 m=1
M32 VBN2 VBP VDD VDD pch l=0.15 w=1 nf=1 m=1
M33 VBN2 VBN2 VBN1 VSS nch l=0.15 w=1 nf=1 m=1
M34 VBN1 VBN1 VSS VSS nch l=0.15 w=1 nf=1 m=1
.ends bias

.subckt dut VDD VSS VB1 VREF VB4 IBUF VIN VOUT
CL VOUT net2 1p
M10 EAO VB2 VY VDD pch l=0.15 w=1 nf=1 m=1
M11 net4 VX VDD VDD pch l=0.15 w=1 nf=1 m=1
M12 VY VX VDD VDD pch l=0.15 w=1 nf=1 m=1
M13 net1 VB4 VDD VDD pch l=0.15 w=1 nf=1 m=1
M14 VX EAO net1 VDD pch l=0.15 w=1 nf=1 m=1
M15 VX VX VSS VSS nch l=0.15 w=1 nf=1 m=1
M16 GATE VX VSS VSS nch l=0.15 w=1 nf=1 m=1
M17 VDD net1 GATE VSS nch l=0.15 w=1 nf=1 m=1
M18 VY EAO IBUF VSS nch l=0.15 w=1 nf=1 m=1
M19 VY VY VDD VDD pch l=0.15 w=1 nf=1 m=1
M2 net3 VB1 VDD VDD pch l=0.15 w=1 nf=1 m=1
M20 GATE VY VDD VDD pch l=0.15 w=1 nf=1 m=1
M21 VSS IBUF GATE VDD pch l=0.15 w=1 nf=1 m=1
M3 net0 VREF net3 VDD pch l=0.15 w=1 nf=1 m=1
M4 net5 FB net3 VDD pch l=0.15 w=1 nf=1 m=1
M5 net0 VBN1 VSS VSS nch l=0.15 w=1 nf=1 m=1
M6 net5 VBN1 VSS VSS nch l=0.15 w=1 nf=1 m=1
M7 VX VBN2 net0 VSS nch l=0.15 w=1 nf=1 m=1
M8 EAO VBN2 net5 VSS nch l=0.15 w=1 nf=1 m=1
M9 VX VB2 net4 VDD pch l=0.15 w=1 nf=1 m=1
MNP VIN GATE VOUT VSS nch l=0.15 w=1 nf=1 m=1
R1 FB VSS 1k
R2 VOUT FB 1k
R3 net2 VSS 1k
RL VOUT VSS 1k
X1 VDD VSS VBN2 VBN1 bias
.ends dut
