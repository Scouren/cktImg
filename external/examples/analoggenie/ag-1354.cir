* official Analog Canvas netlist; PDK X cards rewritten by convert.py
.model nch nmos
.model pch pmos

.subckt comp VDD VSS INN OUT VX VB1 VB2
M1 net11 net2 VDD VDD pch l=0.15 w=1 nf=1 m=1
M10 net1 OUT net4 VSS nch l=0.15 w=1 nf=1 m=1
M11 VX VN net9 VSS nch l=0.15 w=1 nf=1 m=1
M12 OUT VN net8 VSS nch l=0.15 w=1 nf=1 m=1
M13 net9 VX VSS VSS nch l=0.15 w=1 nf=1 m=1
M14 net8 VX VSS VSS nch l=0.15 w=1 nf=1 m=1
M15 net4 VB2 VSS VSS nch l=0.15 w=1 nf=1 m=1
M16 net0 net0 VDD VDD pch l=0.15 w=1 nf=1 m=1
M17 net5 net0 VDD VDD pch l=0.15 w=1 nf=1 m=1
M18 VN net0 VDD VDD pch l=0.15 w=1 nf=1 m=1
M19 net0 net5 VSS VSS nch l=0.15 w=1 nf=1 m=1
M2 net3 net2 VDD VDD pch l=0.15 w=1 nf=1 m=1
M20 net5 net5 VSS VSS nch l=0.15 w=1 nf=1 m=1
M21 VN VN net7 VSS nch l=0.15 w=1 nf=1 m=1
M22 net7 VN VSS VSS nch l=0.15 w=1 nf=1 m=1
M3 net10 net1 VDD VDD pch l=0.15 w=1 nf=1 m=1
M4 net6 net1 VDD VDD pch l=0.15 w=1 nf=1 m=1
M5 VX VB1 net11 VDD pch l=0.15 w=1 nf=1 m=1
M6 net2 VB1 net3 VDD pch l=0.15 w=1 nf=1 m=1
M7 net1 VB1 net10 VDD pch l=0.15 w=1 nf=1 m=1
M8 OUT VB1 net6 VDD pch l=0.15 w=1 nf=1 m=1
M9 net2 INN net4 VSS nch l=0.15 w=1 nf=1 m=1
.ends comp

.subckt dut VDD VSS VSTO VCONT1 VCONT2 VCONT3 VOUT VB1 VB2
CL VOUT VSS 1p
CSTO VSTO VSS 1p
LRX VX net1 1n
MN1 VX VCONT2 VSS VSS nch l=0.15 w=1 nf=1 m=1
MN2 net1 VCONT3 VSS VSS nch l=0.15 w=1 nf=1 m=1
MP2 net1 net0 VOUT VDD pch l=0.15 w=1 nf=1 m=1
MP3 VX VCONT1 VSTO VDD pch l=0.15 w=1 nf=1 m=1
X1 VDD VSS net1 net0 VX VB1 VB2 comp
.ends dut
