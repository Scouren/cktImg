* official Analog Canvas netlist; PDK X cards rewritten by convert.py
.model nch nmos
.model pch pmos

.subckt Error_Amplifier VDD VSS VREF OUT VX
M13 net3 VY VDD VDD pch l=0.15 w=1 nf=1 m=1
M14 VY VB1 net3 VDD pch l=0.15 w=1 nf=1 m=1
M15 VY VBN net2 VSS nch l=0.15 w=1 nf=1 m=1
M16 net2 net1 VSS VSS nch l=0.15 w=1 nf=1 m=1
M17 net1 VBN net4 VSS nch l=0.15 w=1 nf=1 m=1
M18 net4 net1 VSS VSS nch l=0.15 w=1 nf=1 m=1
M19 net8 VB2 VDD VDD pch l=0.15 w=1 nf=1 m=1
M20 net1 VREF net8 VDD pch l=0.15 w=1 nf=1 m=1
M21 net5 OUT net8 VDD pch l=0.15 w=1 nf=1 m=1
M22 net5 VBN net6 VSS nch l=0.15 w=1 nf=1 m=1
M23 net6 net5 VSS VSS nch l=0.15 w=1 nf=1 m=1
M24 net9 VY VDD VDD pch l=0.15 w=1 nf=1 m=1
M25 OUT VB1 net9 VDD pch l=0.15 w=1 nf=1 m=1
M26 OUT VBN VX VSS nch l=0.15 w=1 nf=1 m=1
M27 VX net5 VSS VSS nch l=0.15 w=1 nf=1 m=1
M28 net0 net7 VDD VDD pch l=0.15 w=1 nf=1 m=1
M29 net0 net0 VSS VSS nch l=0.15 w=1 nf=1 m=1
M30 net7 net7 VDD VDD pch l=0.15 w=1 nf=1 m=1
M31 net7 net0 VSS VSS nch l=0.15 w=1 nf=1 m=1
M32 VBN net7 VDD VDD pch l=0.15 w=1 nf=1 m=1
M33 VBN VBN OUT VSS nch l=0.15 w=1 nf=1 m=1
M34 OUT VBN VSS VSS nch l=0.15 w=1 nf=1 m=1
.ends Error_Amplifier

.subckt dut VDD VSS VREF VIN pb nb VOUT VERR
M1 VX VEA VIN VDD pch l=0.15 w=1 nf=1 m=1
M10 VERR nb VSS VSS nch l=0.15 w=1 nf=1 m=1
M2 net2 net2 VX VDD pch l=0.15 w=1 nf=1 m=1
M3 net2 nb VSS VSS nch l=0.15 w=1 nf=1 m=1
M4 net1 pb VIN VDD pch l=0.15 w=1 nf=1 m=1
M5 net0 VEA net1 VDD pch l=0.15 w=1 nf=1 m=1
M6 net0 net0 VSS VSS nch l=0.15 w=1 nf=1 m=1
M7 VERR net0 VSS VSS nch l=0.15 w=1 nf=1 m=1
M8 VOUT VERR VIN VDD pch l=0.15 w=1 nf=1 m=1
M9 VERR net2 VOUT VDD pch l=0.15 w=1 nf=1 m=1
X1 VDD VSS VREF VEA VX Error_Amplifier
.ends dut
