* official Analog Canvas netlist; PDK X cards rewritten by convert.py
.model nch nmos
.model pch pmos

.subckt comparator VDD VSS INN OUT
M10 OUT OUT net1 VSS nch l=0.15 w=1 nf=1 m=1
M11 net1 VBN VSS VSS nch l=0.15 w=1 nf=1 m=1
M12 net2 net2 VSS VSS nch l=0.15 w=1 nf=1 m=1
M13 OUT net2 VSS VSS nch l=0.15 w=1 nf=1 m=1
M14 net0 net0 VDD VDD pch l=0.15 w=1 nf=1 m=1
M15 VBN net0 VDD VDD pch l=0.15 w=1 nf=1 m=1
M16 VB1 VB1 VDD VDD pch l=0.15 w=1 nf=1 m=1
M17 net0 VX VSS VSS nch l=0.15 w=1 nf=1 m=1
M18 VBN VBN VSS VSS nch l=0.15 w=1 nf=1 m=1
M19 VB1 VBN VSS VSS nch l=0.15 w=1 nf=1 m=1
M20 VB2 VB2 VDD VDD pch l=0.15 w=1 nf=1 m=1
M21 VX VB2 VDD VDD pch l=0.15 w=1 nf=1 m=1
M22 VB2 VX net4 VSS nch l=0.15 w=1 nf=1 m=1
M23 VX VX VSS VSS nch l=0.15 w=1 nf=1 m=1
M5 net2 net3 VDD VDD pch l=0.15 w=1 nf=1 m=1
M6 net3 net3 VDD VDD pch l=0.15 w=1 nf=1 m=1
M7 OUT OUT VDD VDD pch l=0.15 w=1 nf=1 m=1
M8 OUT OUT VDD VDD pch l=0.15 w=1 nf=1 m=1
M9 net3 INN net1 VSS nch l=0.15 w=1 nf=1 m=1
R1 net4 VSS 1k
.ends comparator

.subckt dut VDD VSS VSTO VOUT VCONT1 VCONT2 VCONT3
CL VOUT VSS 1p
CSTO VSTO VSS 1p
LRX net0 net2 1n
MN1 net0 VCONT2 VSS VSS nch l=0.15 w=1 nf=1 m=1
MN2 net2 VCONT3 VSS VSS nch l=0.15 w=1 nf=1 m=1
MP2 net2 net1 VOUT VDD pch l=0.15 w=1 nf=1 m=1
MP3 net0 VCONT1 VSTO VDD pch l=0.15 w=1 nf=1 m=1
X1 VDD VSS net2 net1 comparator
.ends dut
