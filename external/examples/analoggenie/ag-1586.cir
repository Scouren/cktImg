* official Analog Canvas netlist; PDK X cards rewritten by convert.py
.model nch nmos
.model pch pmos
.model qpnp pnp

.global VDD

.subckt A1 VSS INN INP OUT
M1 net9 INN net8 VSS nch l=0.15 w=1 nf=1 m=1
M10 net3 net1 VSS VSS nch l=0.15 w=1 nf=1 m=1
M11 net5 net1 VSS VSS nch l=0.15 w=1 nf=1 m=1
M12 VB6 VP VDD VDD pch l=0.15 w=1 nf=1 m=1
M13 VB6 VB6 net6 VSS nch l=0.15 w=1 nf=1 m=1
M14 net6 VB6 VSS VSS nch l=0.15 w=1 nf=1 m=1
M15 VP VP VDD VDD pch l=0.15 w=1 nf=1 m=1
M16 VP net2 net4 VSS nch l=0.15 w=1 nf=1 m=1
M17 net4 net0 VSS VSS nch l=0.15 w=1 nf=1 m=1
M18 net2 VP VDD VDD pch l=0.15 w=1 nf=1 m=1
M19 net2 net4 VSS VSS nch l=0.15 w=1 nf=1 m=1
M2 net7 INP net8 VSS nch l=0.15 w=1 nf=1 m=1
M20 net0 VP VDD VDD pch l=0.15 w=1 nf=1 m=1
M21 net0 net0 VSS VSS nch l=0.15 w=1 nf=1 m=1
M3 net8 VB2 VSS VSS nch l=0.15 w=1 nf=1 m=1
M4 net9 VB1 VDD VDD pch l=0.15 w=1 nf=1 m=1
M5 net7 VB1 VDD VDD pch l=0.15 w=1 nf=1 m=1
M6 net1 VB3 net9 VDD pch l=0.15 w=1 nf=1 m=1
M7 OUT VB3 net7 VDD pch l=0.15 w=1 nf=1 m=1
M8 net1 VB6 net3 VSS nch l=0.15 w=1 nf=1 m=1
M9 OUT VB6 net5 VSS nch l=0.15 w=1 nf=1 m=1
.ends A1

.subckt dut VSS Vout
Q1 VSS VSS X qpnp m=1
Q2 VSS VSS net0 qpnp m=1
R1 Vout X 1k
R2 Vout Y 1k
R3 Y net0 1k
X1 VSS Y X Vout A1
.ends dut
