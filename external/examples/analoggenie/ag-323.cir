* official Analog Canvas netlist; PDK X cards rewritten by convert.py
.model nch nmos
.model pch pmos

.subckt dut VDD VSS Vin1 Vin2 Vout1 Vout2 Vb1 Vb2 Vb3
CL1 Vout1 VSS 1p
CL2 Vout2 VSS 1p
ISS net4 VSS DC 1m
M1 net2 Vin1 net4 VSS nch l=0.15 w=1 nf=1 m=1
M2 net0 Vin2 net4 VSS nch l=0.15 w=1 nf=1 m=1
M3 Vout1 Vb3 net2 VSS nch l=0.15 w=1 nf=1 m=1
M4 Vout2 Vb3 net0 VSS nch l=0.15 w=1 nf=1 m=1
M5 Vout1 Vb2 net1 VDD pch l=0.15 w=1 nf=1 m=1
M6 Vout2 Vb2 net3 VDD pch l=0.15 w=1 nf=1 m=1
M7 net1 Vb1 VDD VDD pch l=0.15 w=1 nf=1 m=1
M8 net3 Vb1 VDD VDD pch l=0.15 w=1 nf=1 m=1
.ends dut
