* official Analog Canvas netlist; PDK X cards rewritten by convert.py
.model nch nmos
.model pch pmos
.model qpnp pnp

.subckt A1 VDD VSS INN INP OUT VB1 VB2
M1 net2 INP net7 VSS nch l=0.15 w=1 nf=1 m=1
M10 net0 net5 VSS VSS nch l=0.15 w=1 nf=1 m=1
M11 net4 net5 VSS VSS nch l=0.15 w=1 nf=1 m=1
M12 VB4 net3 VDD VDD pch l=0.15 w=1 nf=1 m=1
M13 VB4 VB4 VB5 VSS nch l=0.15 w=1 nf=1 m=1
M14 VB5 VB5 VSS VSS nch l=0.15 w=1 nf=1 m=1
M15 net3 net3 VDD VDD pch l=0.15 w=1 nf=1 m=1
M16 VB3 net3 VDD VDD pch l=0.15 w=1 nf=1 m=1
M17 net3 VB3 VSS VSS nch l=0.15 w=1 nf=1 m=1
M18 net1 VB3 VSS VSS nch l=0.15 w=1 nf=1 m=1
M2 net6 INN net7 VSS nch l=0.15 w=1 nf=1 m=1
M3 net7 VB5 VSS VSS nch l=0.15 w=1 nf=1 m=1
M4 net6 VB1 VDD VDD pch l=0.15 w=1 nf=1 m=1
M5 net2 VB1 VDD VDD pch l=0.15 w=1 nf=1 m=1
M6 net5 VB2 net6 VDD pch l=0.15 w=1 nf=1 m=1
M7 OUT VB2 net2 VDD pch l=0.15 w=1 nf=1 m=1
M8 net5 VB4 net0 VSS nch l=0.15 w=1 nf=1 m=1
M9 OUT VB4 net4 VSS nch l=0.15 w=1 nf=1 m=1
R4 VB3 net1 1k
.ends A1

.subckt dut VDD VSS Vout VB1 VB2
Q1 VSS VSS X qpnp m=1
Q2 VSS VSS net0 qpnp m=1
R1 Vout X 1k
R2 Vout Y 1k
R3 Y net0 1k
X1 VDD VSS Y X Vout VB1 VB2 A1
.ends dut
