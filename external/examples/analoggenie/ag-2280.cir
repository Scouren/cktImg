* official Analog Canvas netlist; PDK X cards rewritten by convert.py
.model nch nmos
.model pch pmos

.subckt dut VDD VSS VB2 VREF VB1 VB4 IBUF VIN VOUT
CL VOUT net3 1p
M10 net5 VB1 net11 VDD pch l=0.15 w=1 nf=1 m=1
M11 net7 net5 VDD VDD pch l=0.15 w=1 nf=1 m=1
M12 net11 net5 VDD VDD pch l=0.15 w=1 nf=1 m=1
M13 net9 VB4 VDD VDD pch l=0.15 w=1 nf=1 m=1
M14 VX EAO net9 VDD pch l=0.15 w=1 nf=1 m=1
M15 VX VX VSS VSS nch l=0.15 w=1 nf=1 m=1
M16 GATE VX VSS VSS nch l=0.15 w=1 nf=1 m=1
M17 VDD net9 GATE VSS nch l=0.15 w=1 nf=1 m=1
M18 net2 EAO IBUF VSS nch l=0.15 w=1 nf=1 m=1
M19 net2 net2 VDD VDD pch l=0.15 w=1 nf=1 m=1
M2 EAO VB2 VDD VDD pch l=0.15 w=1 nf=1 m=1
M20 GATE net2 VDD VDD pch l=0.15 w=1 nf=1 m=1
M21 VSS IBUF GATE VDD pch l=0.15 w=1 nf=1 m=1
M22 VY VB5 net4 VSS nch l=0.15 w=1 nf=1 m=1
M23 VX VB5 net10 VSS nch l=0.15 w=1 nf=1 m=1
M24 net4 VY VSS VSS nch l=0.15 w=1 nf=1 m=1
M25 net10 VX VSS VSS nch l=0.15 w=1 nf=1 m=1
M26 VB5 net1 VDD VDD pch l=0.15 w=1 nf=1 m=1
M27 net1 net1 VDD VDD pch l=0.15 w=1 nf=1 m=1
M28 VB3 net1 VDD VDD pch l=0.15 w=1 nf=1 m=1
M29 net1 VB3 VSS VSS nch l=0.15 w=1 nf=1 m=1
M3 VX VREF EAO VDD pch l=0.15 w=1 nf=1 m=1
M30 VB3 VB3 VSS VSS nch l=0.15 w=1 nf=1 m=1
M31 VB5 VB5 net0 VSS nch l=0.15 w=1 nf=1 m=1
M32 net0 VB5 VSS VSS nch l=0.15 w=1 nf=1 m=1
M4 VY FB EAO VDD pch l=0.15 w=1 nf=1 m=1
M5 net8 VY VSS VSS nch l=0.15 w=1 nf=1 m=1
M6 net6 VX VSS VSS nch l=0.15 w=1 nf=1 m=1
M7 EAO VB5 net8 VSS nch l=0.15 w=1 nf=1 m=1
M8 net5 VB5 net6 VSS nch l=0.15 w=1 nf=1 m=1
M9 EAO VB1 net7 VDD pch l=0.15 w=1 nf=1 m=1
MNP VIN GATE VOUT VSS nch l=0.15 w=1 nf=1 m=1
R1 FB VSS 1k
R2 VOUT FB 1k
R3 net3 VSS 1k
RL VOUT VSS 1k
.ends dut
