* official Analog Canvas netlist; PDK X cards rewritten by convert.py
.model nch nmos
.model pch pmos

.subckt dut VDD VSS VIN VREF VB2 VB3 VB4 VB5 VB6 VOUT
CF1 VOUT VFB 1p
Cm1 Vo1 VOUT 1p
Cm2 Vo1 VT 1p
M11 VT VB2 VSS VSS nch l=0.15 w=1 nf=1 m=1
M12 net11 VFB VT VSS nch l=0.15 w=1 nf=1 m=1
M13 net5 VREF VT VSS nch l=0.15 w=1 nf=1 m=1
M14 net4 net0 VSS VSS nch l=0.15 w=1 nf=1 m=1
M15 net12 net0 VSS VSS nch l=0.15 w=1 nf=1 m=1
M16 VG VB4 VIN VDD pch l=0.15 w=1 nf=1 m=1
M17 VG Vo1 VSS VSS nch l=0.15 w=1 nf=1 m=1
M18 VG VG VSS VSS nch l=0.15 w=1 nf=1 m=1
M19 net0 VBN net4 VSS nch l=0.15 w=1 nf=1 m=1
M20 Vo1 VBN net12 VSS nch l=0.15 w=1 nf=1 m=1
M21 VX Vo1 VSS VSS nch l=0.15 w=1 nf=1 m=1
M22 VY VG VSS VSS nch l=0.15 w=1 nf=1 m=1
M23 VX VX VIN VDD pch l=0.15 w=1 nf=1 m=1
M24 VY VX VIN VDD pch l=0.15 w=1 nf=1 m=1
M25 net1 net5 VIN VDD pch l=0.15 w=1 nf=1 m=1
M26 net5 VB1 net1 VDD pch l=0.15 w=1 nf=1 m=1
M27 VY net11 VIN VDD pch l=0.15 w=1 nf=1 m=1
M28 net11 VB1 VY VDD pch l=0.15 w=1 nf=1 m=1
M29 net7 net5 VIN VDD pch l=0.15 w=1 nf=1 m=1
M30 net0 VB1 net7 VDD pch l=0.15 w=1 nf=1 m=1
M31 VX net11 VIN VDD pch l=0.15 w=1 nf=1 m=1
M32 Vo1 VB1 VX VDD pch l=0.15 w=1 nf=1 m=1
M33 VBN net2 VIN VDD pch l=0.15 w=1 nf=1 m=1
M34 VBN VBN net10 VSS nch l=0.15 w=1 nf=1 m=1
M35 net10 VBN VSS VSS nch l=0.15 w=1 nf=1 m=1
M36 net2 net2 VIN VDD pch l=0.15 w=1 nf=1 m=1
M37 net2 VB3 net13 VSS nch l=0.15 w=1 nf=1 m=1
M38 net13 net8 VSS VSS nch l=0.15 w=1 nf=1 m=1
M39 net8 net8 VSS VSS nch l=0.15 w=1 nf=1 m=1
M40 net8 net2 VIN VDD pch l=0.15 w=1 nf=1 m=1
M41 VB3 net2 VIN VDD pch l=0.15 w=1 nf=1 m=1
M42 VB3 VB3 VSS VSS nch l=0.15 w=1 nf=1 m=1
MD1 VT Vo1 VSS VSS nch l=0.15 w=1 nf=1 m=1
MD2 net6 VB5 VSS VSS nch l=0.15 w=1 nf=1 m=1
MD3 net3 VT net6 VSS nch l=0.15 w=1 nf=1 m=1
MD4 net9 VB6 net6 VSS nch l=0.15 w=1 nf=1 m=1
MD5 VT net9 VIN VDD pch l=0.15 w=1 nf=1 m=1
MD6 net9 net9 VIN VDD pch l=0.15 w=1 nf=1 m=1
MD7 net3 net3 VIN VDD pch l=0.15 w=1 nf=1 m=1
MPT VOUT VY VIN VDD pch l=0.15 w=1 nf=1 m=1
RF1 VOUT VFB 1k
RF2 VFB VSS 1k
.ends dut
