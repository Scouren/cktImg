* official Analog Canvas netlist; PDK X cards rewritten by convert.py
.model nch nmos
.model pch pmos

.subckt dut VDD VSS vci phi1 phi2 vco VB1
C1 net2 net4 1p
C2 net3 vco 1p
M1 vci phi1 net2 VSS nch l=0.15 w=1 nf=1 m=1
M10 net7 net5 VSS VSS nch l=0.15 w=1 nf=1 m=1
M11 vco VX VSS VSS nch l=0.15 w=1 nf=1 m=1
M12 net7 net7 VDD VDD pch l=0.15 w=1 nf=1 m=1
M13 vco net7 VDD VDD pch l=0.15 w=1 nf=1 m=1
M14 net1 net1 VDD VDD pch l=0.15 w=1 nf=1 m=1
M15 net6 net1 VDD VDD pch l=0.15 w=1 nf=1 m=1
M16 net6 net6 VSS VSS nch l=0.15 w=1 nf=1 m=1
M17 VB2 VB2 VDD VDD pch l=0.15 w=1 nf=1 m=1
M18 VB2 net6 VSS VSS nch l=0.15 w=1 nf=1 m=1
M19 VB1 VB2 VDD VDD pch l=0.15 w=1 nf=1 m=1
M2 net2 phi2 VSS VSS nch l=0.15 w=1 nf=1 m=1
M20 VB1 VB1 VSS VSS nch l=0.15 w=1 nf=1 m=1
M3 net4 phi1 VSS VSS nch l=0.15 w=1 nf=1 m=1
M4 net4 phi2 net3 VSS nch l=0.15 w=1 nf=1 m=1
M5 net0 VB2 VDD VDD pch l=0.15 w=1 nf=1 m=1
M6 VX net3 net0 VDD pch l=0.15 w=1 nf=1 m=1
M7 net5 VSS net0 VDD pch l=0.15 w=1 nf=1 m=1
M8 VX VX VSS VSS nch l=0.15 w=1 nf=1 m=1
M9 net5 net5 VSS VSS nch l=0.15 w=1 nf=1 m=1
R1 net1 VSS 1k
.ends dut
