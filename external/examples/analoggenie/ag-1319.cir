* official Analog Canvas netlist; PDK X cards rewritten by convert.py
.model nch nmos
.model pch pmos

.subckt dut VDD VSS VIN VCONT1 VCONT2 VCONT3 VCONT4 VCONT5 VP VREF VB2 VB1
.model DIODE D(IS=1e-14 N=1)
CFLY VX1 VX2 1p
CO VP VN 1p
COP VP VSS 1p
D1 VN VX2 DIODE
L1 VX1 VX3 1n
M1 VS VCONT1 VIN VIN pch l=0.15 w=1 nf=1 m=1
M2 VX1 VCONT2 VIN VIN pch l=0.15 w=1 nf=1 m=1
M3 VX2 VCONT3 VIN VIN pch l=0.15 w=1 nf=1 m=1
M4 VX3 VCONT4 VSS VSS nch l=0.15 w=1 nf=1 m=1
M5 VX3 VCONT5 VP VP pch l=0.15 w=1 nf=1 m=1
MB1 VB1 VB1 VDD VDD pch l=0.15 w=1 nf=1 m=1
MB2 net7 VB1 VDD VDD pch l=0.15 w=1 nf=1 m=1
MB3 VBP VBP VDD VDD pch l=0.15 w=1 nf=1 m=1
MB4 VB1 net7 VSS VSS nch l=0.15 w=1 nf=1 m=1
MB5 net2 net7 VSS VSS nch l=0.15 w=1 nf=1 m=1
MB6 VBP net7 VSS VSS nch l=0.15 w=1 nf=1 m=1
MN1 VCTRL net6 VSS VSS nch l=0.15 w=1 nf=1 m=1
MN2 net6 net6 VSS VSS nch l=0.15 w=1 nf=1 m=1
MN3 VX2 VX2 VSS VSS nch l=0.15 w=1 nf=1 m=1
MN4 net1 VX2 VSS VSS nch l=0.15 w=1 nf=1 m=1
MN5 net4 net4 VSS VSS nch l=0.15 w=1 nf=1 m=1
MN6 net3 net4 VSS VSS nch l=0.15 w=1 nf=1 m=1
MN7 net4 VB2 VSS VSS nch l=0.15 w=1 nf=1 m=1
MP1 VCTRL net1 VDD VDD pch l=0.15 w=1 nf=1 m=1
MP2 net5 VBP VDD VDD pch l=0.15 w=1 nf=1 m=1
MP3 net1 net1 VDD VDD pch l=0.15 w=1 nf=1 m=1
MP4 net6 VFP1 net5 net0 pch l=0.15 w=1 nf=1 m=1
MP5 VX2 VREF net5 net0 pch l=0.15 w=1 nf=1 m=1
MP6 net4 VCTRL VS VS pch l=0.15 w=1 nf=1 m=1
MP7 net3 net3 VS VS pch l=0.15 w=1 nf=1 m=1
MP8 VX1 net3 VS VS pch l=0.15 w=1 nf=1 m=1
R1 VP VFP1 1k
R2 VFP1 VSS 1k
RBIAS net7 net2 1k
.ends dut
