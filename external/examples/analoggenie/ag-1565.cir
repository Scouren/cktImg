* official Analog Canvas netlist; PDK X cards rewritten by convert.py
.model nch nmos
.model pch pmos
.model qpnp pnp

.subckt A1 VDD VSS INN INP VB2 VB1 OUT
M1 VX INN net9 VDD pch l=0.15 w=1 nf=1 m=1
M10 net6 VB4 net4 VSS nch l=0.15 w=1 nf=1 m=1
M11 OUT VB4 net10 VSS nch l=0.15 w=1 nf=1 m=1
M12 net3 VX VSS VSS nch l=0.15 w=1 nf=1 m=1
M13 net7 net0 VSS VSS nch l=0.15 w=1 nf=1 m=1
M14 net4 net0 VSS VSS nch l=0.15 w=1 nf=1 m=1
M15 net10 VX VSS VSS nch l=0.15 w=1 nf=1 m=1
M16 VB5 VB5 VDD VDD pch l=0.15 w=1 nf=1 m=1
M17 VB3 VB5 VDD VDD pch l=0.15 w=1 nf=1 m=1
M18 VB4 VB5 VDD VDD pch l=0.15 w=1 nf=1 m=1
M19 VB5 VB3 net1 VSS nch l=0.15 w=1 nf=1 m=1
M2 net0 INP net9 VDD pch l=0.15 w=1 nf=1 m=1
M20 VB3 VB3 VSS VSS nch l=0.15 w=1 nf=1 m=1
M21 VB4 VB4 net8 VSS nch l=0.15 w=1 nf=1 m=1
M22 net8 VB4 VSS VSS nch l=0.15 w=1 nf=1 m=1
M3 net9 VB2 VDD VDD pch l=0.15 w=1 nf=1 m=1
M4 net2 net6 VDD VDD pch l=0.15 w=1 nf=1 m=1
M5 net5 net6 VDD VDD pch l=0.15 w=1 nf=1 m=1
M6 net6 VB1 net2 VDD pch l=0.15 w=1 nf=1 m=1
M7 OUT VB1 net5 VDD pch l=0.15 w=1 nf=1 m=1
M8 VX VB4 net3 VSS nch l=0.15 w=1 nf=1 m=1
M9 net0 VB4 net7 VSS nch l=0.15 w=1 nf=1 m=1
R4 net1 VSS 1k
.ends A1

.subckt dut VDD VSS Vout VB1 VB2
Q1 VSS VSS X qpnp m=1
Q2 VSS VSS net0 qpnp m=1
R1 Vout X 1k
R2 Vout Y 1k
R3 Y net0 1k
X1 VDD VSS Y X VB2 VB1 Vout A1
.ends dut
