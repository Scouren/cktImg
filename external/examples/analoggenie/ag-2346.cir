* official Analog Canvas netlist; PDK X cards rewritten by convert.py
.model nch nmos
.model pch pmos

.subckt dut VDD VSS VREF VB4 IBUF VIN VOUT VB1
CL VOUT net8 1p
M1 net6 net6 VDD VDD pch l=0.15 w=1 nf=1 m=1
M13 net7 VB4 VDD VDD pch l=0.15 w=1 nf=1 m=1
M14 VX EAO net7 VDD pch l=0.15 w=1 nf=1 m=1
M15 VX VX VSS VSS nch l=0.15 w=1 nf=1 m=1
M16 GATE VX VSS VSS nch l=0.15 w=1 nf=1 m=1
M17 VDD net7 GATE VSS nch l=0.15 w=1 nf=1 m=1
M18 net0 EAO IBUF VSS nch l=0.15 w=1 nf=1 m=1
M19 net0 net0 VDD VDD pch l=0.15 w=1 nf=1 m=1
M2 net4 net4 VDD VDD pch l=0.15 w=1 nf=1 m=1
M20 GATE net0 VDD VDD pch l=0.15 w=1 nf=1 m=1
M21 VSS IBUF GATE VDD pch l=0.15 w=1 nf=1 m=1
M22 net5 net2 VSS VSS nch l=0.15 w=1 nf=1 m=1
M23 net2 net5 VDD VDD pch l=0.15 w=1 nf=1 m=1
M24 net2 net2 VSS VSS nch l=0.15 w=1 nf=1 m=1
M25 net1 net1 VDD VDD pch l=0.15 w=1 nf=1 m=1
M26 net1 net2 VSS VSS nch l=0.15 w=1 nf=1 m=1
M27 VBN net1 VDD VDD pch l=0.15 w=1 nf=1 m=1
M28 VBN VBN VSS VSS nch l=0.15 w=1 nf=1 m=1
M29 VB1 VB1 VDD VDD pch l=0.15 w=1 nf=1 m=1
M3 net6 FB VX VSS nch l=0.15 w=1 nf=1 m=1
M30 VB1 VBN VSS VSS nch l=0.15 w=1 nf=1 m=1
M4 net4 VREF VX VSS nch l=0.15 w=1 nf=1 m=1
M5 VX VBN VSS VSS nch l=0.15 w=1 nf=1 m=1
M6 net3 net6 VDD VDD pch l=0.15 w=1 nf=1 m=1
M7 EAO net4 VDD VDD pch l=0.15 w=1 nf=1 m=1
M8 net3 net3 VSS VSS nch l=0.15 w=1 nf=1 m=1
M9 EAO net3 VSS VSS nch l=0.15 w=1 nf=1 m=1
MNP VIN GATE VOUT VSS nch l=0.15 w=1 nf=1 m=1
R1 FB VSS 1k
R2 VOUT FB 1k
R3 VDD net5 1k
R4 VDD net2 1k
R5 net8 VSS 1k
RL VOUT VSS 1k
.ends dut
