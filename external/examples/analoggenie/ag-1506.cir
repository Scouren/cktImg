* official Analog Canvas netlist; PDK X cards rewritten by convert.py
.model nch nmos
.model pch pmos
.model qnpn npn

.subckt opamp VDD VSS INP INN VB1 VB3 VB5 VB2 OUT
M1 net5 net2 VDD VDD pch l=0.15 w=1 nf=1 m=1
M10 net1 INP net3 VDD pch l=0.15 w=1 nf=1 m=1
M11 net4 INN net3 VDD pch l=0.15 w=1 nf=1 m=1
M2 net0 net2 VDD VDD pch l=0.15 w=1 nf=1 m=1
M3 net2 VB3 net5 VDD pch l=0.15 w=1 nf=1 m=1
M4 OUT VB3 net0 VDD pch l=0.15 w=1 nf=1 m=1
M5 net2 VB5 net1 VSS nch l=0.15 w=1 nf=1 m=1
M6 OUT VB5 net4 VSS nch l=0.15 w=1 nf=1 m=1
M7 net1 VB2 VSS VSS nch l=0.15 w=1 nf=1 m=1
M8 net4 VB2 VSS VSS nch l=0.15 w=1 nf=1 m=1
M9 net3 VB1 VDD VDD pch l=0.15 w=1 nf=1 m=1
.ends opamp

.subckt dut VDD VSS Vout VB1 VB2 VB3
M11 net0 net1 VDD VDD pch l=0.15 w=1 nf=1 m=1
M12 net1 net1 VDD VDD pch l=0.15 w=1 nf=1 m=1
M13 VB4 net1 VDD VDD pch l=0.15 w=1 nf=1 m=1
M14 net0 net0 Z VSS nch l=0.15 w=1 nf=1 m=1
M15 Z net0 VSS VSS nch l=0.15 w=1 nf=1 m=1
M16 net1 VB4 VSS VSS nch l=0.15 w=1 nf=1 m=1
M17 VB4 VB4 VSS VSS nch l=0.15 w=1 nf=1 m=1
Q1 net3 net3 VSS VSS qnpn m=1
Q2 Z Z VSS VSS qnpn m=1
R1 Vout net3 1k
R2 Vout net2 1k
R3 net2 Z 1k
X1 VDD VSS net3 net2 VB1 VB3 net0 VB2 Vout opamp
.ends dut
