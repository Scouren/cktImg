* official Analog Canvas netlist; PDK X cards rewritten by convert.py
.model nch nmos

.subckt dut VSS IREF1 IREF2 vOUT
M1 net1 IREF2 VSS VSS nch l=0.15 w=1 nf=1 m=1
M2 vOUT IREF1 net1 VSS nch l=0.15 w=1 nf=1 m=1
M3 net0 IREF2 VSS VSS nch l=0.15 w=1 nf=1 m=1
M4 IREF1 IREF1 VSS VSS nch l=0.15 w=1 nf=1 m=1
M5 IREF2 IREF1 net0 VSS nch l=0.15 w=1 nf=1 m=1
.ends dut
