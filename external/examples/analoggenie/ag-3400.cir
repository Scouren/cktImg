* official Analog Canvas netlist; PDK X cards rewritten by convert.py
.model nch nmos
.model pch pmos

.subckt dut VDD VSS vci phi1 phi2 vco VB1
C1 net6 net0 1p
C2 net3 vco 1p
M1 vci phi1 net6 VSS nch l=0.15 w=1 nf=1 m=1
M10 net1 VB3 net4 VDD pch l=0.15 w=1 nf=1 m=1
M11 vco VB3 net7 VDD pch l=0.15 w=1 nf=1 m=1
M12 net5 net5 VDD VDD pch l=0.15 w=1 nf=1 m=1
M13 net8 net5 VDD VDD pch l=0.15 w=1 nf=1 m=1
M14 net8 net8 VSS VSS nch l=0.15 w=1 nf=1 m=1
M15 VB1 net8 VSS VSS nch l=0.15 w=1 nf=1 m=1
M16 VB1 VB1 VDD VDD pch l=0.15 w=1 nf=1 m=1
M17 VB2 VB1 VDD VDD pch l=0.15 w=1 nf=1 m=1
M18 VB2 VB2 VSS VSS nch l=0.15 w=1 nf=1 m=1
M2 net6 phi2 VSS VSS nch l=0.15 w=1 nf=1 m=1
M3 net0 phi1 VSS VSS nch l=0.15 w=1 nf=1 m=1
M4 net0 phi2 net3 VSS nch l=0.15 w=1 nf=1 m=1
M5 net1 net3 net2 VSS nch l=0.15 w=1 nf=1 m=1
M6 vco VSS net2 VSS nch l=0.15 w=1 nf=1 m=1
M7 net2 VB2 VSS VSS nch l=0.15 w=1 nf=1 m=1
M8 net4 net1 VDD VDD pch l=0.15 w=1 nf=1 m=1
M9 net7 net1 VDD VDD pch l=0.15 w=1 nf=1 m=1
R1 net5 VSS 1k
.ends dut
