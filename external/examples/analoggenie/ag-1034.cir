* official Analog Canvas netlist; PDK X cards rewritten by convert.py
.model nch nmos
.model pch pmos

.subckt dut VDD VSS vo1 vi1 vo2 vi2
IBIAS VDD net0 DC 1m
M1 vo1 vi1 net1 VSS nch l=0.15 w=1 nf=1 m=1
M2 vo2 vi2 net1 VSS nch l=0.15 w=1 nf=1 m=1
M3 vo1 vo1 VDD VDD pch l=0.15 w=1 nf=1 m=1
M4 vo2 vo2 VDD VDD pch l=0.15 w=1 nf=1 m=1
M5 net1 net0 VSS VSS nch l=0.15 w=1 nf=1 m=1
M6 vo2 vo1 VDD VDD pch l=0.15 w=1 nf=1 m=1
M7 vo1 vo2 VDD VDD pch l=0.15 w=1 nf=1 m=1
M8 net0 net0 VSS VSS nch l=0.15 w=1 nf=1 m=1
.ends dut
