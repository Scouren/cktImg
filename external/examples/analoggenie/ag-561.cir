* official Analog Canvas netlist; PDK X cards rewritten by convert.py
.model nch nmos

.subckt dut VDD VSS CK CK_bar
CL1 VSS Y1 1p
CL2 VSS X1 1p
CL3 VSS Y2 1p
CL4 VSS X2 1p
ISS1 net4 VSS DC 1m
ISS2 net5 VSS DC 1m
M1 X1 Y2 net2 VSS nch l=0.15 w=1 nf=1 m=1
M10 X2 Y2 net3 VSS nch l=0.15 w=1 nf=1 m=1
M11 net1 CK_bar net5 VSS nch l=0.15 w=1 nf=1 m=1
M12 net3 CK net5 VSS nch l=0.15 w=1 nf=1 m=1
M2 Y1 X2 net2 VSS nch l=0.15 w=1 nf=1 m=1
M3 Y1 X1 net0 VSS nch l=0.15 w=1 nf=1 m=1
M4 X1 Y1 net0 VSS nch l=0.15 w=1 nf=1 m=1
M5 net2 CK net4 VSS nch l=0.15 w=1 nf=1 m=1
M6 net0 CK_bar net4 VSS nch l=0.15 w=1 nf=1 m=1
M7 X2 X1 net1 VSS nch l=0.15 w=1 nf=1 m=1
M8 Y2 Y1 net1 VSS nch l=0.15 w=1 nf=1 m=1
M9 Y2 X2 net3 VSS nch l=0.15 w=1 nf=1 m=1
RD1 VDD X1 1k
RD2 VDD Y1 1k
RD3 VDD X2 1k
RD4 VDD Y2 1k
.ends dut
