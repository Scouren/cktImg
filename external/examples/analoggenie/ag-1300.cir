* official Analog Canvas netlist; PDK X cards rewritten by convert.py
.model nch nmos
.model pch pmos

.subckt dut VDD VSS VS5 VIN VB3 VS1 VS2 VS4 VS3 VP VREF VB2 VB1
.model DIODE D(IS=1e-14 N=1)
CFLY VX1 VX2 1p
CO VP VN 1p
COP VP VSS 1p
D1 VN VX2 DIODE
L1 VX1 VX3 1n
M1 VX1 VS1 VIN VDD pch l=0.15 w=1 nf=1 m=1
M10 net5 net0 VSS VSS nch l=0.15 w=1 nf=1 m=1
M11 net0 VB3 VSS VSS nch l=0.15 w=1 nf=1 m=1
M12 net3 net3 VDD VDD pch l=0.15 w=1 nf=1 m=1
M13 net3 VX2 VSS VSS nch l=0.15 w=1 nf=1 m=1
M14 VX2 VREF net2 VDD pch l=0.15 w=1 nf=1 m=1
M15 VX2 VX2 VSS VSS nch l=0.15 w=1 nf=1 m=1
M16 net2 VB4 VDD VDD pch l=0.15 w=1 nf=1 m=1
M17 net4 VFP1 net2 VDD pch l=0.15 w=1 nf=1 m=1
M18 net4 net4 VSS VSS nch l=0.15 w=1 nf=1 m=1
M19 VEA net3 VDD VDD pch l=0.15 w=1 nf=1 m=1
M2 VX2 VS2 VIN VDD pch l=0.15 w=1 nf=1 m=1
M20 VEA net4 VSS VSS nch l=0.15 w=1 nf=1 m=1
M21 VB2 VB2 VDD VDD pch l=0.15 w=1 nf=1 m=1
M22 VB2 net1 VX2 VSS nch l=0.15 w=1 nf=1 m=1
M23 net1 VB2 VDD VDD pch l=0.15 w=1 nf=1 m=1
M24 net1 net1 VSS VSS nch l=0.15 w=1 nf=1 m=1
M25 VB4 VB4 VDD VDD pch l=0.15 w=1 nf=1 m=1
M26 VB4 net1 VSS VSS nch l=0.15 w=1 nf=1 m=1
M27 VB1 VB4 VDD VDD pch l=0.15 w=1 nf=1 m=1
M28 VB1 VB1 VSS VSS nch l=0.15 w=1 nf=1 m=1
M3 VP VS3 VX3 VDD pch l=0.15 w=1 nf=1 m=1
M4 VX3 VS4 VSS VSS nch l=0.15 w=1 nf=1 m=1
M5 net6 VS5 VIN VDD pch l=0.15 w=1 nf=1 m=1
M6 VX1 net5 net6 VDD pch l=0.15 w=1 nf=1 m=1
M7 net5 net5 net6 VDD pch l=0.15 w=1 nf=1 m=1
M8 net0 VEA net6 VDD pch l=0.15 w=1 nf=1 m=1
M9 net0 net0 VSS VSS nch l=0.15 w=1 nf=1 m=1
R1 VP VFP1 1k
R2 VFP1 VSS 1k
RBIAS VX2 VSS 1k
.ends dut
