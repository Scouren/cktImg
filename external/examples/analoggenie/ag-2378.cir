* official Analog Canvas netlist; PDK X cards rewritten by convert.py
.model nch nmos
.model pch pmos

.subckt EA VDD VSS VB1 OUT X VB2 VREF
M11 net1 VX VDD VDD pch l=0.15 w=1 nf=1 m=1
M12 OUT VB1 net1 VDD pch l=0.15 w=1 nf=1 m=1
M13 OUT VC X VSS nch l=0.15 w=1 nf=1 m=1
M14 X net8 VSS VSS nch l=0.15 w=1 nf=1 m=1
M15 net8 OUT net5 net3 pch l=0.15 w=1 nf=1 m=1
M16 net8 VC net0 VSS nch l=0.15 w=1 nf=1 m=1
M17 net0 net8 VSS VSS nch l=0.15 w=1 nf=1 m=1
M18 net5 VB2 VDD VDD pch l=0.15 w=1 nf=1 m=1
M19 net9 VREF net5 net3 pch l=0.15 w=1 nf=1 m=1
M20 net9 VC net2 VSS nch l=0.15 w=1 nf=1 m=1
M21 net2 net9 VSS VSS nch l=0.15 w=1 nf=1 m=1
M22 net6 VX VDD VDD pch l=0.15 w=1 nf=1 m=1
M23 VX VB1 net6 VDD pch l=0.15 w=1 nf=1 m=1
M24 VX VC net7 VSS nch l=0.15 w=1 nf=1 m=1
M25 net7 net9 VSS VSS nch l=0.15 w=1 nf=1 m=1
M26 VC VBP VDD VDD pch l=0.15 w=1 nf=1 m=1
M27 VC VC OUT VSS nch l=0.15 w=1 nf=1 m=1
M28 OUT VC VSS VSS nch l=0.15 w=1 nf=1 m=1
M29 VBP VBP VDD VDD pch l=0.15 w=1 nf=1 m=1
M30 VBP VB4 VB3 VSS nch l=0.15 w=1 nf=1 m=1
M31 VB3 net4 VSS VSS nch l=0.15 w=1 nf=1 m=1
M32 net4 VBP VDD VDD pch l=0.15 w=1 nf=1 m=1
M33 net4 net4 VSS VSS nch l=0.15 w=1 nf=1 m=1
M34 VB4 VBP VDD VDD pch l=0.15 w=1 nf=1 m=1
M35 VB4 VB3 VSS VSS nch l=0.15 w=1 nf=1 m=1
.ends EA

.subckt dut VDD VSS VREF VB1 VB2 VIN pb VOUT VERR nb
M1 net1 VEA VIN VDD pch l=0.15 w=1 nf=1 m=1
M10 VERR nb VSS VSS nch l=0.15 w=1 nf=1 m=1
M2 net0 net0 net1 VDD pch l=0.15 w=1 nf=1 m=1
M3 net0 nb VSS VSS nch l=0.15 w=1 nf=1 m=1
M4 net2 pb VIN VDD pch l=0.15 w=1 nf=1 m=1
M5 net3 VEA net2 VDD pch l=0.15 w=1 nf=1 m=1
M6 net3 net3 VSS VSS nch l=0.15 w=1 nf=1 m=1
M7 VERR net3 VSS VSS nch l=0.15 w=1 nf=1 m=1
M8 VOUT VERR VIN VDD pch l=0.15 w=1 nf=1 m=1
M9 VERR net0 VOUT VDD pch l=0.15 w=1 nf=1 m=1
X1 VDD VSS VB1 VEA net1 VB2 VREF EA
.ends dut
