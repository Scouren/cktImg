* official Analog Canvas netlist; PDK X cards rewritten by convert.py
.model nch nmos
.model pch pmos
.model qnpn npn

.subckt dut VDD VSS Vout VB3 VB2
M1 net4 X net0 VDD pch l=0.15 w=1 nf=1 m=1
M10 net3 net2 VDD VDD pch l=0.15 w=1 nf=1 m=1
M11 net1 net2 VDD VDD pch l=0.15 w=1 nf=1 m=1
M12 net5 net5 VDD VDD pch l=0.15 w=1 nf=1 m=1
M13 VBN net5 VDD VDD pch l=0.15 w=1 nf=1 m=1
M14 VBN VBN VQ VSS nch l=0.15 w=1 nf=1 m=1
M15 VQ VBN VSS VSS nch l=0.15 w=1 nf=1 m=1
M2 net6 Y net0 VDD pch l=0.15 w=1 nf=1 m=1
M3 net0 VB1 VDD VDD pch l=0.15 w=1 nf=1 m=1
M4 net4 VB2 VSS VSS nch l=0.15 w=1 nf=1 m=1
M5 net6 VB2 VSS VSS nch l=0.15 w=1 nf=1 m=1
M6 net2 VBN net4 VSS nch l=0.15 w=1 nf=1 m=1
M7 Vout VBN net6 VSS nch l=0.15 w=1 nf=1 m=1
M8 net2 VB3 net3 VDD pch l=0.15 w=1 nf=1 m=1
M9 Vout VB3 net1 VDD pch l=0.15 w=1 nf=1 m=1
Q1 X X VSS VSS qnpn m=1
Q2 VQ VQ VSS VSS qnpn m=1
R1 Vout X 1k
R2 Vout Y 1k
R3 Y VQ 1k
R4 net5 VSS 1k
.ends dut
