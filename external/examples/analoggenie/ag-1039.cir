* official Analog Canvas netlist; PDK X cards rewritten by convert.py
.model nch nmos
.model pch pmos

.subckt dut VDD VSS FB Reset Enable VBIAS Vin1 Vin2 Q Q_bar Latch
C1 net0 Vin1 1p
C2 net4 Vin2 1p
M1 Q net0 net1 VSS nch l=0.15 w=1 nf=1 m=1
M10 net1 Enable net3 VSS nch l=0.15 w=1 nf=1 m=1
M11 net2 Latch net3 VSS nch l=0.15 w=1 nf=1 m=1
M12 net3 VBIAS VSS VSS nch l=0.15 w=1 nf=1 m=1
M2 Q_bar net4 net1 VSS nch l=0.15 w=1 nf=1 m=1
M3 Q Q VDD VDD pch l=0.15 w=1 nf=1 m=1
M4 Q_bar Q_bar VDD VDD pch l=0.15 w=1 nf=1 m=1
M5 Q_bar Q net2 VSS nch l=0.15 w=1 nf=1 m=1
M6 Q Q_bar net2 VSS nch l=0.15 w=1 nf=1 m=1
M7 Q FB net0 VSS nch l=0.15 w=1 nf=1 m=1
M8 Q FB Q_bar VSS nch l=0.15 w=1 nf=1 m=1
M9 Q_bar Reset net4 VSS nch l=0.15 w=1 nf=1 m=1
.ends dut
