* official Analog Canvas netlist; PDK X cards rewritten by convert.py
.model nch nmos
.model pch pmos

.subckt opamp VDD VSS INP INN OUT
M1 net4 VB1 VDD VDD pch l=0.15 w=1 nf=1 m=1
M10 net5 net3 VSS VSS nch l=0.15 w=1 nf=1 m=1
M11 OUT VB2 VSS VSS nch l=0.15 w=1 nf=1 m=1
M12 VB4 net0 VDD VDD pch l=0.15 w=1 nf=1 m=1
M13 net0 net0 VDD VDD pch l=0.15 w=1 nf=1 m=1
M14 VB5 net0 VDD VDD pch l=0.15 w=1 nf=1 m=1
M15 net6 VB4 VSS VSS nch l=0.15 w=1 nf=1 m=1
M16 net0 VB4 VSS VSS nch l=0.15 w=1 nf=1 m=1
M17 VB5 VB5 net1 VSS nch l=0.15 w=1 nf=1 m=1
M18 net1 VB5 VSS VSS nch l=0.15 w=1 nf=1 m=1
M2 net7 VB1 VDD VDD pch l=0.15 w=1 nf=1 m=1
M3 net4 INP OUT VSS nch l=0.15 w=1 nf=1 m=1
M4 net7 INN OUT VSS nch l=0.15 w=1 nf=1 m=1
M5 OUT VB3 net4 VDD pch l=0.15 w=1 nf=1 m=1
M6 net3 VB3 net7 VDD pch l=0.15 w=1 nf=1 m=1
M7 OUT VB5 net2 VSS nch l=0.15 w=1 nf=1 m=1
M8 net3 VB5 net5 VSS nch l=0.15 w=1 nf=1 m=1
M9 net2 net3 VSS VSS nch l=0.15 w=1 nf=1 m=1
R1 VB4 net6 1k
.ends opamp

.subckt dut VDD VSS Vref VIN VOUT
CL VOUT net1 1p
MNP VIN net0 VOUT VSS nch l=0.15 w=1 nf=1 m=1
R1 VOUT FB 1k
R2 FB VSS 1k
R3 net1 VSS 1k
X1 VDD VSS Vref FB net0 opamp
.ends dut
