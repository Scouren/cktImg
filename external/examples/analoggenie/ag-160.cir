* official Analog Canvas netlist; PDK X cards rewritten by convert.py
.model nch nmos

.subckt dut VDD VSS VIN1 VOUT1
CF VOUT1 Y 1p
I1 VDD Y DC 1m
M1 Y VOUT1 VSS VSS nch l=0.15 w=1 nf=1 m=1
R1 VIN1 VOUT1 1k
.ends dut
