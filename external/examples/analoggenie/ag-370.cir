* official Analog Canvas netlist; PDK X cards rewritten by convert.py
.model nch nmos
.model pch pmos

.subckt dut VDD VSS
M1 net1 net2 VSS VSS nch l=0.15 w=1 nf=1 m=1
M2 net2 net2 VSS VSS nch l=0.15 w=1 nf=1 m=1
M3 net2 net1 net0 net0 pch l=0.15 w=1 nf=1 m=1
M4 net1 net1 VDD VDD pch l=0.15 w=1 nf=1 m=1
RS VDD net0 1k
.ends dut
