* official Analog Canvas netlist; PDK X cards rewritten by convert.py
.model nch nmos
.model pch pmos

.subckt dut VDD VSS Vin Vout
C1 net0 VSS 1p
I1 VDD net0 DC 1m
M1 Vout Vin VSS VSS nch l=0.15 w=1 nf=1 m=1
M2 Vout Vin net0 VDD pch l=0.15 w=1 nf=1 m=1
RF Vin Vout 1k
.ends dut
