* official Analog Canvas netlist; PDK X cards rewritten by convert.py
.model nch nmos
.model pch pmos

.subckt AMP1 VDD VSS INP INN OUT
M10 net1 INN net4 VSS nch l=0.15 w=1 nf=1 m=1
M11 INN INP net4 VSS nch l=0.15 w=1 nf=1 m=1
M12 net4 VX VSS VSS nch l=0.15 w=1 nf=1 m=1
M13 net2 net2 VSS VSS nch l=0.15 w=1 nf=1 m=1
M14 OUT net2 VSS VSS nch l=0.15 w=1 nf=1 m=1
M15 VX net0 VDD VDD pch l=0.15 w=1 nf=1 m=1
M16 VY net0 VDD VDD pch l=0.15 w=1 nf=1 m=1
M17 net0 net0 VDD VDD pch l=0.15 w=1 nf=1 m=1
M18 net3 net0 VDD VDD pch l=0.15 w=1 nf=1 m=1
M19 VX VX VSS VSS nch l=0.15 w=1 nf=1 m=1
M20 VY VY VSS VSS nch l=0.15 w=1 nf=1 m=1
M21 net0 net3 net5 VSS nch l=0.15 w=1 nf=1 m=1
M22 net3 net5 VSS VSS nch l=0.15 w=1 nf=1 m=1
M23 net5 VY VSS VSS nch l=0.15 w=1 nf=1 m=1
M6 net2 net1 VDD VDD pch l=0.15 w=1 nf=1 m=1
M7 net1 net1 VDD VDD pch l=0.15 w=1 nf=1 m=1
M8 INN INN VDD VDD pch l=0.15 w=1 nf=1 m=1
M9 OUT INN VDD VDD pch l=0.15 w=1 nf=1 m=1
.ends AMP1

.subckt dut VDD VSS biasp biascas biasn Vout Vref
C1 Vset VSS 1p
C2 n3 Vout 1p
M1 Vout n3 VDD VDD pch l=0.15 w=1 nf=1 m=1
M2 n1 Vset Vout VDD pch l=0.15 w=1 nf=1 m=1
M3 n1 biasn VSS VSS nch l=0.15 w=1 nf=1 m=1
M4 n3 biasp VDD VDD pch l=0.15 w=1 nf=1 m=1
M5 n3 biascas n1 VSS nch l=0.15 w=1 nf=1 m=1
R1 fb VSS 1k
R2 Vout fb 1k
X1 VDD VSS Vref fb Vset AMP1
.ends dut
