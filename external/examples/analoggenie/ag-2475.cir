* official Analog Canvas netlist; PDK X cards rewritten by convert.py
.model nch nmos
.model pch pmos

.subckt bias VDD VSS VB7 VB8
M31 VB7 VB9 VDD VDD pch l=0.15 w=1 nf=1 m=1
M32 VB7 VB7 VB8 VSS nch l=0.15 w=1 nf=1 m=1
M33 VB8 VB8 VSS VSS nch l=0.15 w=1 nf=1 m=1
M34 VB9 VB9 VDD VDD pch l=0.15 w=1 nf=1 m=1
M35 net1 VB9 VDD VDD pch l=0.15 w=1 nf=1 m=1
M36 net0 VB9 VDD VDD pch l=0.15 w=1 nf=1 m=1
M37 VB3 VB9 VDD VDD pch l=0.15 w=1 nf=1 m=1
M38 VB9 net3 VSS VSS nch l=0.15 w=1 nf=1 m=1
M39 net1 net1 net3 VSS nch l=0.15 w=1 nf=1 m=1
M40 net3 net1 net2 VSS nch l=0.15 w=1 nf=1 m=1
M41 net2 net0 VB3 VSS nch l=0.15 w=1 nf=1 m=1
M42 net0 net0 net2 VSS nch l=0.15 w=1 nf=1 m=1
M43 VB3 VB3 VSS VSS nch l=0.15 w=1 nf=1 m=1
.ends bias

.subckt dut VIN VSS VB1 VB2 VREF VB4 VB6 VB5 VOUT
CF1 VOUT VFB 1p
Cm1 net3 VOUT 1p
Cm2 net3 net9 1p
M1 VX VB1 VIN VIN pch l=0.15 w=1 nf=1 m=1
M11 net6 VB8 VSS VSS nch l=0.15 w=1 nf=1 m=1
M12 net0 VFB net6 VSS nch l=0.15 w=1 nf=1 m=1
M13 VX VREF net6 VSS nch l=0.15 w=1 nf=1 m=1
M14 net7 net2 VSS VSS nch l=0.15 w=1 nf=1 m=1
M15 net1 net2 VSS VSS nch l=0.15 w=1 nf=1 m=1
M16 VG VB4 VIN VIN pch l=0.15 w=1 nf=1 m=1
M17 VG net3 VSS VSS nch l=0.15 w=1 nf=1 m=1
M18 VG VG VSS VSS nch l=0.15 w=1 nf=1 m=1
M2 net0 VB1 VIN VIN pch l=0.15 w=1 nf=1 m=1
M21 net4 net3 VSS VSS nch l=0.15 w=1 nf=1 m=1
M22 net10 VG VSS VSS nch l=0.15 w=1 nf=1 m=1
M23 net4 net4 VIN VIN pch l=0.15 w=1 nf=1 m=1
M24 net10 net4 VIN VIN pch l=0.15 w=1 nf=1 m=1
M3 net2 VB2 VX VIN pch l=0.15 w=1 nf=1 m=1
M4 net3 VB2 net0 VIN pch l=0.15 w=1 nf=1 m=1
M5 net2 VB7 net7 VSS nch l=0.15 w=1 nf=1 m=1
M6 net3 VB7 net1 VSS nch l=0.15 w=1 nf=1 m=1
MD1 net9 net3 VSS VSS nch l=0.15 w=1 nf=1 m=1
MD2 net8 VB5 VSS VSS nch l=0.15 w=1 nf=1 m=1
MD3 VX net9 net8 VSS nch l=0.15 w=1 nf=1 m=1
MD4 net5 VB6 net8 VSS nch l=0.15 w=1 nf=1 m=1
MD5 net9 net5 VIN VIN pch l=0.15 w=1 nf=1 m=1
MD6 VX VX VIN VIN pch l=0.15 w=1 nf=1 m=1
MD7 net5 net5 VIN VIN pch l=0.15 w=1 nf=1 m=1
MPT VOUT net10 VIN VIN pch l=0.15 w=1 nf=1 m=1
RF1 VOUT VFB 1k
RF2 VFB VSS 1k
X1 VIN VSS VB7 VB8 bias
.ends dut
