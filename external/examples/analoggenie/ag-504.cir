* official Analog Canvas netlist; PDK X cards rewritten by convert.py
.model nch nmos

.subckt dut VDD VSS LO LO_bar VRF+ VRF- Vout1 Vout2
M1 net1 VRF+ VSS VSS nch l=0.15 w=1 nf=1 m=1
M2 Vout1 LO net1 VSS nch l=0.15 w=1 nf=1 m=1
M3 Vout2 LO_bar net1 VSS nch l=0.15 w=1 nf=1 m=1
M4 net0 VRF- VSS VSS nch l=0.15 w=1 nf=1 m=1
M5 Vout1 LO_bar net0 VSS nch l=0.15 w=1 nf=1 m=1
M6 Vout2 LO net0 VSS nch l=0.15 w=1 nf=1 m=1
R1 VDD Vout1 1k
R2 VDD Vout2 1k
.ends dut
