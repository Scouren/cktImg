* official Analog Canvas netlist; PDK X cards rewritten by convert.py
.model nch nmos
.model pch pmos

.subckt opamp VDD VSS VB3 INP INN X OUT
M10 net2 net0 VSS VSS nch l=0.15 w=1 nf=1 m=1
M11 net1 net0 VSS VSS nch l=0.15 w=1 nf=1 m=1
M5 X VB3 VDD VDD pch l=0.15 w=1 nf=1 m=1
M6 net0 INP X VDD pch l=0.15 w=1 nf=1 m=1
M7 OUT INN X VDD pch l=0.15 w=1 nf=1 m=1
M8 net0 VB4 net2 VSS nch l=0.15 w=1 nf=1 m=1
M9 OUT VB4 net1 VSS nch l=0.15 w=1 nf=1 m=1
.ends opamp

.subckt dut VDD VSS vci phi1 phi2 vco VB1 VB2
C1 vcx VSS 1p
C2 net0 vco 1p
M1 vci phi1 vcx VSS nch l=0.15 w=1 nf=1 m=1
M12 net1 net1 VDD VDD pch l=0.15 w=1 nf=1 m=1
M13 VB2 net1 VDD VDD pch l=0.15 w=1 nf=1 m=1
M14 VB3 VB1 VSS VSS nch l=0.15 w=1 nf=1 m=1
M15 VB1 VB1 VSS VSS nch l=0.15 w=1 nf=1 m=1
M16 net1 VB2 net2 VSS nch l=0.15 w=1 nf=1 m=1
M17 VB2 VB2 VSS VSS nch l=0.15 w=1 nf=1 m=1
M2 vcx phi2 net0 VSS nch l=0.15 w=1 nf=1 m=1
M3 VB3 VB3 VDD VDD pch l=0.15 w=1 nf=1 m=1
M4 VB1 net1 VDD VDD pch l=0.15 w=1 nf=1 m=1
R1 net2 VSS 1k
X1 VDD VSS VB3 VSS net0 vcx vco opamp
.ends dut
