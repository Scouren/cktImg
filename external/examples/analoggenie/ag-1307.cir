* official Analog Canvas netlist; PDK X cards rewritten by convert.py
.model nch nmos
.model pch pmos

.subckt dut VDD VSS VIN VCONT1 VCONT2 VCONT3 VCONT5 VCONT4 VP VB3
.model DIODE D(IS=1e-14 N=1)
CFLY VX1 VX2 1p
CO VP VN 1p
COP VP VSS 1p
D1 VN VX2 DIODE
L1 VX1 VX3 1n
M1 net3 VCONT1 VIN VIN pch l=0.15 w=1 nf=1 m=1
M10 net6 net6 VSS VSS nch l=0.15 w=1 nf=1 m=1
M11 net6 VB3 VSS VSS nch l=0.15 w=1 nf=1 m=1
M12 net5 net5 VDD VDD pch l=0.15 w=1 nf=1 m=1
M13 VEA net5 VDD VDD pch l=0.15 w=1 nf=1 m=1
M14 net8 VB4 VDD VDD pch l=0.15 w=1 nf=1 m=1
M15 VX2 VREF net8 net7 pch l=0.15 w=1 nf=1 m=1
M16 net0 VFP1 net8 net7 pch l=0.15 w=1 nf=1 m=1
M17 net5 VX2 VSS VSS nch l=0.15 w=1 nf=1 m=1
M18 VX2 VX2 VSS VSS nch l=0.15 w=1 nf=1 m=1
M19 net0 net0 VSS VSS nch l=0.15 w=1 nf=1 m=1
M2 VX1 VCONT2 VIN VIN pch l=0.15 w=1 nf=1 m=1
M20 VEA net0 VSS VSS nch l=0.15 w=1 nf=1 m=1
M21 VB2 VB2 VDD VDD pch l=0.15 w=1 nf=1 m=1
M22 VB2 net4 VSS VSS nch l=0.15 w=1 nf=1 m=1
M23 net4 VB2 VDD VDD pch l=0.15 w=1 nf=1 m=1
M24 net4 net4 VSS VSS nch l=0.15 w=1 nf=1 m=1
M25 net2 net2 VDD VDD pch l=0.15 w=1 nf=1 m=1
M26 net2 net4 VSS VSS nch l=0.15 w=1 nf=1 m=1
M27 VB1 net2 VDD VDD pch l=0.15 w=1 nf=1 m=1
M28 VB1 VB1 VSS VSS nch l=0.15 w=1 nf=1 m=1
M29 VB4 VB4 VDD VDD pch l=0.15 w=1 nf=1 m=1
M3 VX2 VCONT3 VIN VIN pch l=0.15 w=1 nf=1 m=1
M30 VB4 VB1 VSS VSS nch l=0.15 w=1 nf=1 m=1
M4 VX3 VCONT5 VP VP pch l=0.15 w=1 nf=1 m=1
M5 VX3 VCONT4 VSS VSS nch l=0.15 w=1 nf=1 m=1
M6 VX1 net1 net3 net3 pch l=0.15 w=1 nf=1 m=1
M7 net1 net1 net3 net3 pch l=0.15 w=1 nf=1 m=1
M8 net6 VEA net3 net3 pch l=0.15 w=1 nf=1 m=1
M9 net1 net6 VSS VSS nch l=0.15 w=1 nf=1 m=1
R1 VP VFP1 1k
R2 VFP1 VSS 1k
.ends dut
