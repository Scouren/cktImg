* official Analog Canvas netlist; PDK X cards rewritten by convert.py
.model nch nmos
.model pch pmos

.subckt BIAS VDD VSS VB2 VB1 VBN
MB1 VB2 VB2 VDD VDD pch l=0.15 w=1 nf=1 m=1
MB10 VB1 VBN VSS VSS nch l=0.15 w=1 nf=1 m=1
MB2 net0 VB2 VDD VDD pch l=0.15 w=1 nf=1 m=1
MB3 net1 net1 VDD VDD pch l=0.15 w=1 nf=1 m=1
MB4 VBN net1 VDD VDD pch l=0.15 w=1 nf=1 m=1
MB5 VB1 VB1 VDD VDD pch l=0.15 w=1 nf=1 m=1
MB6 VB2 net0 VSS VSS nch l=0.15 w=1 nf=1 m=1
MB7 net2 net0 VSS VSS nch l=0.15 w=1 nf=1 m=1
MB8 net1 net0 VSS VSS nch l=0.15 w=1 nf=1 m=1
MB9 VBN VBN VSS VSS nch l=0.15 w=1 nf=1 m=1
RBIAS net0 net2 1k
.ends BIAS

.subckt EA1 VDD VSS OUT X INP INN VBN
MN1 X INP net2 VSS nch l=0.15 w=1 nf=1 m=1
MN2 net1 INN net2 VSS nch l=0.15 w=1 nf=1 m=1
MN3 net0 net0 VSS VSS nch l=0.15 w=1 nf=1 m=1
MN4 OUT net0 VSS VSS nch l=0.15 w=1 nf=1 m=1
MN5 net2 VBN VSS VSS nch l=0.15 w=1 nf=1 m=1
MP1 X X VDD VDD pch l=0.15 w=1 nf=1 m=1
MP2 net1 net1 VDD VDD pch l=0.15 w=1 nf=1 m=1
MP3 OUT X VDD VDD pch l=0.15 w=1 nf=1 m=1
MP4 net0 net1 VDD VDD pch l=0.15 w=1 nf=1 m=1
.ends EA1

.subckt ISR VDD VSS TOP OUT IN VB3
MN6 net0 net0 VSS VSS nch l=0.15 w=1 nf=1 m=1
MN7 net0 VB3 VSS VSS nch l=0.15 w=1 nf=1 m=1
MN8 net1 net0 VSS VSS nch l=0.15 w=1 nf=1 m=1
MP5 net0 IN TOP VDD pch l=0.15 w=1 nf=1 m=1
MP6 net1 net1 TOP VDD pch l=0.15 w=1 nf=1 m=1
MP7 OUT net1 TOP VDD pch l=0.15 w=1 nf=1 m=1
.ends ISR

.subckt dut VDD VSS VB3 VG5 VG1 VG2 VIN VG3 VG4 VP VREF VB2 VB1
.model DIODE D(IS=1e-14 N=1)
CFLY VX1 VX2 1p
CO VP VN 1p
COP VP VSS 1p
D1 VN VX2 DIODE
L1 VX1 net0 1n
M1 VX1 VG1 VIN VDD pch l=0.15 w=1 nf=1 m=1
M2 VX2 VG2 VIN VDD pch l=0.15 w=1 nf=1 m=1
M3 VP VG3 net0 VDD pch l=0.15 w=1 nf=1 m=1
M4 net0 VG4 VSS VSS nch l=0.15 w=1 nf=1 m=1
M5 net3 VG5 VIN VDD pch l=0.15 w=1 nf=1 m=1
R1 VP VFP1 1k
R2 VFP1 VSS 1k
X1 VDD VSS net3 VX1 net2 VB3 ISR
X2 VDD VSS net2 net0 VREF VFP1 net1 EA1
X3 VDD VSS VB2 VB1 net1 BIAS
.ends dut
