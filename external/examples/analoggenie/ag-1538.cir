* official Analog Canvas netlist; PDK X cards rewritten by convert.py
.model nch nmos
.model pch pmos
.model qnpn npn

.subckt dut VDD VSS Vout VB2 VB1
M1 net4 X net5 VSS nch l=0.15 w=1 nf=1 m=1
M10 VB2 VB2 VDD VDD pch l=0.15 w=1 nf=1 m=1
M11 VB2 net1 VSS VSS nch l=0.15 w=1 nf=1 m=1
M12 net1 VB2 VDD VDD pch l=0.15 w=1 nf=1 m=1
M13 net3 net1 VSS VSS nch l=0.15 w=1 nf=1 m=1
M14 net0 net0 VDD VDD pch l=0.15 w=1 nf=1 m=1
M15 net0 net1 VSS VSS nch l=0.15 w=1 nf=1 m=1
M16 VB3 net0 VDD VDD pch l=0.15 w=1 nf=1 m=1
M17 VB3 VB3 VSS VSS nch l=0.15 w=1 nf=1 m=1
M18 VB1 VB1 VDD VDD pch l=0.15 w=1 nf=1 m=1
M19 VB1 VB3 VSS VSS nch l=0.15 w=1 nf=1 m=1
M2 net2 Y net5 VSS nch l=0.15 w=1 nf=1 m=1
M3 net4 net4 VDD VDD pch l=0.15 w=1 nf=1 m=1
M4 net2 net2 VDD VDD pch l=0.15 w=1 nf=1 m=1
M5 net5 VB3 VSS VSS nch l=0.15 w=1 nf=1 m=1
M6 Vout net4 VDD VDD pch l=0.15 w=1 nf=1 m=1
M7 Z net2 VDD VDD pch l=0.15 w=1 nf=1 m=1
M8 Vout Z VSS VSS nch l=0.15 w=1 nf=1 m=1
M9 Z Z VSS VSS nch l=0.15 w=1 nf=1 m=1
Q1 X X VSS VSS qnpn m=1
Q2 Z Z VSS VSS qnpn m=1
R1 Vout X 1k
R2 Vout Y 1k
R3 Y Z 1k
R4 net1 net3 1k
.ends dut
