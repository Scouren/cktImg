* official Analog Canvas netlist; PDK X cards rewritten by convert.py
.model nch nmos
.model pch pmos

.subckt dut VDD VSS GND vin- vin+ VBIAS vout
CL vout GND 1p
M1 net2 vin- net3 VSS nch l=0.15 w=1 nf=1 m=1
M2 net1 vin+ net3 VSS nch l=0.15 w=1 nf=1 m=1
M3 net2 net2 VDD VDD pch l=0.15 w=1 nf=1 m=1
M4 net1 net1 VDD VDD pch l=0.15 w=1 nf=1 m=1
M5 net3 VBIAS VSS VSS nch l=0.15 w=1 nf=1 m=1
M6 vout net1 VDD VDD pch l=0.15 w=1 nf=1 m=1
M7 vout net0 VSS VSS nch l=0.15 w=1 nf=1 m=1
M8 net0 net2 VDD VDD pch l=0.15 w=1 nf=1 m=1
M9 net0 net0 VSS VSS nch l=0.15 w=1 nf=1 m=1
.ends dut
