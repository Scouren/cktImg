* official Analog Canvas netlist; PDK X cards rewritten by convert.py

.subckt dut VSS Vin Vout
C1 Vin Vout 1p
C2 Vout VSS 1p
R1 Vin Vout 1k
R2 Vout VSS 1k
.ends dut
