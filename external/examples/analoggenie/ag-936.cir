* official Analog Canvas netlist; PDK X cards rewritten by convert.py
.model nch nmos

.subckt dut VSS II IREG IO
M1 IREG net0 VSS VSS nch l=0.15 w=1 nf=1 m=1
M2 net0 II VSS VSS nch l=0.15 w=1 nf=1 m=1
M3 IO IREG net0 VSS nch l=0.15 w=1 nf=1 m=1
M4 II II VSS VSS nch l=0.15 w=1 nf=1 m=1
.ends dut
