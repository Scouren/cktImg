* official Analog Canvas netlist; PDK X cards rewritten by convert.py
.model nch nmos
.model pch pmos

.subckt bias VDD VSS VB1 VN
M1 VN VN VSS VSS nch l=0.15 w=1 nf=1 m=1
M22 VB1 VB1 VN VSS nch l=0.15 w=1 nf=1 m=1
M23 VB1 VP VDD VDD pch l=0.15 w=1 nf=1 m=1
M24 VP VP VDD VDD pch l=0.15 w=1 nf=1 m=1
M25 net1 VP VDD VDD pch l=0.15 w=1 nf=1 m=1
M26 net0 VP VDD VDD pch l=0.15 w=1 nf=1 m=1
M27 VP net1 net2 VSS nch l=0.15 w=1 nf=1 m=1
M28 net1 net2 VSS VSS nch l=0.15 w=1 nf=1 m=1
M29 net2 net0 VSS VSS nch l=0.15 w=1 nf=1 m=1
M30 net0 net0 VSS VSS nch l=0.15 w=1 nf=1 m=1
.ends bias

.subckt dut VDD VSS VREF VB4 IBUF VIN FB VOUT
CL VOUT net8 1p
M10 EAO VB2 net10 VDD pch l=0.15 w=1 nf=1 m=1
M11 net1 VB3 VDD VDD pch l=0.15 w=1 nf=1 m=1
M12 net10 VB3 VDD VDD pch l=0.15 w=1 nf=1 m=1
M13 net3 VB4 VDD VDD pch l=0.15 w=1 nf=1 m=1
M14 net2 EAO net3 VDD pch l=0.15 w=1 nf=1 m=1
M15 net2 net2 VSS VSS nch l=0.15 w=1 nf=1 m=1
M16 GATE net2 VSS VSS nch l=0.15 w=1 nf=1 m=1
M17 VDD net3 GATE VSS nch l=0.15 w=1 nf=1 m=1
M18 net7 EAO IBUF VSS nch l=0.15 w=1 nf=1 m=1
M19 net7 net7 VDD VDD pch l=0.15 w=1 nf=1 m=1
M2 net4 net9 VSS VSS nch l=0.15 w=1 nf=1 m=1
M20 GATE net7 VDD VDD pch l=0.15 w=1 nf=1 m=1
M21 VSS IBUF GATE VDD pch l=0.15 w=1 nf=1 m=1
M3 net10 VREF net4 VSS nch l=0.15 w=1 nf=1 m=1
M4 net1 FB net4 VSS nch l=0.15 w=1 nf=1 m=1
M5 net0 net6 VSS VSS nch l=0.15 w=1 nf=1 m=1
M6 net5 net6 VSS VSS nch l=0.15 w=1 nf=1 m=1
M7 net6 VB1 net0 VSS nch l=0.15 w=1 nf=1 m=1
M8 EAO VB1 net5 VSS nch l=0.15 w=1 nf=1 m=1
M9 net6 VB2 net1 VDD pch l=0.15 w=1 nf=1 m=1
MNP VIN GATE VOUT VSS nch l=0.15 w=1 nf=1 m=1
R1 FB VSS 1k
R2 VOUT FB 1k
R3 net8 VSS 1k
RL VOUT VSS 1k
X1 VDD VSS VB1 net9 bias
.ends dut
