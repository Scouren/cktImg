* official Analog Canvas netlist; PDK X cards rewritten by convert.py
.model nch nmos
.model pch pmos

.subckt dut VDD VSS vo1 vo2 Iin1 Iin2 Iin3 Iin4
M10 net2 Iin2 VDD VDD pch l=0.15 w=1 nf=1 m=1
M11 net4 Iin3 VSS VSS nch l=0.15 w=1 nf=1 m=1
M12 net5 Iin4 VSS VSS nch l=0.15 w=1 nf=1 m=1
M13 vo1 net1 net7 VDD pch l=0.15 w=1 nf=1 m=1
M14 vo2 net0 net2 VDD pch l=0.15 w=1 nf=1 m=1
M15 vo1 net6 net4 VSS nch l=0.15 w=1 nf=1 m=1
M16 vo2 net3 net5 VSS nch l=0.15 w=1 nf=1 m=1
M17 net6 Iin2 VDD VDD pch l=0.15 w=1 nf=1 m=1
M18 net3 Iin1 VDD VDD pch l=0.15 w=1 nf=1 m=1
M19 net1 Iin4 VSS VSS nch l=0.15 w=1 nf=1 m=1
M20 net0 Iin3 VSS VSS nch l=0.15 w=1 nf=1 m=1
M21 net1 net1 VDD VDD pch l=0.15 w=1 nf=1 m=1
M22 net0 net0 VDD VDD pch l=0.15 w=1 nf=1 m=1
M23 net6 net6 VSS VSS nch l=0.15 w=1 nf=1 m=1
M24 net3 net3 VSS VSS nch l=0.15 w=1 nf=1 m=1
M5 Iin3 Iin3 VSS VSS nch l=0.15 w=1 nf=1 m=1
M6 Iin4 Iin4 VSS VSS nch l=0.15 w=1 nf=1 m=1
M7 Iin1 Iin1 VDD VDD pch l=0.15 w=1 nf=1 m=1
M8 Iin2 Iin2 VDD VDD pch l=0.15 w=1 nf=1 m=1
M9 net7 Iin1 VDD VDD pch l=0.15 w=1 nf=1 m=1
.ends dut
