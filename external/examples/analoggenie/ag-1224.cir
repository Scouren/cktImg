* official Analog Canvas netlist; PDK X cards rewritten by convert.py
.model nch nmos
.model pch pmos

.subckt dut VDD VSS VS5 VIN VS1 VS2 VS3 VS4 VP
.model DIODE D(IS=1e-14 N=1)
CFLY VX1 VX2 1p
CO VP VN 1p
COP VP VSS 1p
D1 VN VX2 DIODE
L1 VX1 VX3 1n
M1 VX1 VS1 VIN VDD pch l=0.15 w=1 nf=1 m=1
M10 VA VA VSS VSS nch l=0.15 w=1 nf=1 m=1
M11 VA VB5 VSS VSS nch l=0.15 w=1 nf=1 m=1
M13 net2 VB1 VDD VDD pch l=0.15 w=1 nf=1 m=1
M14 net1 VB1 VDD VDD pch l=0.15 w=1 nf=1 m=1
M15 net0 VB3 net2 VDD pch l=0.15 w=1 nf=1 m=1
M16 VEA1 VB3 net1 VDD pch l=0.15 w=1 nf=1 m=1
M17 net0 VB6 VA VSS nch l=0.15 w=1 nf=1 m=1
M18 VEA1 VB6 net8 VSS nch l=0.15 w=1 nf=1 m=1
M19 VA net0 VSS VSS nch l=0.15 w=1 nf=1 m=1
M2 VX2 VS2 VIN VDD pch l=0.15 w=1 nf=1 m=1
M20 net8 net0 VSS VSS nch l=0.15 w=1 nf=1 m=1
M21 net2 VFP1 net3 VSS nch l=0.15 w=1 nf=1 m=1
M22 net1 VREF net3 VSS nch l=0.15 w=1 nf=1 m=1
M23 net3 VB2 VSS VSS nch l=0.15 w=1 nf=1 m=1
M24 VB6 VB7 VDD VDD pch l=0.15 w=1 nf=1 m=1
M25 VB6 VB6 net5 VSS nch l=0.15 w=1 nf=1 m=1
M26 net5 VB6 VSS VSS nch l=0.15 w=1 nf=1 m=1
M27 VB7 VB7 VDD VDD pch l=0.15 w=1 nf=1 m=1
M28 net4 VB7 VDD VDD pch l=0.15 w=1 nf=1 m=1
M29 net7 VB7 VDD VDD pch l=0.15 w=1 nf=1 m=1
M3 VP VS3 VX3 VDD pch l=0.15 w=1 nf=1 m=1
M30 VB4 VB7 VDD VDD pch l=0.15 w=1 nf=1 m=1
M31 VB7 VC VSS VSS nch l=0.15 w=1 nf=1 m=1
M32 net4 net4 net10 VSS nch l=0.15 w=1 nf=1 m=1
M33 net7 net7 VC VSS nch l=0.15 w=1 nf=1 m=1
M34 VC net7 net10 VSS nch l=0.15 w=1 nf=1 m=1
M35 net10 net4 VB4 VSS nch l=0.15 w=1 nf=1 m=1
M36 VB4 VB4 VSS VSS nch l=0.15 w=1 nf=1 m=1
M4 VX3 VS4 VSS VSS nch l=0.15 w=1 nf=1 m=1
M5 net9 VS5 VIN VDD pch l=0.15 w=1 nf=1 m=1
M6 VX1 net6 net9 VDD pch l=0.15 w=1 nf=1 m=1
M7 net6 net6 net9 VDD pch l=0.15 w=1 nf=1 m=1
M8 VA VEA1 net9 VDD pch l=0.15 w=1 nf=1 m=1
M9 net6 VA VSS VSS nch l=0.15 w=1 nf=1 m=1
R1 VP VFP1 1k
R2 VFP1 VSS 1k
.ends dut
