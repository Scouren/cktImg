* official Analog Canvas netlist; PDK X cards rewritten by convert.py
.model nch nmos
.model pch pmos

.subckt dut VDD VSS VPB1 VPB2 VNB2 VNB1 Iin Iout
M1 Iin net1 VSS VSS nch l=0.15 w=1 nf=1 m=1
M2 net0 VNB1 VSS VSS nch l=0.15 w=1 nf=1 m=1
M3 net1 VNB2 Iin VSS nch l=0.15 w=1 nf=1 m=1
M4 Iout VNB2 net0 VSS nch l=0.15 w=1 nf=1 m=1
M5 net1 VPB1 VDD VDD pch l=0.15 w=1 nf=1 m=1
M6 Iout VPB2 net1 VDD pch l=0.15 w=1 nf=1 m=1
.ends dut
