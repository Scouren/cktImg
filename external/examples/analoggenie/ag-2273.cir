* official Analog Canvas netlist; PDK X cards rewritten by convert.py
.model nch nmos
.model pch pmos

.subckt dut VDD VSS VB1 VREF VB2 VB3 VIN VOUT IBUF
CL VOUT net10 1p
M1 net4 net4 VDD VDD pch l=0.15 w=1 nf=1 m=1
M10 EAO VB1 net12 VDD pch l=0.15 w=1 nf=1 m=1
M11 net5 net0 VDD VDD pch l=0.15 w=1 nf=1 m=1
M12 net12 net7 VDD VDD pch l=0.15 w=1 nf=1 m=1
M13 VT VB3 VDD VDD pch l=0.15 w=1 nf=1 m=1
M14 net2 EAO VT VDD pch l=0.15 w=1 nf=1 m=1
M15 net2 net2 VSS VSS nch l=0.15 w=1 nf=1 m=1
M16 GATE net2 VSS VSS nch l=0.15 w=1 nf=1 m=1
M17 VDD VT GATE VSS nch l=0.15 w=1 nf=1 m=1
M18 net3 EAO IBUF VSS nch l=0.15 w=1 nf=1 m=1
M19 net3 net3 VDD VDD pch l=0.15 w=1 nf=1 m=1
M2 VC net4 VDD VDD pch l=0.15 w=1 nf=1 m=1
M20 GATE net3 VDD VDD pch l=0.15 w=1 nf=1 m=1
M21 VSS IBUF GATE VDD pch l=0.15 w=1 nf=1 m=1
M22 VC VC net8 VSS nch l=0.15 w=1 nf=1 m=1
M23 net8 VC VSS VSS nch l=0.15 w=1 nf=1 m=1
M24 VT VB2 VSS VSS nch l=0.15 w=1 nf=1 m=1
M25 net0 VB1 net6 VDD pch l=0.15 w=1 nf=1 m=1
M26 net7 VB1 net11 VDD pch l=0.15 w=1 nf=1 m=1
M27 net6 net0 VDD VDD pch l=0.15 w=1 nf=1 m=1
M28 net11 net7 VDD VDD pch l=0.15 w=1 nf=1 m=1
M3 net7 VREF VT VSS nch l=0.15 w=1 nf=1 m=1
M4 net0 FB VT VSS nch l=0.15 w=1 nf=1 m=1
M5 net1 VX VSS VSS nch l=0.15 w=1 nf=1 m=1
M6 net9 VX VSS VSS nch l=0.15 w=1 nf=1 m=1
M7 VX VC net1 VSS nch l=0.15 w=1 nf=1 m=1
M8 EAO VC net9 VSS nch l=0.15 w=1 nf=1 m=1
M9 VX VB1 net5 VDD pch l=0.15 w=1 nf=1 m=1
MNP VIN GATE VOUT VSS nch l=0.15 w=1 nf=1 m=1
R1 FB VSS 1k
R2 VOUT FB 1k
R3 net10 VSS 1k
R4 net4 VSS 1k
RL VOUT VSS 1k
.ends dut
