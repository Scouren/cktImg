* official Analog Canvas netlist; PDK X cards rewritten by convert.py
.model nch nmos
.model pch pmos

.subckt dut VDD VSS Iout1 Iout2
M1 net2 net2 VSS VSS nch l=0.15 w=1 nf=1 m=1
M2 net0 net2 net1 VSS nch l=0.15 w=1 nf=1 m=4
M3 net2 net0 VDD VDD pch l=0.15 w=1 nf=1 m=1
M4 net0 net0 VDD VDD pch l=0.15 w=1 nf=1 m=1
M5 Iout2 net2 VSS VSS nch l=0.15 w=1 nf=1 m=1
M6 Iout1 net0 VDD VDD pch l=0.15 w=1 nf=1 m=1
R net1 VSS 1k
.ends dut
