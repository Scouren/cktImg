* official Analog Canvas netlist; PDK X cards rewritten by convert.py
.model nch nmos

.subckt dut VDD VSS Vb Vout
C1 net0 VSS 1p
C2 Vout net0 1p
I1 net0 VSS DC 1m
LP VDD Vout 1n
M1 Vout Vb net0 VSS nch l=0.15 w=1 nf=1 m=1
RP VDD Vout 1k
.ends dut
