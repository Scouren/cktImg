* official Analog Canvas netlist; PDK X cards rewritten by convert.py
.model nch nmos
.model pch pmos

.subckt dut VDD VSS VB1 VB3 Vref VB2 VIN VOUT
CL VOUT net8 1p
M1 net4 VB1 VDD VDD pch l=0.15 w=1 nf=1 m=1
M10 net2 net1 VSS VSS nch l=0.15 w=1 nf=1 m=1
M11 net7 FB net3 VSS nch l=0.15 w=1 nf=1 m=1
M12 net0 net0 VDD VDD pch l=0.15 w=1 nf=1 m=1
M13 net5 VB4 VSS VSS nch l=0.15 w=1 nf=1 m=1
M14 VB4 net0 VDD VDD pch l=0.15 w=1 nf=1 m=1
M15 VB4 VB4 net5 VSS nch l=0.15 w=1 nf=1 m=1
M2 net7 VB1 VDD VDD pch l=0.15 w=1 nf=1 m=1
M3 net4 Vref net3 VSS nch l=0.15 w=1 nf=1 m=1
M4 net3 VB2 VSS VSS nch l=0.15 w=1 nf=1 m=1
M5 net3 VB3 net4 VDD pch l=0.15 w=1 nf=1 m=1
M6 net1 VB3 net7 VDD pch l=0.15 w=1 nf=1 m=1
M7 net3 VB4 net6 VSS nch l=0.15 w=1 nf=1 m=1
M8 net1 VB4 net2 VSS nch l=0.15 w=1 nf=1 m=1
M9 net6 net1 VSS VSS nch l=0.15 w=1 nf=1 m=1
MNP VIN net3 VOUT VSS nch l=0.15 w=1 nf=1 m=1
R1 VOUT FB 1k
R2 FB VSS 1k
R3 net8 VSS 1k
R4 net0 VSS 1k
.ends dut
