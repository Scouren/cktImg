* official Analog Canvas netlist; PDK X cards rewritten by convert.py
.model nch nmos
.model pch pmos
.model qpnp pnp

.subckt opamp VDD VSS INN INP OUT VB1 VB2
M0 net4 VB4 net5 VSS nch l=0.15 w=1 nf=1 m=1
M1 OUT VB4 net0 VSS nch l=0.15 w=1 nf=1 m=1
M10 net7 net10 VSS VSS nch l=0.15 w=1 nf=1 m=1
M11 net5 VG VSS VSS nch l=0.15 w=1 nf=1 m=1
M12 net0 net10 VSS VSS nch l=0.15 w=1 nf=1 m=1
M13 net6 net4 VDD VDD pch l=0.15 w=1 nf=1 m=1
M14 net2 net4 VDD VDD pch l=0.15 w=1 nf=1 m=1
M15 VB3 net1 VDD VDD pch l=0.15 w=1 nf=1 m=1
M16 net1 net1 VDD VDD pch l=0.15 w=1 nf=1 m=1
M17 VB4 net1 VDD VDD pch l=0.15 w=1 nf=1 m=1
M18 net3 VB3 VSS VSS nch l=0.15 w=1 nf=1 m=1
M19 net1 VB3 VSS VSS nch l=0.15 w=1 nf=1 m=1
M2 net4 VB1 net6 VDD pch l=0.15 w=1 nf=1 m=1
M20 VB4 VB4 net8 VSS nch l=0.15 w=1 nf=1 m=1
M21 net8 VB4 VSS VSS nch l=0.15 w=1 nf=1 m=1
M3 OUT VB1 net2 VDD pch l=0.15 w=1 nf=1 m=1
M4 net9 VG VSS VSS nch l=0.15 w=1 nf=1 m=1
M5 net11 VB2 VDD VDD pch l=0.15 w=1 nf=1 m=1
M6 VG INP net11 VDD pch l=0.15 w=1 nf=1 m=1
M7 net10 INN net11 VDD pch l=0.15 w=1 nf=1 m=1
M8 VG VB4 net9 VSS nch l=0.15 w=1 nf=1 m=1
M9 net10 VB4 net7 VSS nch l=0.15 w=1 nf=1 m=1
R1 VB3 net3 1k
.ends opamp

.subckt dut VDD VSS Vout VB1 VB2
Q1 VSS VSS X qpnp m=1
Q2 VSS VSS net0 qpnp m=1
R1 Vout X 1k
R2 Vout Y 1k
R3 Y net0 1k
X1 VDD VSS Y X Vout VB1 VB2 opamp
.ends dut
