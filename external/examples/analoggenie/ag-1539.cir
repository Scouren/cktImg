* official Analog Canvas netlist; PDK X cards rewritten by convert.py
.model nch nmos
.model pch pmos
.model qnpn npn

.subckt dut VDD VSS Vout VB1
M10 Vout Z VSS VSS nch l=0.15 w=1 nf=1 m=1
M11 net4 VB2 VSS VSS nch l=0.15 w=1 nf=1 m=1
M12 net0 net0 VSS VSS nch l=0.15 w=1 nf=1 m=1
M13 net2 net2 VDD VDD pch l=0.15 w=1 nf=1 m=1
M14 net2 net0 VSS VSS nch l=0.15 w=1 nf=1 m=1
M15 VB2 net2 VDD VDD pch l=0.15 w=1 nf=1 m=1
M16 VB2 VB2 VSS VSS nch l=0.15 w=1 nf=1 m=1
M17 VB1 VB1 VDD VDD pch l=0.15 w=1 nf=1 m=1
M18 VB1 VB2 VSS VSS nch l=0.15 w=1 nf=1 m=1
M3 Z net3 VDD VDD pch l=0.15 w=1 nf=1 m=1
M4 net3 net3 VDD VDD pch l=0.15 w=1 nf=1 m=1
M5 net1 net1 VDD VDD pch l=0.15 w=1 nf=1 m=1
M6 Vout net1 VDD VDD pch l=0.15 w=1 nf=1 m=1
M7 Z Z VSS VSS nch l=0.15 w=1 nf=1 m=1
M8 net3 Y net4 VSS nch l=0.15 w=1 nf=1 m=1
M9 net1 X net4 VSS nch l=0.15 w=1 nf=1 m=1
Q1 X X VSS VSS qnpn m=1
Q2 Z Z VSS VSS qnpn m=1
R1 Vout X 1k
R2 Vout Y 1k
R3 Y Z 1k
R4 VDD net0 1k
.ends dut
