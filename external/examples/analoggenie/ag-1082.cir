* official Analog Canvas netlist; PDK X cards rewritten by convert.py
.model nch nmos

.subckt dut VDD VSS Vb Voutp Voutn
I1 X VSS DC 1m
M1 Voutp Vb X VSS nch l=0.15 w=1 nf=1 m=1
M2 Voutn X VSS VSS nch l=0.15 w=1 nf=1 m=1
R1 VDD Voutp 1k
R2 VDD Voutn 1k
RS net0 X 1k
VS net0 VSS DC 1 SIN(0 1 1k 0 0 0)
.ends dut
