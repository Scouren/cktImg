* official Analog Canvas netlist; PDK X cards rewritten by convert.py
.model nch nmos
.model pch pmos

.subckt dut VDD VSS Vinp Vinn VNB1 VPB1 vOUT
M1 net2 Vinp net3 VSS nch l=0.15 w=1 nf=1 m=1
M10 net3 VNB1 VSS VSS nch l=0.15 w=1 nf=1 m=1
M11 net5 net2 net3 VSS nch l=0.15 w=1 nf=1 m=1
M12 net1 net4 net3 VSS nch l=0.15 w=1 nf=1 m=1
M13 net5 VPB1 VDD VDD pch l=0.15 w=1 nf=1 m=1
M14 net1 VPB1 VDD VDD pch l=0.15 w=1 nf=1 m=1
M15 net8 net6 VDD VDD pch l=0.15 w=1 nf=1 m=1
M16 net8 VNB1 VSS VSS nch l=0.15 w=1 nf=1 m=1
M2 net4 Vinn net3 VSS nch l=0.15 w=1 nf=1 m=1
M3 net0 net5 net2 VSS nch l=0.15 w=1 nf=1 m=1
M4 vOUT net1 net4 VSS nch l=0.15 w=1 nf=1 m=1
M5 net0 net8 net7 VDD pch l=0.15 w=1 nf=1 m=1
M6 vOUT net8 net6 VDD pch l=0.15 w=1 nf=1 m=1
M7 net7 net0 VDD VDD pch l=0.15 w=1 nf=1 m=1
M8 net6 net0 VDD VDD pch l=0.15 w=1 nf=1 m=1
M9 net3 VNB1 VSS VSS nch l=0.15 w=1 nf=1 m=1
.ends dut
