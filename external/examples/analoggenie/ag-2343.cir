* official Analog Canvas netlist; PDK X cards rewritten by convert.py
.model nch nmos
.model pch pmos

.subckt bias VDD VSS VB1 VBN
M1 VBN VBN VSS VSS nch l=0.15 w=1 nf=1 m=1
M11 VBN VB1 VDD VDD pch l=0.15 w=1 nf=1 m=1
M12 VB1 VB1 VDD VDD pch l=0.15 w=1 nf=1 m=1
M22 VB1 net1 VSS VSS nch l=0.15 w=1 nf=1 m=1
M23 net1 net1 VSS VSS nch l=0.15 w=1 nf=1 m=1
M24 net0 net1 VSS VSS nch l=0.15 w=1 nf=1 m=1
R3 VDD net0 1k
R4 net0 net1 1k
RF VDD net1 1k
.ends bias

.subckt dut VDD VSS VREF VB4 IBUF VIN VOUT VB1
CL VOUT net5 1p
M10 EAO net0 VSS VSS nch l=0.15 w=1 nf=1 m=1
M13 net2 VB4 VDD VDD pch l=0.15 w=1 nf=1 m=1
M14 VX EAO net2 VDD pch l=0.15 w=1 nf=1 m=1
M15 VX VX VSS VSS nch l=0.15 w=1 nf=1 m=1
M16 GATE VX VSS VSS nch l=0.15 w=1 nf=1 m=1
M17 VDD net2 GATE VSS nch l=0.15 w=1 nf=1 m=1
M18 net3 EAO IBUF IBUF nch l=0.15 w=1 nf=1 m=1
M19 net3 net3 VDD VDD pch l=0.15 w=1 nf=1 m=1
M2 VX VBN VSS VSS nch l=0.15 w=1 nf=1 m=1
M20 GATE net3 VDD VDD pch l=0.15 w=1 nf=1 m=1
M21 VSS IBUF GATE VSS pch l=0.15 w=1 nf=1 m=1
M3 net4 VREF VX VSS nch l=0.15 w=1 nf=1 m=1
M4 net1 FB VX VSS nch l=0.15 w=1 nf=1 m=1
M5 net4 net4 VDD VDD pch l=0.15 w=1 nf=1 m=1
M6 net1 net1 VDD VDD pch l=0.15 w=1 nf=1 m=1
M7 EAO net4 VDD VDD pch l=0.15 w=1 nf=1 m=1
M8 net0 net1 VDD VDD pch l=0.15 w=1 nf=1 m=1
M9 net0 net0 VSS VSS nch l=0.15 w=1 nf=1 m=1
MNP VIN GATE VOUT VOUT nch l=0.15 w=1 nf=1 m=1
R1 FB VSS 1k
R2 VOUT FB 1k
RESR net5 VSS 1k
RL VOUT VSS 1k
X1 VDD VSS VB1 VBN bias
.ends dut
