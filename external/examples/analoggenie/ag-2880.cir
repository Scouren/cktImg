* official Analog Canvas netlist; PDK X cards rewritten by convert.py
.model nch nmos
.model pch pmos

.subckt opamp VDD VSS vn vcx vp vco
M10 VB3 VBP VDD VDD pch l=0.15 w=1 nf=1 m=1
M11 VB3 VB2 VSS VSS nch l=0.15 w=1 nf=1 m=1
M12 VBP VBP VDD VDD pch l=0.15 w=1 nf=1 m=1
M13 VBP VB3 VB2 VSS nch l=0.15 w=1 nf=1 m=1
M14 VB2 net2 VSS VSS nch l=0.15 w=1 nf=1 m=1
M15 net2 VBP VDD VDD pch l=0.15 w=1 nf=1 m=1
M16 net2 net2 VSS VSS nch l=0.15 w=1 nf=1 m=1
M17 VBN VB1 VDD VDD pch l=0.15 w=1 nf=1 m=1
M18 VBN VBN VSS VSS nch l=0.15 w=1 nf=1 m=1
M19 VB1 VB1 VDD VDD pch l=0.15 w=1 nf=1 m=1
M20 VB1 net3 VSS VSS nch l=0.15 w=1 nf=1 m=1
M21 net3 VBP VDD VDD pch l=0.15 w=1 nf=1 m=1
M22 net3 net3 VSS VSS nch l=0.15 w=1 nf=1 m=1
M3 net1 vcx VDD VDD pch l=0.15 w=1 nf=1 m=1
M4 net0 vcx VDD VDD pch l=0.15 w=1 nf=1 m=1
M5 vcx VBC net1 VDD pch l=0.15 w=1 nf=1 m=1
M6 vco VBC net0 VDD pch l=0.15 w=1 nf=1 m=1
M7 vcx vn net4 VSS nch l=0.15 w=1 nf=1 m=1
M8 vco vp net4 VSS nch l=0.15 w=1 nf=1 m=1
M9 net4 VBN VSS VSS nch l=0.15 w=1 nf=1 m=1
.ends opamp

.subckt dut VDD VSS vci phi1 phi2 vco
C1 vcx VSS 1p
C2 net0 vco 1p
M1 vci phi1 vcx VSS nch l=0.15 w=1 nf=1 m=1
M2 vcx phi2 net0 VSS nch l=0.15 w=1 nf=1 m=1
X1 VDD VSS net0 vcx VSS vco opamp
.ends dut
