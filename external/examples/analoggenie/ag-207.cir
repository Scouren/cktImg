* official Analog Canvas netlist; PDK X cards rewritten by convert.py
.model nch nmos

.subckt dut VDD VSS VB VOUT VIN
M1 VOUT VB VIN VSS nch l=0.15 w=1 nf=1 m=1
R1 VOUT VIN 1k
RD VDD VOUT 1k
.ends dut
