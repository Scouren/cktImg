* official Analog Canvas netlist; PDK X cards rewritten by convert.py
.model qnpn npn

.subckt dut VDD VSS
I1 VDD net1 DC 50uA
Q1 net1 net0 VSS VSS qnpn m=1
Q2 net0 net0 VSS VSS qnpn m=1
Q3 VDD net1 net0 VSS qnpn m=1
.ends dut
