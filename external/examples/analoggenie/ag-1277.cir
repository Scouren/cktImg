* official Analog Canvas netlist; PDK X cards rewritten by convert.py
.model nch nmos
.model pch pmos

.subckt dut VDD VSS VS5 VS1 VS2 VIN VS4 VS3 VP VB3 VREF
.model DIODE D(IS=1e-14 N=1)
CFLY VX1 VX2 1p
CO VP VN 1p
COP VP VSS 1p
D1 VN VX2 DIODE
L1 VX1 VX3 1n
M1 VX1 VS1 VIN VDD pch l=0.15 w=1 nf=1 m=1
M2 VX2 VS2 VIN VDD pch l=0.15 w=1 nf=1 m=1
M3 VX3 VS3 VP VDD pch l=0.15 w=1 nf=1 m=1
M4 VX3 VS4 VSS VSS nch l=0.15 w=1 nf=1 m=1
M5 net4 VS5 VIN VDD pch l=0.15 w=1 nf=1 m=1
MN1 net5 VFP1 net0 VSS nch l=0.15 w=1 nf=1 m=1
MN10 VBN VBN VSS VSS nch l=0.15 w=1 nf=1 m=1
MN11 VBP VB2 VSS VSS nch l=0.15 w=1 nf=1 m=1
MN12 net2 VB2 VSS VSS nch l=0.15 w=1 nf=1 m=1
MN2 VX3 VREF net0 VSS nch l=0.15 w=1 nf=1 m=1
MN3 net0 VBN VSS VSS nch l=0.15 w=1 nf=1 m=1
MN4 net6 net6 VSS VSS nch l=0.15 w=1 nf=1 m=1
MN5 VCTRL net6 VSS VSS nch l=0.15 w=1 nf=1 m=1
MN6 net1 net1 VSS VSS nch l=0.15 w=1 nf=1 m=1
MN7 net3 net1 VSS VSS nch l=0.15 w=1 nf=1 m=1
MN8 net1 VB3 VSS VSS nch l=0.15 w=1 nf=1 m=1
MN9 VB1 VBN VSS VSS nch l=0.15 w=1 nf=1 m=1
MP1 net5 net5 VDD VDD pch l=0.15 w=1 nf=1 m=1
MP10 VBP VBP VDD VDD pch l=0.15 w=1 nf=1 m=1
MP11 VB2 VBP VDD VDD pch l=0.15 w=1 nf=1 m=1
MP2 VX3 VX3 VDD VDD pch l=0.15 w=1 nf=1 m=1
MP3 net6 net5 VDD VDD pch l=0.15 w=1 nf=1 m=1
MP4 net3 net3 net4 VDD pch l=0.15 w=1 nf=1 m=1
MP5 VX1 net3 net4 VDD pch l=0.15 w=1 nf=1 m=1
MP6 net1 VCTRL net4 VDD pch l=0.15 w=1 nf=1 m=1
MP7 VCTRL VX3 VDD VDD pch l=0.15 w=1 nf=1 m=1
MP8 VB1 VB1 VDD VDD pch l=0.15 w=1 nf=1 m=1
MP9 VBN VBP VDD VDD pch l=0.15 w=1 nf=1 m=1
R1 VP VFP1 1k
R2 VFP1 VSS 1k
RBIAS VB2 net2 1k
.ends dut
