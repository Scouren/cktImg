* official Analog Canvas netlist; PDK X cards rewritten by convert.py
.model nch nmos
.model pch pmos

.subckt dut VDD VSS VIN VS5 VS1 VS2 VS3 VS4 VP VB3 VREF VB1 VB2
.model DIODE D(IS=1e-14 N=1)
CFLY VX1 VX2 1p
CO VP VN 1p
COP VP VSS 1p
D1 VN VX2 DIODE
L1 VX1 VX3 1n
M1 VX1 VS1 VIN VDD pch l=0.15 w=1 nf=1 m=1
M2 VX2 VS2 VIN VDD pch l=0.15 w=1 nf=1 m=1
M3 VP VS3 VX3 VDD pch l=0.15 w=1 nf=1 m=1
M4 VX3 VS4 VSS VSS nch l=0.15 w=1 nf=1 m=1
M5 VA VS5 VIN VDD pch l=0.15 w=1 nf=1 m=1
MN1 VX2 VX2 VSS VSS nch l=0.15 w=1 nf=1 m=1
MN10 net3 net3 VSS VSS nch l=0.15 w=1 nf=1 m=1
MN11 VB2 net3 VX2 VSS nch l=0.15 w=1 nf=1 m=1
MN12 VA VA VSS VSS nch l=0.15 w=1 nf=1 m=1
MN13 VX2 VA VSS VSS nch l=0.15 w=1 nf=1 m=1
MN2 net4 VX2 VSS VSS nch l=0.15 w=1 nf=1 m=1
MN3 VEA net2 VSS VSS nch l=0.15 w=1 nf=1 m=1
MN4 net2 net2 VSS VSS nch l=0.15 w=1 nf=1 m=1
MN5 net0 net5 VSS VSS nch l=0.15 w=1 nf=1 m=1
MN6 net5 net5 VSS VSS nch l=0.15 w=1 nf=1 m=1
MN7 net5 VB3 VSS VSS nch l=0.15 w=1 nf=1 m=1
MN8 VB1 VB1 VSS VSS nch l=0.15 w=1 nf=1 m=1
MN9 VB4 net3 VSS VSS nch l=0.15 w=1 nf=1 m=1
MP1 net4 net4 VDD VDD pch l=0.15 w=1 nf=1 m=1
MP10 VB4 VB4 VDD VDD pch l=0.15 w=1 nf=1 m=1
MP11 net3 VB2 VDD VDD pch l=0.15 w=1 nf=1 m=1
MP12 VB2 VB2 VDD VDD pch l=0.15 w=1 nf=1 m=1
MP13 VA VB2 VDD VDD pch l=0.15 w=1 nf=1 m=1
MP2 VEA net4 VDD VDD pch l=0.15 w=1 nf=1 m=1
MP3 net1 VB4 VDD VDD pch l=0.15 w=1 nf=1 m=1
MP4 VX2 VREF net1 VDD pch l=0.15 w=1 nf=1 m=1
MP5 net2 VFP1 net1 VDD pch l=0.15 w=1 nf=1 m=1
MP6 VX1 net0 VA VDD pch l=0.15 w=1 nf=1 m=1
MP7 net0 net0 VA VDD pch l=0.15 w=1 nf=1 m=1
MP8 net5 VEA VA VDD pch l=0.15 w=1 nf=1 m=1
MP9 VB1 VB4 VDD VDD pch l=0.15 w=1 nf=1 m=1
R1 VP VFP1 1k
R2 VFP1 VSS 1k
.ends dut
