* official Analog Canvas netlist; PDK X cards rewritten by convert.py
.model nch nmos

.subckt dut VDD VSS Vout
Iin VDD net2 DC 1m
M1 net0 net0 VSS VSS nch l=0.15 w=1 nf=1 m=1
M2 net1 net0 VSS VSS nch l=0.15 w=1 nf=1 m=1
M3 net2 net2 net0 VSS nch l=0.15 w=1 nf=1 m=1
M4 Vout net2 net1 VSS nch l=0.15 w=1 nf=1 m=1
.ends dut
