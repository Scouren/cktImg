* official Analog Canvas netlist; PDK X cards rewritten by convert.py
.model pch pmos
.model qnpn npn

.subckt dut VDD VSS VREF1
VB1 VDD net0 DC 1
M1 net1 net3 VDD VDD pch l=0.15 w=1 nf=1 m=1
M2 net4 net3 VDD VDD pch l=0.15 w=1 nf=1 m=1
M3 net3 net0 net1 VDD pch l=0.15 w=1 nf=1 m=1
M4 VREF1 net0 net4 VDD pch l=0.15 w=1 nf=1 m=1
Q1 net3 net2 net5 VSS qnpn m=1
Q2 net2 net2 VSS VSS qnpn m=1
R1 VREF1 net2 1k
R2 net5 VSS 1k
.ends dut
