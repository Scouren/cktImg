* official Analog Canvas netlist; PDK X cards rewritten by convert.py
.model qnpn npn

.subckt dut Vcc VSS RF LO IFp IFn
C1 RF net5 1p
C2 LO net6 1p
C3 net5 VSS 1p
C4 net6 VSS 1p
C5 net6 VSS 1p
C6 net0 VSS 1p
Cblock1 net2 net1 1p
Cblock2 net7 net4 1p
L1 RF net5 1n
L2 LO net6 1n
L3 net5 net6 1n
L4 net6 net0 1n
Q1 net7 net5 VSS VSS qnpn m=1
Q2 net2 net0 VSS VSS qnpn m=1
Q3 IFn net4 net3 VSS qnpn m=1
Q4 IFp net1 net3 VSS qnpn m=1
Rc1 Vcc IFp 1k
Rc2 Vcc IFn 1k
Re net3 VSS 1k
RL1 Vcc net7 1k
RL2 Vcc net2 1k
.ends dut
