* official Analog Canvas netlist; PDK X cards rewritten by convert.py
.model nch nmos

.subckt dut VDD VSS vi+ Iout1 VC vi- Iout2
I1 VDD net1 DC 1m
I2 net4 VSS DC 1m
I3 VDD net5 DC 1m
I4 net3 VSS DC 1m
M1 net1 vi+ net0 VSS nch l=0.15 w=1 nf=1 m=1
M2 net5 vi- net2 VSS nch l=0.15 w=1 nf=1 m=1
M3 net0 net4 VSS VSS nch l=0.15 w=1 nf=1 m=1
M4 net2 net3 VSS VSS nch l=0.15 w=1 nf=1 m=1
M5 VDD net1 net4 VSS nch l=0.15 w=1 nf=1 m=1
M6 VDD net5 net3 VSS nch l=0.15 w=1 nf=1 m=1
M7 Iout1 net4 VSS VSS nch l=0.15 w=1 nf=1 m=1
M8 Iout2 net3 VSS VSS nch l=0.15 w=1 nf=1 m=1
M9 net2 VC net0 VSS nch l=0.15 w=1 nf=1 m=1
.ends dut
