* official Analog Canvas netlist; PDK X cards rewritten by convert.py
.model nch nmos
.model pch pmos

.subckt dut VDD VSS AC Out
C1 net3 net0 1pF
I1 VDD net2 DC 10uA
I2 VDD net1 DC 10uA
I3 VDD net5 DC 10uA
I4 VDD net3 DC 10uA
M1 VSS AC net2 VDD pch l=0.35 w=10 nf=1 m=1
M2 net0 net2 net1 VDD pch l=0.35 w=10 nf=1 m=1
M3 net4 net5 net1 VDD pch l=0.35 w=10 nf=1 m=1
M4 net0 net4 VSS VSS nch l=2 w=5 nf=1 m=1
M5 net4 net4 VSS VSS nch l=2 w=5 nf=1 m=1
M6 VSS Out net5 VDD pch l=0.35 w=10 nf=1 m=1
M7 net3 net0 VSS VSS nch l=2 w=5 nf=1 m=2
M8 VDD net3 Out VSS nch l=0.35 w=10 nf=1 m=1
M9 Out net0 VSS VSS nch l=0.35 w=10 nf=1 m=1
.ends dut
