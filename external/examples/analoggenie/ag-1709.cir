* official Analog Canvas netlist; PDK X cards rewritten by convert.py
.model nch nmos
.model pch pmos
.model qpnp pnp

.subckt opamp VDD VSS INN INP OUT
M1 VN net1 VDD VDD pch l=0.15 w=1 nf=1 m=1
M10 VB3 VB1 VDD VDD pch l=0.15 w=1 nf=1 m=1
M11 VB1 VB1 VDD VDD pch l=0.15 w=1 nf=1 m=1
M12 VB2 VB2 VDD VDD pch l=0.15 w=1 nf=1 m=1
M13 net2 VB2 VDD VDD pch l=0.15 w=1 nf=1 m=1
M14 VB3 VB3 VSS VSS nch l=0.15 w=1 nf=1 m=1
M15 VB1 net0 VSS VSS nch l=0.15 w=1 nf=1 m=1
M16 VB2 net2 net0 VSS nch l=0.15 w=1 nf=1 m=1
M17 net2 net0 VSS VSS nch l=0.15 w=1 nf=1 m=1
M2 net1 net1 VDD VDD pch l=0.15 w=1 nf=1 m=1
M3 net4 net4 VDD VDD pch l=0.15 w=1 nf=1 m=1
M4 OUT net4 VDD VDD pch l=0.15 w=1 nf=1 m=1
M5 net1 INN net3 VSS nch l=0.15 w=1 nf=1 m=1
M6 net4 INP net3 VSS nch l=0.15 w=1 nf=1 m=1
M7 net3 VB3 VSS VSS nch l=0.15 w=1 nf=1 m=1
M8 VN VN VSS VSS nch l=0.15 w=1 nf=1 m=1
M9 OUT VN VSS VSS nch l=0.15 w=1 nf=1 m=1
R4 net0 VSS 1k
.ends opamp

.subckt dut VSS Vout
Q1 VSS VSS net1 qpnp m=1
Q2 net1 net1 X qpnp m=1
Q3 VSS VSS net0 qpnp m=1
Q4 net0 net0 net2 qpnp m=1
R1 Vout X 1k
R2 Vout Y 1k
R3 Y net2 1k
X1 VDD VSS Y X Vout opamp
.ends dut
