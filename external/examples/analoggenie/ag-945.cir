* official Analog Canvas netlist; PDK X cards rewritten by convert.py
.model nch nmos
.model pch pmos

.subckt dut VDD VSS Iout
.model DIODE D(IS=1e-14 N=1)
D net3 VSS DIODE
IPTAT VDD net4 DC 1m
M1 net4 net1 net3 VSS nch l=0.15 w=1 nf=1 m=1
M2 net1 net1 net2 VSS nch l=0.15 w=1 nf=1 m=1
M3 net0 net4 VSS VSS nch l=0.15 w=1 nf=1 m=1
M4 net0 net0 VDD VDD pch l=0.15 w=1 nf=1 m=1
M5 net1 net0 VDD VDD pch l=0.15 w=1 nf=1 m=1
M6 Iout net0 VDD VDD pch l=0.15 w=1 nf=1 m=1
R net2 VSS 1k
.ends dut
