* official Analog Canvas netlist; PDK X cards rewritten by convert.py
.model nch nmos
.model pch pmos

.subckt dut VDD VSS vci phi1 phi2 vco
C1 net5 net0 1p
C2 net3 vco 1p
M1 vci phi1 net5 VSS nch l=0.15 w=1 nf=1 m=1
M10 net1 net1 net2 VDD pch l=0.15 w=1 nf=1 m=1
M11 VB1 net1 VDD VDD pch l=0.15 w=1 nf=1 m=1
M12 VB1 VB1 VSS VSS nch l=0.15 w=1 nf=1 m=1
M13 VX VX VDD VDD pch l=0.15 w=1 nf=1 m=1
M14 VX VB1 VSS VSS nch l=0.15 w=1 nf=1 m=1
M2 net5 phi2 VSS VSS nch l=0.15 w=1 nf=1 m=1
M3 net0 phi1 VSS VSS nch l=0.15 w=1 nf=1 m=1
M4 net0 phi2 net3 VSS nch l=0.15 w=1 nf=1 m=1
M5 VX net3 net4 VSS nch l=0.15 w=1 nf=1 m=1
M6 vco VSS net4 VSS nch l=0.15 w=1 nf=1 m=1
M7 net4 VB1 VSS VSS nch l=0.15 w=1 nf=1 m=1
M8 VX VX VDD VDD pch l=0.15 w=1 nf=1 m=1
M9 vco VX VDD VDD pch l=0.15 w=1 nf=1 m=1
R1 VDD net2 1k
R2 net1 VSS 1k
.ends dut
