* official Analog Canvas netlist; PDK X cards rewritten by convert.py
.model nch nmos
.model pch pmos

.subckt dut VDD VSS Vin Vout
M1 net1 Vin net0 VSS nch l=0.15 w=1 nf=1 m=1
M2 Vout net1 VDD VDD pch l=0.15 w=1 nf=1 m=1
RD1 VDD net1 1k
RD2 Vout VSS 1k
RF net0 Vout 1k
RS net0 VSS 1k
.ends dut
