* official Analog Canvas netlist; PDK X cards rewritten by convert.py
.model nch nmos

.subckt dut VDD VSS
I2 VDD net1 DC 50uA
M1 net1 net1 net0 VSS nch l=0.15 w=1 nf=1 m=1
M2 net0 net1 VSS VSS nch l=0.15 w=1 nf=1 m=1
M3 VDD net1 net2 VSS nch l=0.15 w=1 nf=1 m=1
M4 net2 net1 VSS VSS nch l=0.15 w=1 nf=1 m=1
.ends dut
