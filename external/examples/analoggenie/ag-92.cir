* official Analog Canvas netlist; PDK X cards rewritten by convert.py
.model nch nmos
.model pch pmos

.subckt dut VDD VSS Vin1 Vin2 Vb1 Vb Vout1 Vout2
M1 X Vin1 net0 VSS nch l=0.15 w=1 nf=1 m=1
M2 Y Vin2 net0 VSS nch l=0.15 w=1 nf=1 m=1
M3 Vout1 Vb1 X VSS nch l=0.15 w=1 nf=1 m=1
M4 Vout2 Vb1 Y VSS nch l=0.15 w=1 nf=1 m=1
M5 Vout1 Vout1 VDD VDD pch l=0.15 w=1 nf=1 m=1
M6 Vout2 Vout2 VDD VDD pch l=0.15 w=1 nf=1 m=1
M7 net0 Vb VSS VSS nch l=0.15 w=1 nf=1 m=1
R1 X Y 1k
.ends dut
