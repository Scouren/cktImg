* official Analog Canvas netlist; PDK X cards rewritten by convert.py
.model nch nmos
.model pch pmos

.subckt dut VDD VSS VIN VOUT VERR
M1 VZ VEAOUT VIN VDD pch l=0.15 w=1 nf=1 m=1
M10 VEAOUT VC VY VSS nch l=0.15 w=1 nf=1 m=1
M11 VY VB2 VSS VSS nch l=0.15 w=1 nf=1 m=1
M12 VX VB1 VDD VDD pch l=0.15 w=1 nf=1 m=1
M13 VZ VREF VX VDD pch l=0.15 w=1 nf=1 m=1
M14 VY VEAOUT VX VDD pch l=0.15 w=1 nf=1 m=1
M15 VC net1 VDD VDD pch l=0.15 w=1 nf=1 m=1
M16 VC VC VEAOUT VSS nch l=0.15 w=1 nf=1 m=1
M17 VEAOUT VC VSS VSS nch l=0.15 w=1 nf=1 m=1
M18 net1 net1 VDD VDD pch l=0.15 w=1 nf=1 m=1
M19 net1 net0 VSS VSS nch l=0.15 w=1 nf=1 m=1
M2 VX VX VZ VDD pch l=0.15 w=1 nf=1 m=1
M20 net0 net1 VDD VDD pch l=0.15 w=1 nf=1 m=1
M21 net0 net0 VSS VSS nch l=0.15 w=1 nf=1 m=1
M3 VX nb VSS VSS nch l=0.15 w=1 nf=1 m=1
M4 VW VD VDD VDD pch l=0.15 w=1 nf=1 m=1
M5 VD VB3 VW VDD pch l=0.15 w=1 nf=1 m=1
M6 VD VC VZ VSS nch l=0.15 w=1 nf=1 m=1
M7 VZ VB2 VSS VSS nch l=0.15 w=1 nf=1 m=1
M8 net2 VD VDD VDD pch l=0.15 w=1 nf=1 m=1
M9 VEAOUT VB3 net2 VDD pch l=0.15 w=1 nf=1 m=1
MBIAS VERR nb VSS VSS nch l=0.15 w=1 nf=1 m=1
MCHG VY pb VIN VDD pch l=0.15 w=1 nf=1 m=1
MCTRL VERR VX VOUT VDD pch l=0.15 w=1 nf=1 m=1
MGEN VW VW VSS VSS nch l=0.15 w=1 nf=1 m=1
MINJ VERR VW VSS VSS nch l=0.15 w=1 nf=1 m=1
MRES VOUT VERR VIN VDD pch l=0.15 w=1 nf=1 m=1
MSEN VW VEAOUT VY VDD pch l=0.15 w=1 nf=1 m=1
.ends dut
