* official Analog Canvas netlist; PDK X cards rewritten by convert.py
.model nch nmos
.model pch pmos

.subckt dut VDD VSS AC Out
C1 net4 net0 1pF
I2 VDD net3 DC 10uA
I4 VDD net4 DC 10uA
M1 net0 VSS net3 VDD pch l=0.15 w=1 nf=1 m=1
M2 net2 net1 net3 VDD pch l=0.15 w=1 nf=1 m=1
M3 net0 net2 VSS VSS nch l=0.15 w=1 nf=1 m=1
M4 net2 net2 VSS VSS nch l=0.15 w=1 nf=1 m=1
M5 net4 net0 VSS VSS nch l=0.15 w=1 nf=1 m=2
M6 VDD net4 Out VSS nch l=0.15 w=1 nf=1 m=1
R1 net1 Out 20kΩ
R2 net1 AC 20kΩ
.ends dut
