* official Analog Canvas netlist; PDK X cards rewritten by convert.py
.model nch nmos
.model pch pmos

.subckt dut VDD VSS VIN VCONT2 VCONT3 VCONT4 VCONT5 VP VCONT1 VB4 VB1 VB2 VB3
.model DIODE D(IS=1e-14 N=1)
CFLY VX1 VX2 1p
CO VP VN 1p
COP VP VSS 1p
D1 VN VX2 DIODE
L1 VX1 VX3 1n
M1 VX1 VCONT2 VIN VDD pch l=0.15 w=1 nf=1 m=1
M10 VX VX VSS VSS nch l=0.15 w=1 nf=1 m=1
M11 VX VB4 VSS VSS nch l=0.15 w=1 nf=1 m=1
M12 net4 VB1 VDD VDD pch l=0.15 w=1 nf=1 m=1
M13 net2 VB1 VDD VDD pch l=0.15 w=1 nf=1 m=1
M14 VBN VB2 net4 VDD pch l=0.15 w=1 nf=1 m=1
M15 VCTRL VB2 net2 VDD pch l=0.15 w=1 nf=1 m=1
M16 net4 VFP1 net3 VSS nch l=0.15 w=1 nf=1 m=1
M17 net2 VREF net3 VSS nch l=0.15 w=1 nf=1 m=1
M18 net3 VTN VSS VSS nch l=0.15 w=1 nf=1 m=1
M19 VBN VCN VX VSS nch l=0.15 w=1 nf=1 m=1
M2 VX2 VCONT3 VIN VDD pch l=0.15 w=1 nf=1 m=1
M20 VCTRL VCN net1 VSS nch l=0.15 w=1 nf=1 m=1
M21 VX VBN VSS VSS nch l=0.15 w=1 nf=1 m=1
M22 net1 VBN VSS VSS nch l=0.15 w=1 nf=1 m=1
M23 VBP VBP VDD VDD pch l=0.15 w=1 nf=1 m=1
M24 VBN VBP VDD VDD pch l=0.15 w=1 nf=1 m=1
M25 VBP VBN VB3 VSS nch l=0.15 w=1 nf=1 m=1
M26 VBN VB3 VSS VSS nch l=0.15 w=1 nf=1 m=1
M27 VCN VBP VDD VDD pch l=0.15 w=1 nf=1 m=1
M28 VCN VCN VTN VSS nch l=0.15 w=1 nf=1 m=1
M29 VTN VTN VSS VSS nch l=0.15 w=1 nf=1 m=1
M3 VP VCONT5 VX3 VDD pch l=0.15 w=1 nf=1 m=1
M4 VX3 VCONT4 VSS VSS nch l=0.15 w=1 nf=1 m=1
M5 net0 VCONT1 VIN VDD pch l=0.15 w=1 nf=1 m=1
M6 VX1 net5 net0 VDD pch l=0.15 w=1 nf=1 m=1
M7 net5 net5 net0 VDD pch l=0.15 w=1 nf=1 m=1
M8 VX VCTRL net0 VDD pch l=0.15 w=1 nf=1 m=1
M9 net5 VX VSS VSS nch l=0.15 w=1 nf=1 m=1
R1 VP VFP1 1k
R2 VFP1 VSS 1k
RBIAS VB3 VSS 1k
.ends dut
