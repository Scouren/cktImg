* official Analog Canvas netlist; PDK X cards rewritten by convert.py
.model nch nmos
.model pch pmos
.model qpnp pnp

.subckt dut VDD VSS Vout VB2 VB1 VB3
M1 X VG VDD VDD pch l=0.15 w=1 nf=1 m=1
M10 VE4 VB2 net0 VDD pch l=0.15 w=1 nf=1 m=1
M11 VG VB2 net7 VDD pch l=0.15 w=1 nf=1 m=1
M12 VE4 VB4 net3 VSS nch l=0.15 w=1 nf=1 m=1
M13 VG VB4 net6 VSS nch l=0.15 w=1 nf=1 m=1
M14 net3 VB5 VSS VSS nch l=0.15 w=1 nf=1 m=1
M15 net6 VB5 VSS VSS nch l=0.15 w=1 nf=1 m=1
M16 VB4 net4 VDD VDD pch l=0.15 w=1 nf=1 m=1
M17 VB4 VB4 VB5 VSS nch l=0.15 w=1 nf=1 m=1
M18 VB5 VB5 VSS VSS nch l=0.15 w=1 nf=1 m=1
M19 net4 net4 VDD VDD pch l=0.15 w=1 nf=1 m=1
M2 Vout VG VDD VDD pch l=0.15 w=1 nf=1 m=1
M20 net4 VB3 net2 VSS nch l=0.15 w=1 nf=1 m=1
M21 net2 net1 VSS VSS nch l=0.15 w=1 nf=1 m=1
M22 net1 net4 VDD VDD pch l=0.15 w=1 nf=1 m=1
M23 net1 net1 VSS VSS nch l=0.15 w=1 nf=1 m=1
M24 VB3 net4 VDD VDD pch l=0.15 w=1 nf=1 m=1
M25 VB3 VB3 VSS VSS nch l=0.15 w=1 nf=1 m=1
M3 net5 VG VDD VDD pch l=0.15 w=1 nf=1 m=1
M4 VE3 VG VDD VDD pch l=0.15 w=1 nf=1 m=1
M5 VE3 VB1 VDD VDD pch l=0.15 w=1 nf=1 m=1
M6 net3 Y VE3 VDD pch l=0.15 w=1 nf=1 m=1
M7 net6 X VE3 VDD pch l=0.15 w=1 nf=1 m=1
M8 net0 VE4 VDD VDD pch l=0.15 w=1 nf=1 m=1
M9 net7 VE4 VDD VDD pch l=0.15 w=1 nf=1 m=1
Q1 VSS VSS net5 qpnp m=1
Q2 VSS net5 X qpnp m=1
Q3 VSS VSS VE3 qpnp m=1
Q4 VSS VE3 VE4 qpnp m=1
R1 Y VE4 1k
R2 Vout Y 1k
.ends dut
