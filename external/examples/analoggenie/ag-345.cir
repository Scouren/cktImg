* official Analog Canvas netlist; PDK X cards rewritten by convert.py
.model nch nmos

.subckt dut VDD VSS Vout
CF X Vout 1p
I1 VDD Vout DC 1m
Iin X VSS DC 1m
Mout Vout X VSS VSS nch l=0.15 w=1 nf=1 m=1
RO Vout VSS 1k
.ends dut
