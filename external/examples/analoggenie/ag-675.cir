* official Analog Canvas netlist; PDK X cards rewritten by convert.py
.model nch nmos
.model pch pmos

.subckt dut VDD VSS vin1 vin2 vout
Ibias net1 VSS DC 1m
M1 net0 vin1 net1 VSS nch l=0.15 w=1 nf=1 m=1
M2 vout vin2 net1 VSS nch l=0.15 w=1 nf=1 m=1
M3 net0 net0 VDD VDD pch l=0.15 w=1 nf=1 m=1
M4 vout net0 VDD VDD pch l=0.15 w=1 nf=1 m=1
.ends dut
