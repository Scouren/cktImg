* official Analog Canvas netlist; PDK X cards rewritten by convert.py
.model nch nmos
.model pch pmos

.subckt dut VDD VSS CK A B Q
M1 net3 B VDD VDD pch l=0.15 w=1 nf=1 m=1
M10 net3 A VDD VDD pch l=0.15 w=1 nf=1 m=1
M2 net3 CK net4 VSS nch l=0.15 w=1 nf=1 m=1
M3 net4 B net0 VSS nch l=0.15 w=1 nf=1 m=1
M4 net1 net3 VDD VDD pch l=0.15 w=1 nf=1 m=1
M5 net2 CK net1 VDD pch l=0.15 w=1 nf=1 m=1
M6 net2 net4 VSS VSS nch l=0.15 w=1 nf=1 m=1
M7 Q net1 VDD VDD pch l=0.15 w=1 nf=1 m=1
M8 Q net2 VSS VSS nch l=0.15 w=1 nf=1 m=1
M9 net0 A VSS VSS nch l=0.15 w=1 nf=1 m=1
.ends dut
