* official Analog Canvas netlist; PDK X cards rewritten by convert.py
.model nch nmos
.model pch pmos
.model qnpn npn

.subckt dut VDD VSS Vout
M1 net4 net4 VDD VDD pch l=0.15 w=1 nf=1 m=1
M10 VB1 net0 VDD VDD pch l=0.15 w=1 nf=1 m=1
M11 net0 net0 net3 VDD pch l=0.15 w=1 nf=1 m=1
M12 VB1 VB1 VSS VSS nch l=0.15 w=1 nf=1 m=1
M2 net1 net1 VDD VDD pch l=0.15 w=1 nf=1 m=1
M3 net1 Y net2 VSS nch l=0.15 w=1 nf=1 m=1
M4 net4 X net2 VSS nch l=0.15 w=1 nf=1 m=1
M5 net2 VB1 VSS VSS nch l=0.15 w=1 nf=1 m=1
M6 Vout net4 VDD VDD pch l=0.15 w=1 nf=1 m=1
M7 Z net1 VDD VDD pch l=0.15 w=1 nf=1 m=1
M8 Vout Z VSS VSS nch l=0.15 w=1 nf=1 m=1
M9 Z Z VSS VSS nch l=0.15 w=1 nf=1 m=1
Q1 X X VSS VSS qnpn m=1
Q2 Z Z VSS VSS qnpn m=1
R1 Vout X 1k
R2 Vout Y 1k
R3 Y Z 1k
R4 VDD net3 1k
R5 net0 VSS 1k
.ends dut
