* official Analog Canvas netlist; PDK X cards rewritten by convert.py
.model qnpn npn

.subckt dut VCC VSS Io
IB VCC net2 DC 1m
Ii net1 VSS DC 1m
Q1 net2 net1 VSS VSS qnpn m=1
Q2 VCC net2 net1 VSS qnpn m=1
Q3 Io net2 net0 VSS qnpn m=1
Q4 net0 net0 VSS VSS qnpn m=1
.ends dut
