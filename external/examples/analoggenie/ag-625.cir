* official Analog Canvas netlist; PDK X cards rewritten by convert.py
.model qnpn npn

.subckt dut Vcc SUB Vref
I1 Vcc Vref DC 150uA
Q1 net0 net0 SUB SUB qnpn m=1
Q2 net2 net0 net1 SUB qnpn m=10
Q3 Vref net2 SUB SUB qnpn m=1
R1 Vref net0 25kΩ
R2 net1 SUB 2.25kΩ
R3 Vref net2 25kΩ
.ends dut
