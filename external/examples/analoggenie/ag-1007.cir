* official Analog Canvas netlist; PDK X cards rewritten by convert.py
.model nch nmos
.model pch pmos

.subckt opamp_differential VDD VSS VIP VIN VOP VON params: gain=1e6 vocm=0
VCM ncm 0 DC {vocm}
EPLUS VOP ncm VIP VIN {gain/2}
EMINUS VON ncm VIN VIP {gain/2}
.ends opamp_differential

.subckt dut VDD VSS VPB1 VPB2 vIN+ vIN- VNB1 vOUT- vOUT+ VNB2
C1 vOUT- VSS 1p
C2 vOUT+ VSS 1p
M1 N1 vIN+ net1 VSS nch l=0.15 w=1 nf=1 m=1
M10 N1 VPB1 VDD VDD pch l=0.15 w=1 nf=1 m=1
M11 net2 VPB1 VDD VDD pch l=0.15 w=1 nf=1 m=1
M12 N5 VPB2 N1 VDD pch l=0.15 w=1 nf=1 m=1
M13 N4 VPB2 net2 VDD pch l=0.15 w=1 nf=1 m=1
M14 N4 VNB2 net8 VSS nch l=0.15 w=1 nf=1 m=1
M15 vOUT- net4 net9 VSS nch l=0.15 w=1 nf=1 m=1
M16 net8 N4 VSS VSS nch l=0.15 w=1 nf=1 m=1
M17 net9 N4 VSS VSS nch l=0.15 w=1 nf=1 m=1
M18 vOUT+ net3 net7 VSS nch l=0.15 w=1 nf=1 m=1
M19 N5 VNB2 net0 VSS nch l=0.15 w=1 nf=1 m=1
M2 N2 vIN+ net1 VSS nch l=0.15 w=1 nf=1 m=1
M20 net7 N5 VSS VSS nch l=0.15 w=1 nf=1 m=1
M21 net0 N5 VSS VSS nch l=0.15 w=1 nf=1 m=1
M3 net2 vIN- net1 VSS nch l=0.15 w=1 nf=1 m=1
M4 N3 vIN- net1 VSS nch l=0.15 w=1 nf=1 m=1
M5 net1 VNB1 VSS VSS nch l=0.15 w=1 nf=1 m=1
M6 N2 VPB1 VDD VDD pch l=0.15 w=1 nf=1 m=1
M7 N3 VPB1 VDD VDD pch l=0.15 w=1 nf=1 m=1
M8 vOUT- net5 N2 VDD pch l=0.15 w=1 nf=1 m=1
M9 vOUT+ net6 N3 VDD pch l=0.15 w=1 nf=1 m=1
X1 VDD VSS N2 N3 net6 net5 opamp_differential gain=1e6
X2 VDD VSS net9 net7 net3 net4 opamp_differential gain=1e6
.ends dut
