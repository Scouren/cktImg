* official Analog Canvas netlist; PDK X cards rewritten by convert.py
.model nch nmos
.model pch pmos

.subckt dut VDD VSS vci phi1 phi2 vco VB1
C1 net2 net3 1p
C2 net0 vco 1p
M1 vci phi1 net2 VSS nch l=0.15 w=1 nf=1 m=1
M10 VX VX VDD VDD pch l=0.15 w=1 nf=1 m=1
M11 VBN VX VDD VDD pch l=0.15 w=1 nf=1 m=1
M12 VX VY VSS VSS nch l=0.15 w=1 nf=1 m=1
M13 VBN VBN VSS VSS nch l=0.15 w=1 nf=1 m=1
M14 VB1 VB1 VDD VDD pch l=0.15 w=1 nf=1 m=1
M15 VY VB1 VDD VDD pch l=0.15 w=1 nf=1 m=1
M16 VB1 VY net1 VSS nch l=0.15 w=1 nf=1 m=1
M17 VY VY VSS VSS nch l=0.15 w=1 nf=1 m=1
M2 net2 phi2 VSS VSS nch l=0.15 w=1 nf=1 m=1
M3 net3 phi1 VSS VSS nch l=0.15 w=1 nf=1 m=1
M4 net3 phi2 net0 VSS nch l=0.15 w=1 nf=1 m=1
M5 VX net0 net4 VSS nch l=0.15 w=1 nf=1 m=1
M6 vco VSS net4 VSS nch l=0.15 w=1 nf=1 m=1
M7 VX VX VDD VDD pch l=0.15 w=1 nf=1 m=1
M8 vco VX VDD VDD pch l=0.15 w=1 nf=1 m=1
M9 net4 VBN VSS VSS nch l=0.15 w=1 nf=1 m=1
R1 net1 VSS 1k
.ends dut
