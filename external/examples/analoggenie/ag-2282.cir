* official Analog Canvas netlist; PDK X cards rewritten by convert.py
.model nch nmos
.model pch pmos

.subckt dut VDD VSS VB3 VREF VB2 VB4 IBUF VIN VOUT
CL VOUT net4 1p
M1 net5 net5 VDD VDD pch l=0.15 w=1 nf=1 m=1
M10 net8 VB2 net9 VDD pch l=0.15 w=1 nf=1 m=1
M11 net2 net8 VDD VDD pch l=0.15 w=1 nf=1 m=1
M12 net9 net8 VDD VDD pch l=0.15 w=1 nf=1 m=1
M13 net6 VB4 VDD VDD pch l=0.15 w=1 nf=1 m=1
M14 VX EAO net6 VDD pch l=0.15 w=1 nf=1 m=1
M15 VX VX VSS VSS nch l=0.15 w=1 nf=1 m=1
M16 GATE VX VSS VSS nch l=0.15 w=1 nf=1 m=1
M17 VDD net6 GATE VSS nch l=0.15 w=1 nf=1 m=1
M18 net7 EAO IBUF VSS nch l=0.15 w=1 nf=1 m=1
M19 net7 net7 VDD VDD pch l=0.15 w=1 nf=1 m=1
M2 EAO VB3 VDD VDD pch l=0.15 w=1 nf=1 m=1
M20 GATE net7 VDD VDD pch l=0.15 w=1 nf=1 m=1
M21 VSS IBUF GATE VDD pch l=0.15 w=1 nf=1 m=1
M22 VB1 net5 VDD VDD pch l=0.15 w=1 nf=1 m=1
M23 VB1 VB1 net3 VSS nch l=0.15 w=1 nf=1 m=1
M24 net3 VB1 VSS VSS nch l=0.15 w=1 nf=1 m=1
M25 EAO VB1 net10 VSS nch l=0.15 w=1 nf=1 m=1
M26 net10 net12 VSS VSS nch l=0.15 w=1 nf=1 m=1
M27 net8 VB1 net0 VSS nch l=0.15 w=1 nf=1 m=1
M28 net0 VX VSS VSS nch l=0.15 w=1 nf=1 m=1
M3 VX VREF EAO VDD pch l=0.15 w=1 nf=1 m=1
M4 net12 FB EAO VDD pch l=0.15 w=1 nf=1 m=1
M5 net1 VX VSS VSS nch l=0.15 w=1 nf=1 m=1
M6 net11 net12 VSS VSS nch l=0.15 w=1 nf=1 m=1
M7 VX VB1 net1 VSS nch l=0.15 w=1 nf=1 m=1
M8 net12 VB1 net11 VSS nch l=0.15 w=1 nf=1 m=1
M9 EAO VB2 net2 VDD pch l=0.15 w=1 nf=1 m=1
MNP VIN GATE VOUT VSS nch l=0.15 w=1 nf=1 m=1
R1 FB VSS 1k
R2 VOUT FB 1k
R3 net5 VSS 1k
R4 net4 VSS 1k
RL VOUT VSS 1k
.ends dut
