* official Analog Canvas netlist; PDK X cards rewritten by convert.py
.model nch nmos
.model pch pmos
.model qpnp pnp

.subckt dut VDD VSS Vout
M1 net1 VB1 VDD VDD pch l=0.15 w=1 nf=1 m=1
M10 VE VB2 VSS VSS nch l=0.15 w=1 nf=1 m=1
M11 net6 VB2 VSS VSS nch l=0.15 w=1 nf=1 m=1
M12 net3 net3 VDD VDD pch l=0.15 w=1 nf=1 m=1
M13 VB4 net3 VDD VDD pch l=0.15 w=1 nf=1 m=1
M14 VB4 VB4 net2 VSS nch l=0.15 w=1 nf=1 m=1
M15 net2 VB4 VSS VSS nch l=0.15 w=1 nf=1 m=1
M2 VE Y net1 VDD pch l=0.15 w=1 nf=1 m=1
M3 net6 X net1 VDD pch l=0.15 w=1 nf=1 m=1
M4 net4 VP VDD VDD pch l=0.15 w=1 nf=1 m=1
M5 Y VP VDD VDD pch l=0.15 w=1 nf=1 m=1
M6 VP VB3 net4 VDD pch l=0.15 w=1 nf=1 m=1
M7 Vout VB3 Y VDD pch l=0.15 w=1 nf=1 m=1
M8 VP VB4 VE VSS nch l=0.15 w=1 nf=1 m=1
M9 Vout VB4 net6 VSS nch l=0.15 w=1 nf=1 m=1
Q1 VSS VSS net0 qpnp m=1
Q2 net0 net0 net5 qpnp m=1
Q3 VSS VSS VE qpnp m=1
Q4 VE VE Y qpnp m=1
R1 Vout X 1k
R2 Vout Y 1k
R3 X net5 1k
R4 net3 VSS 1k
.ends dut
