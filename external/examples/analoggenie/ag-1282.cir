* official Analog Canvas netlist; PDK X cards rewritten by convert.py
.model nch nmos
.model pch pmos

.subckt dut VDD VSS VIN VCONT1 VCONT2 VCONT3 VB3 VCONT4 VCONT5 VP VB1 VB2
.model DIODE D(IS=1e-14 N=1)
CFLY VX1 VX2 1p
CO VP VN 1p
COP VP VSS 1p
D1 VN VX2 DIODE
L1 VX1 VX3 1n
M1 VX1 VCONT2 VIN VDD pch l=0.15 w=1 nf=1 m=1
M2 VX2 VCONT3 VIN VDD pch l=0.15 w=1 nf=1 m=1
M3 VX3 VCONT5 VP VDD pch l=0.15 w=1 nf=1 m=1
M4 VX3 VCONT4 VSS VSS nch l=0.15 w=1 nf=1 m=1
M5 net1 VCONT1 VIN VDD pch l=0.15 w=1 nf=1 m=1
MN1 net8 VFP1 net7 VSS nch l=0.15 w=1 nf=1 m=1
MN10 VB1 VBN VSS VSS nch l=0.15 w=1 nf=1 m=1
MN11 net6 net3 VB2 VSS nch l=0.15 w=1 nf=1 m=1
MN12 net9 net2 net6 VSS nch l=0.15 w=1 nf=1 m=1
MN13 net3 net3 net6 VSS nch l=0.15 w=1 nf=1 m=1
MN14 net2 net2 net9 VSS nch l=0.15 w=1 nf=1 m=1
MN15 VB2 VB2 VSS VSS nch l=0.15 w=1 nf=1 m=1
MN16 VBP net9 VSS VSS nch l=0.15 w=1 nf=1 m=1
MN2 VX3 VREF net7 VSS nch l=0.15 w=1 nf=1 m=1
MN3 net0 net0 VSS VSS nch l=0.15 w=1 nf=1 m=1
MN4 VCTRL net0 VSS VSS nch l=0.15 w=1 nf=1 m=1
MN5 net7 VBN VSS VSS nch l=0.15 w=1 nf=1 m=1
MN6 net4 net5 VSS VSS nch l=0.15 w=1 nf=1 m=1
MN7 net5 net5 VSS VSS nch l=0.15 w=1 nf=1 m=1
MN8 net5 VB3 VSS VSS nch l=0.15 w=1 nf=1 m=1
MN9 VBN VBN VSS VSS nch l=0.15 w=1 nf=1 m=1
MP1 net0 net8 VDD VDD pch l=0.15 w=1 nf=1 m=1
MP10 VB1 VB1 VDD VDD pch l=0.15 w=1 nf=1 m=1
MP11 VBP VBP VDD VDD pch l=0.15 w=1 nf=1 m=1
MP12 VB2 VBP VDD VDD pch l=0.15 w=1 nf=1 m=1
MP13 net2 VBP VDD VDD pch l=0.15 w=1 nf=1 m=1
MP14 net3 VBP VDD VDD pch l=0.15 w=1 nf=1 m=1
MP2 net8 net8 VDD VDD pch l=0.15 w=1 nf=1 m=1
MP3 VX3 VX3 VDD VDD pch l=0.15 w=1 nf=1 m=1
MP4 net4 net4 net1 VDD pch l=0.15 w=1 nf=1 m=1
MP5 VX1 net4 net1 VDD pch l=0.15 w=1 nf=1 m=1
MP6 net5 VCTRL net1 VDD pch l=0.15 w=1 nf=1 m=1
MP8 VCTRL VX3 VDD VDD pch l=0.15 w=1 nf=1 m=1
MP9 VBN VBP VDD VDD pch l=0.15 w=1 nf=1 m=1
R1 VP VFP1 1k
R2 VFP1 VSS 1k
.ends dut
