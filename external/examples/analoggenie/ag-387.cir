* official Analog Canvas netlist; PDK X cards rewritten by convert.py
.model nch nmos
.model pch pmos

* Ideal inverter: switches at V(VDD,VSS)/2; vt sets the step width, td the delay
.subckt inverter VDD VSS A Y params: vt=10m td=10p
BhA hA 0 V={0.5*(1+tanh((V(A,VSS)-0.5*V(VDD,VSS))/vt))}
Bf nfn VSS V={V(VDD,VSS)*(1-V(hA))}
Rd nfn ndl 1k
Cd ndl VSS {td/1000}
BY Y VSS V={V(ndl,VSS)}
.ends inverter

.subckt dut VDD VSS CKin CK_bar CK
M1 net1 VDD CKin VSS nch l=0.15 w=1 nf=1 m=1
M2 CKin VSS net1 VDD pch l=0.15 w=1 nf=1 m=1
X1 VDD VSS CKin net0 inverter td=10p vt=10m
X2 VDD VSS net0 CK inverter td=10p vt=10m
X3 VDD VSS net1 CK_bar inverter td=10p vt=10m
.ends dut
