* official Analog Canvas netlist; PDK X cards rewritten by convert.py
.model nch nmos
.model pch pmos

.subckt dut VDD VSS VIN VCONT1 VCONT2 VCONT3 VCONT4 VCONT5 VB3 VREF
.model DIODE D(IS=1e-14 N=1)
CFLY VX1 VX2 1p
CO VP VN 1p
COP VP VSS 1p
D1 VN VX2 DIODE
L1 VX1 VX3 1n
M1 VX1 VCONT2 VIN VIN pch l=0.15 w=1 nf=1 m=1
M2 VX2 VCONT3 VIN VIN pch l=0.15 w=1 nf=1 m=1
M3 VX3 VCONT5 VP VP pch l=0.15 w=1 nf=1 m=1
M4 VX3 VCONT4 VSS VSS nch l=0.15 w=1 nf=1 m=1
M5 net0 VCONT1 VIN VIN pch l=0.15 w=1 nf=1 m=1
MN1 net9 net9 VSS VSS nch l=0.15 w=1 nf=1 m=1
MN10 net5 net5 VSS VSS nch l=0.15 w=1 nf=1 m=1
MN11 net4 net5 VSS VSS nch l=0.15 w=1 nf=1 m=1
MN2 VX2 VX2 VSS VSS nch l=0.15 w=1 nf=1 m=1
MN3 VCTRL net9 VSS VSS nch l=0.15 w=1 nf=1 m=1
MN4 net8 VX2 VSS VSS nch l=0.15 w=1 nf=1 m=1
MN5 net1 net1 VSS VSS nch l=0.15 w=1 nf=1 m=1
MN6 net2 net1 VSS VSS nch l=0.15 w=1 nf=1 m=1
MN7 net1 VB3 VSS VSS nch l=0.15 w=1 nf=1 m=1
MN8 VBP net5 VSS VSS nch l=0.15 w=1 nf=1 m=1
MN9 net7 net7 VSS VSS nch l=0.15 w=1 nf=1 m=1
MP1 net8 net8 VDD VDD pch l=0.15 w=1 nf=1 m=1
MP10 net7 VBP VDD VDD pch l=0.15 w=1 nf=1 m=1
MP11 net4 net4 VDD VDD pch l=0.15 w=1 nf=1 m=1
MP12 net5 net4 VDD VDD pch l=0.15 w=1 nf=1 m=1
MP2 VCTRL net8 VDD VDD pch l=0.15 w=1 nf=1 m=1
MP3 net3 VBP VDD VDD pch l=0.15 w=1 nf=1 m=1
MP4 net9 VFP1 net3 net6 pch l=0.15 w=1 nf=1 m=1
MP5 VX2 VREF net3 net6 pch l=0.15 w=1 nf=1 m=1
MP6 net1 VCTRL net0 net0 pch l=0.15 w=1 nf=1 m=1
MP7 net2 net2 net0 net0 pch l=0.15 w=1 nf=1 m=1
MP8 VX1 net2 net0 net0 pch l=0.15 w=1 nf=1 m=1
MP9 VBP VBP VDD VDD pch l=0.15 w=1 nf=1 m=1
R1 VP VFP1 1k
R2 VFP1 VSS 1k
.ends dut
