* official Analog Canvas netlist; PDK X cards rewritten by convert.py
.model nch nmos
.model pch pmos
.model qnpn npn

.subckt opamp VDD VSS INP INN OUT VZ
M1 net3 INP net5 VSS nch l=0.15 w=1 nf=1 m=1
M10 VB3 net6 VDD VDD pch l=0.15 w=1 nf=1 m=1
M11 VB3 VB3 VSS VSS nch l=0.15 w=1 nf=1 m=1
M12 net6 net6 VDD VDD pch l=0.15 w=1 nf=1 m=1
M13 net6 net2 VSS VSS nch l=0.15 w=1 nf=1 m=1
M14 net2 net0 VDD VDD pch l=0.15 w=1 nf=1 m=1
M15 net2 net2 VSS VSS nch l=0.15 w=1 nf=1 m=1
M16 net0 net0 VDD VDD pch l=0.15 w=1 nf=1 m=1
M17 net0 net2 net7 VSS nch l=0.15 w=1 nf=1 m=1
M18 net7 net4 VSS VSS nch l=0.15 w=1 nf=1 m=1
M19 net4 net0 VDD VDD pch l=0.15 w=1 nf=1 m=1
M2 net1 INN net5 VSS nch l=0.15 w=1 nf=1 m=1
M20 net4 net4 VSS VSS nch l=0.15 w=1 nf=1 m=1
M3 net3 net3 VDD VDD pch l=0.15 w=1 nf=1 m=1
M4 net1 net1 VDD VDD pch l=0.15 w=1 nf=1 m=1
M5 OUT net3 VDD VDD pch l=0.15 w=1 nf=1 m=1
M6 VZ net1 VDD VDD pch l=0.15 w=1 nf=1 m=1
M7 OUT VZ VSS VSS nch l=0.15 w=1 nf=1 m=1
M8 VZ VZ VSS VSS nch l=0.15 w=1 nf=1 m=1
M9 net5 VB3 VSS VSS nch l=0.15 w=1 nf=1 m=1
.ends opamp

.subckt dut VDD VSS Vout
Q1 X X VSS VSS qnpn m=1
Q2 net0 net0 VSS VSS qnpn m=1
R1 Vout X 1k
R2 Vout Y 1k
R3 Y net0 1k
X1 VDD VSS X Y Vout net0 opamp
.ends dut
