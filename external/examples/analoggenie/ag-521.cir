* official Analog Canvas netlist; PDK X cards rewritten by convert.py
.model nch nmos

.subckt dut VDD VSS Voutn Voutp Vinp Vinn
C1 VDD Voutn 1p
C2 VDD Voutp 1p
ISS net0 VSS DC 1m
L1 VDD Voutn 1n
L2 VDD Voutp 1n
M1 Voutn Vinp net0 VSS nch l=0.15 w=1 nf=1 m=1
M2 Voutp Vinn net0 VSS nch l=0.15 w=1 nf=1 m=1
Rp VDD Voutn 1k
Rp2 VDD Voutp 1k
.ends dut
