* official Analog Canvas netlist; PDK X cards rewritten by convert.py
.model nch nmos
.model pch pmos
.model qnpn npn

.subckt opamp VDD VSS INN INP OUT VB1 VB2
M10 net0 VX VSS VSS nch l=0.15 w=1 nf=1 m=1
M11 net5 INN net2 VSS nch l=0.15 w=1 nf=1 m=1
M12 net4 INP net2 VSS nch l=0.15 w=1 nf=1 m=1
M13 net2 VB5 VSS VSS nch l=0.15 w=1 nf=1 m=1
M14 VB3 net1 VDD VDD pch l=0.15 w=1 nf=1 m=1
M15 net1 net1 VDD VDD pch l=0.15 w=1 nf=1 m=1
M16 VB3 VB3 VSS VSS nch l=0.15 w=1 nf=1 m=1
M17 net1 VB3 VSS VSS nch l=0.15 w=1 nf=1 m=1
M18 VB4 net1 VDD VDD pch l=0.15 w=1 nf=1 m=1
M19 VB4 VB4 VB5 VSS nch l=0.15 w=1 nf=1 m=1
M20 VB5 VB5 VSS VSS nch l=0.15 w=1 nf=1 m=1
M3 net5 VB1 VDD VDD pch l=0.15 w=1 nf=1 m=1
M4 VX VB2 net5 VDD pch l=0.15 w=1 nf=1 m=1
M5 VX VB4 net3 VSS nch l=0.15 w=1 nf=1 m=1
M6 net3 VX VSS VSS nch l=0.15 w=1 nf=1 m=1
M7 net4 VB1 VDD VDD pch l=0.15 w=1 nf=1 m=1
M8 OUT VB2 net4 VDD pch l=0.15 w=1 nf=1 m=1
M9 OUT VB4 net0 VSS nch l=0.15 w=1 nf=1 m=1
.ends opamp

.subckt dut VDD VSS Vout VB1 VB2
Q1 net2 net2 VSS VSS qnpn m=1
Q2 net0 net0 VSS VSS qnpn m=1
R1 Vout net2 1k
R2 Vout net1 1k
R3 net1 net0 1k
X1 VDD VSS net1 net2 Vout VB1 VB2 opamp
.ends dut
