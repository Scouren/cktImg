* official Analog Canvas netlist; PDK X cards rewritten by convert.py
.model nch nmos
.model pch pmos

.subckt dut VDD VSS VIN VOUT Vref
CL VOUT VX 1p
M1 VX FB net0 VSS nch l=0.15 w=1 nf=1 m=1
M10 net3 net3 VDD VDD pch l=0.15 w=1 nf=1 m=1
M11 VB1 net3 VDD VDD pch l=0.15 w=1 nf=1 m=1
M12 VB1 VB1 VSS VSS nch l=0.15 w=1 nf=1 m=1
M2 net2 Vref net0 VSS nch l=0.15 w=1 nf=1 m=1
M3 VX VX VDD VDD pch l=0.15 w=1 nf=1 m=1
M4 net2 net2 VDD VDD pch l=0.15 w=1 nf=1 m=1
M5 net1 VX VDD VDD pch l=0.15 w=1 nf=1 m=1
M6 net4 net2 VDD VDD pch l=0.15 w=1 nf=1 m=1
M7 net1 net1 VSS VSS nch l=0.15 w=1 nf=1 m=1
M8 net4 net1 VSS VSS nch l=0.15 w=1 nf=1 m=1
M9 net0 VB1 VSS VSS nch l=0.15 w=1 nf=1 m=1
MNP VIN net4 VOUT VSS nch l=0.15 w=1 nf=1 m=1
R1 VOUT FB 1k
R2 FB VSS 1k
R3 VX VSS 1k
R4 net3 VSS 1k
.ends dut
