* official Analog Canvas netlist; PDK X cards rewritten by convert.py
.model nch nmos
.model pch pmos

.subckt dut VDD VSS Vref Vout biasp biascas biasn
C1 Vset VSS 1p
C2 n3 Vout 1p
M1 Vout n3 VDD VDD pch l=0.15 w=1 nf=1 m=1
M10 Vset fb VDD VDD pch l=0.15 w=1 nf=1 m=1
M11 VY net1 VDD VDD pch l=0.15 w=1 nf=1 m=1
M12 net2 VN VSS VSS nch l=0.15 w=1 nf=1 m=1
M13 Vset VY VSS VSS nch l=0.15 w=1 nf=1 m=1
M14 VY VY VSS VSS nch l=0.15 w=1 nf=1 m=1
M15 VN VB1 VDD VDD pch l=0.15 w=1 nf=1 m=1
M16 VN VN VSS VSS nch l=0.15 w=1 nf=1 m=1
M17 VB1 VB1 VDD VDD pch l=0.15 w=1 nf=1 m=1
M18 VB1 VX VSS VSS nch l=0.15 w=1 nf=1 m=1
M19 VB2 VB2 VDD VDD pch l=0.15 w=1 nf=1 m=1
M2 n1 Vset Vout VDD pch l=0.15 w=1 nf=1 m=1
M20 VB2 VX VSS VSS nch l=0.15 w=1 nf=1 m=1
M21 VX VB2 VDD VDD pch l=0.15 w=1 nf=1 m=1
M22 net0 VX VSS VSS nch l=0.15 w=1 nf=1 m=1
M3 n1 biasn VSS VSS nch l=0.15 w=1 nf=1 m=1
M4 n3 biasp VDD VDD pch l=0.15 w=1 nf=1 m=1
M5 n3 biascas n1 VSS nch l=0.15 w=1 nf=1 m=1
M6 fb Vref net2 VSS nch l=0.15 w=1 nf=1 m=1
M7 net1 fb net2 VSS nch l=0.15 w=1 nf=1 m=1
M8 fb fb VDD VDD pch l=0.15 w=1 nf=1 m=1
M9 net1 net1 VDD VDD pch l=0.15 w=1 nf=1 m=1
R1 fb VSS 1k
R2 Vout fb 1k
R3 VX net0 1k
.ends dut
