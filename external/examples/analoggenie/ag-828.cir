* official Analog Canvas netlist; PDK X cards rewritten by convert.py
.model qnpn npn

.subckt dut VCC VEE VSS Vod- Vod+
ITAIL net3 VEE DC 1m
Q1 Vod- net1 net0 VEE qnpn m=1
Q2 Vod+ net4 net2 VEE qnpn m=1
RC1 VCC Vod- 1k
RC2 VCC Vod+ 1k
RE1 net0 net3 1k
RE2 net2 net3 1k
V1 net1 VSS DC 1
V2 VSS net4 DC 1
.ends dut
