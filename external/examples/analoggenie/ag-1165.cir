* official Analog Canvas netlist; PDK X cards rewritten by convert.py
.model nch nmos

.subckt dut VDD VSS Vip Vin Vop Von Vctrl
C1 Vop net0 1p
C2 net0 Vctrl 1p
C3 Von net1 1p
C4 net1 Vctrl 1p
L1 VDD Vop 1n
L2 net0 VSS 1n
L3 VDD Von 1n
L4 net1 VSS 1n
M1 Vop Von net0 VSS nch l=0.15 w=1 nf=1 m=1
M2 Von Vop net1 VSS nch l=0.15 w=1 nf=1 m=1
M3 Vop VDD Vip VSS nch l=0.15 w=1 nf=1 m=1
M4 Von VDD Vin VSS nch l=0.15 w=1 nf=1 m=1
.ends dut
