* official Analog Canvas netlist; PDK X cards rewritten by convert.py
.model nch nmos
.model pch pmos

.subckt dut VDD VSS GND v1 v2 v3 v4
VB1 net0 GND DC 1
IBIAS VDD VB DC 1m
M1 v3 v1 net2 VSS nch l=0.15 w=1 nf=1 m=1
M2 v4 v2 net2 VSS nch l=0.15 w=1 nf=1 m=1
M3 v3 net1 VDD VDD pch l=0.15 w=1 nf=1 m=1
M4 v4 net1 VDD VDD pch l=0.15 w=1 nf=1 m=1
M5 net2 VB VSS VSS nch l=0.15 w=1 nf=1 m=1
MB VB VB VSS VSS nch l=0.15 w=1 nf=1 m=1
MC1 net1 net0 net3 VSS nch l=0.15 w=1 nf=1 m=1
MC2 net5 net4 net3 VSS nch l=0.15 w=1 nf=1 m=1
MC3 net1 net1 VDD VDD pch l=0.15 w=1 nf=1 m=1
MC4 net5 net5 VDD VDD pch l=0.15 w=1 nf=1 m=1
MC5 net3 VB VSS VSS nch l=0.15 w=1 nf=1 m=1
RCM1 net4 v3 1k
RCM2 net4 v4 1k
.ends dut
