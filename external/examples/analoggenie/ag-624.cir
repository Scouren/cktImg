* official Analog Canvas netlist; PDK X cards rewritten by convert.py
.model qnpn npn

.subckt dut VSS Voutp Voutn
I1 VSS Voutp DC 50uA
I2 VSS Voutn DC 207.5uA
Q1 Voutp Voutp net1 VSS qnpn m=1
Q10 net2 net2 VSS VSS qnpn m=1
Q11 Voutn Voutn net10 VSS qnpn m=1
Q12 net10 net10 net7 VSS qnpn m=1
Q13 net7 net7 net5 VSS qnpn m=1
Q14 net5 net5 net12 VSS qnpn m=1
Q15 net12 net12 net9 VSS qnpn m=1
Q16 net9 net9 net8 VSS qnpn m=1
Q17 net8 net8 net11 VSS qnpn m=1
Q18 net11 net11 net4 VSS qnpn m=1
Q19 net4 net4 VSS VSS qnpn m=1
Q2 net1 net1 net6 VSS qnpn m=1
Q3 net6 net6 net0 VSS qnpn m=1
Q4 net0 net0 net14 VSS qnpn m=1
Q5 net14 net14 net15 VSS qnpn m=1
Q6 net15 net15 net3 VSS qnpn m=1
Q7 net3 net3 net16 VSS qnpn m=1
Q8 net16 net16 net13 VSS qnpn m=1
Q9 net13 net13 net2 VSS qnpn m=1
.ends dut
