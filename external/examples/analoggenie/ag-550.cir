* official Analog Canvas netlist; PDK X cards rewritten by convert.py
.model nch nmos
.model pch pmos

* Ideal inverter: switches at V(VDD,VSS)/2; vt sets the step width, td the delay
.subckt inverter VDD VSS A Y params: vt=10m td=10p
BhA hA 0 V={0.5*(1+tanh((V(A,VSS)-0.5*V(VDD,VSS))/vt))}
Bf nfn VSS V={V(VDD,VSS)*(1-V(hA))}
Rd nfn ndl 1k
Cd ndl VSS {td/1000}
BY Y VSS V={V(ndl,VSS)}
.ends inverter

.subckt dut VDD VSS QA QB Vb2 Vb1 Vcont
C1 net3 VSS 1p
M1 Vcont net4 net0 VDD pch l=0.15 w=1 nf=1 m=1
M2 Vcont net2 net1 VSS nch l=0.15 w=1 nf=1 m=1
M3 net0 Vb2 VDD VDD pch l=0.15 w=1 nf=1 m=1
M4 net1 Vb1 VSS VSS nch l=0.15 w=1 nf=1 m=1
M5 QB VDD net2 VSS nch l=0.15 w=1 nf=1 m=1
M6 net2 VSS QB VDD pch l=0.15 w=1 nf=1 m=1
R1 Vcont net3 1k
X1 VDD VSS QA net4 inverter td=10p vt=10m
.ends dut
