* official Analog Canvas netlist; PDK X cards rewritten by convert.py
.model nch nmos
.model pch pmos

.subckt AMP1 VDD VSS OUT INP INN VB
M10 INN INN VDD VDD pch l=0.15 w=1 nf=1 m=1
M11 INN INP net1 VSS nch l=0.15 w=1 nf=1 m=1
M12 OUT INN VDD VDD pch l=0.15 w=1 nf=1 m=1
M13 OUT VX VSS VSS nch l=0.15 w=1 nf=1 m=1
M14 net1 VB VSS VSS nch l=0.15 w=1 nf=1 m=1
M6 VX net0 VDD VDD pch l=0.15 w=1 nf=1 m=1
M7 VX VX VSS VSS nch l=0.15 w=1 nf=1 m=1
M8 net0 net0 VDD VDD pch l=0.15 w=1 nf=1 m=1
M9 net0 INN net1 VSS nch l=0.15 w=1 nf=1 m=1
.ends AMP1

.subckt dut VDD VSS Vref Vout biasp biascas biasn
C1 Vset VSS 1p
C2 n3 Vout 1p
M1 Vout n3 VDD VDD pch l=0.15 w=1 nf=1 m=1
M15 VB2 VB2 VDD VDD pch l=0.15 w=1 nf=1 m=1
M16 net0 VB2 VDD VDD pch l=0.15 w=1 nf=1 m=1
M17 net1 VB2 VDD VDD pch l=0.15 w=1 nf=1 m=1
M18 VW VB2 VDD VDD pch l=0.15 w=1 nf=1 m=1
M19 VB1 VB1 VDD VDD pch l=0.15 w=1 nf=1 m=1
M2 n1 Vset Vout VDD pch l=0.15 w=1 nf=1 m=1
M20 VB VB1 VDD VDD pch l=0.15 w=1 nf=1 m=1
M21 VB2 VX VSS VSS nch l=0.15 w=1 nf=1 m=1
M22 net0 net0 VX VSS nch l=0.15 w=1 nf=1 m=1
M23 net1 net1 VZ VSS nch l=0.15 w=1 nf=1 m=1
M24 VW VW VSS VSS nch l=0.15 w=1 nf=1 m=1
M25 VB1 VW VSS VSS nch l=0.15 w=1 nf=1 m=1
M26 VB VB VSS VSS nch l=0.15 w=1 nf=1 m=1
M27 VX net0 VZ VSS nch l=0.15 w=1 nf=1 m=1
M28 VZ net1 VW VSS nch l=0.15 w=1 nf=1 m=1
M3 n1 biasn VSS VSS nch l=0.15 w=1 nf=1 m=1
M4 n3 biasp VDD VDD pch l=0.15 w=1 nf=1 m=1
M5 n3 biascas n1 VSS nch l=0.15 w=1 nf=1 m=1
R1 fb VSS 1k
R2 Vout fb 1k
X1 VDD VSS Vset Vref fb VB AMP1
.ends dut
