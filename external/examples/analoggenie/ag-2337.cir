* official Analog Canvas netlist; PDK X cards rewritten by convert.py
.model nch nmos
.model pch pmos

.subckt dut VDD VSS VREF VB3 IB VIN VOUT
CL VOUT net3 1p
M1 net7 net7 VDD VDD pch l=0.15 w=1 nf=1 m=1
M10 VBN VB1 VDD VDD pch l=0.15 w=1 nf=1 m=1
M11 VBN VBN VSS VSS nch l=0.15 w=1 nf=1 m=1
M12 VB1 VB1 VDD VDD pch l=0.15 w=1 nf=1 m=1
M13 net6 VB3 VDD VDD pch l=0.15 w=1 nf=1 m=1
M14 net1 EAO net6 VDD pch l=0.15 w=1 nf=1 m=1
M15 net1 net1 VSS VSS nch l=0.15 w=1 nf=1 m=1
M16 GATE net1 VSS VSS nch l=0.15 w=1 nf=1 m=1
M17 VDD net6 GATE VSS nch l=0.15 w=1 nf=1 m=1
M18 net0 EAO IB IB nch l=0.15 w=1 nf=1 m=1
M19 net0 net0 VDD VDD pch l=0.15 w=1 nf=1 m=1
M2 net5 net5 VDD VDD pch l=0.15 w=1 nf=1 m=1
M20 GATE net0 VDD VDD pch l=0.15 w=1 nf=1 m=1
M21 VSS IB GATE VSS pch l=0.15 w=1 nf=1 m=1
M22 VB1 net4 VSS VSS nch l=0.15 w=1 nf=1 m=1
M23 VB2 VB2 VDD VDD pch l=0.15 w=1 nf=1 m=1
M24 VB2 net4 VSS VSS nch l=0.15 w=1 nf=1 m=1
M25 net4 VB2 VDD VDD pch l=0.15 w=1 nf=1 m=1
M26 net2 net4 VSS VSS nch l=0.15 w=1 nf=1 m=1
M3 net7 VREF net1 VSS nch l=0.15 w=1 nf=1 m=1
M4 net5 FB net1 VSS nch l=0.15 w=1 nf=1 m=1
M5 net1 VBN VSS VSS nch l=0.15 w=1 nf=1 m=1
M6 EAO net7 VDD VDD pch l=0.15 w=1 nf=1 m=1
M7 net8 net5 VDD VDD pch l=0.15 w=1 nf=1 m=1
M8 net8 net8 VSS VSS nch l=0.15 w=1 nf=1 m=1
M9 EAO net8 VSS VSS nch l=0.15 w=1 nf=1 m=1
MNP VIN GATE VOUT VOUT nch l=0.15 w=1 nf=1 m=1
R1 FB VSS 1k
R2 VOUT FB 1k
R4 net4 net2 1k
R5 net3 VSS 1k
RL VOUT VSS 1k
.ends dut
