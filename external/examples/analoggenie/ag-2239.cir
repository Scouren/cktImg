* official Analog Canvas netlist; PDK X cards rewritten by convert.py
.model nch nmos
.model pch pmos

.subckt dut VDD VSS Vref VIN VOUT VB1
CL VOUT VX 1p
M10 net0 net0 VSS VSS nch l=0.15 w=1 nf=1 m=1
M11 net4 net0 VSS VSS nch l=0.15 w=1 nf=1 m=1
M12 net3 net2 VDD VDD pch l=0.15 w=1 nf=1 m=1
M13 net2 net2 VDD VDD pch l=0.15 w=1 nf=1 m=1
M14 VB2 net2 VDD VDD pch l=0.15 w=1 nf=1 m=1
M15 net2 net3 VB1 VSS nch l=0.15 w=1 nf=1 m=1
M16 net3 VB1 VSS VSS nch l=0.15 w=1 nf=1 m=1
M17 VB2 VB2 VSS VSS nch l=0.15 w=1 nf=1 m=1
M3 net0 VX VDD VDD pch l=0.15 w=1 nf=1 m=1
M4 VX VX VDD VDD pch l=0.15 w=1 nf=1 m=1
M5 net1 net1 VDD VDD pch l=0.15 w=1 nf=1 m=1
M6 net4 net1 VDD VDD pch l=0.15 w=1 nf=1 m=1
M7 VX FB net5 VSS nch l=0.15 w=1 nf=1 m=1
M8 net1 Vref net5 VSS nch l=0.15 w=1 nf=1 m=1
M9 net5 VB2 VSS VSS nch l=0.15 w=1 nf=1 m=1
MNP VIN net4 VOUT VSS nch l=0.15 w=1 nf=1 m=1
R1 VOUT FB 1k
R2 FB VSS 1k
R3 VB1 VSS 1k
R4 VX VSS 1k
.ends dut
