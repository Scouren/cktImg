* official Analog Canvas netlist; PDK X cards rewritten by convert.py
.model nch nmos
.model pch pmos
.model qpnp pnp

.subckt opamp VDD VSS VB1 INN VB3 INP OUT VB2
M1 INN VB1 VDD VDD pch l=0.15 w=1 nf=1 m=1
M10 net7 INP net4 VSS nch l=0.15 w=1 nf=1 m=1
M11 net4 VB2 VSS VSS nch l=0.15 w=1 nf=1 m=1
M12 net1 net1 net2 VDD pch l=0.15 w=1 nf=1 m=1
M13 VB4 net1 VDD VDD pch l=0.15 w=1 nf=1 m=1
M14 VB4 VB4 net6 VSS nch l=0.15 w=1 nf=1 m=1
M15 net6 VB4 VSS VSS nch l=0.15 w=1 nf=1 m=1
M2 net7 VB1 VDD VDD pch l=0.15 w=1 nf=1 m=1
M3 net5 VB3 INN VDD pch l=0.15 w=1 nf=1 m=1
M4 OUT VB3 net7 VDD pch l=0.15 w=1 nf=1 m=1
M5 net5 VB4 net3 VSS nch l=0.15 w=1 nf=1 m=1
M6 OUT VB4 net0 VSS nch l=0.15 w=1 nf=1 m=1
M7 net3 net5 VSS VSS nch l=0.15 w=1 nf=1 m=1
M8 net0 net5 VSS VSS nch l=0.15 w=1 nf=1 m=1
M9 INN INN net4 VSS nch l=0.15 w=1 nf=1 m=1
R4 VDD net2 1k
R5 net1 VSS 1k
.ends opamp

.subckt dut VDD VSS Vout VB1 VB2 VB3
Q1 VSS VSS net2 qpnp m=1
Q2 net2 net2 X qpnp m=1
Q3 VSS VSS net1 qpnp m=1
Q4 net1 net1 net0 qpnp m=1
R1 Vout X 1k
R2 Vout Y 1k
R3 Y net0 1k
X1 VDD VSS VB1 Y VB3 X Vout VB2 opamp
.ends dut
