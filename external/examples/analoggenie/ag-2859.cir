* official Analog Canvas netlist; PDK X cards rewritten by convert.py
.model nch nmos
.model pch pmos

.subckt dut VDD VSS vci phi1 phi2 vco VB2 VB1
C1 vcx VSS 1p
C2 net8 vco 1p
M1 vci phi1 vcx VSS nch l=0.15 w=1 nf=1 m=1
M10 VB2 VB2 VDD VDD pch l=0.15 w=1 nf=1 m=1
M11 VB2 net7 VSS VSS nch l=0.15 w=1 nf=1 m=1
M12 net9 VB2 VDD VDD pch l=0.15 w=1 nf=1 m=1
M13 net9 net9 net7 VSS nch l=0.15 w=1 nf=1 m=1
M14 net7 net9 net10 VSS nch l=0.15 w=1 nf=1 m=1
M15 net2 VB2 VDD VDD pch l=0.15 w=1 nf=1 m=1
M16 net2 net2 net10 VSS nch l=0.15 w=1 nf=1 m=1
M17 net10 net2 net6 VSS nch l=0.15 w=1 nf=1 m=1
M18 net6 VB2 VDD VDD pch l=0.15 w=1 nf=1 m=1
M19 net6 net6 VSS VSS nch l=0.15 w=1 nf=1 m=1
M2 vcx phi2 net8 VSS nch l=0.15 w=1 nf=1 m=1
M20 net4 net6 VSS VSS nch l=0.15 w=1 nf=1 m=1
M21 net4 net4 VDD VDD pch l=0.15 w=1 nf=1 m=1
M22 VX net4 VDD VDD pch l=0.15 w=1 nf=1 m=1
M23 VX VX VSS VSS nch l=0.15 w=1 nf=1 m=1
M24 VB1 VB1 VDD VDD pch l=0.15 w=1 nf=1 m=1
M25 VB1 VX VSS VSS nch l=0.15 w=1 nf=1 m=1
M3 vcx net8 net5 VSS nch l=0.15 w=1 nf=1 m=1
M4 vco VSS net5 VSS nch l=0.15 w=1 nf=1 m=1
M5 net5 VX VSS VSS nch l=0.15 w=1 nf=1 m=1
M6 vcx net3 net0 VDD pch l=0.15 w=1 nf=1 m=1
M7 vco net3 net1 VDD pch l=0.15 w=1 nf=1 m=1
M8 net0 vcx VDD VDD pch l=0.15 w=1 nf=1 m=1
M9 net1 vcx VDD VDD pch l=0.15 w=1 nf=1 m=1
.ends dut
