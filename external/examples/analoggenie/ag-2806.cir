* official Analog Canvas netlist; PDK X cards rewritten by convert.py
.model nch nmos
.model pch pmos

.subckt dut VDD VSS vci phi1 phi2 vco
C1 vcx VSS 1p
C2 net2 vco 1p
M1 vci phi1 vcx VSS nch l=0.15 w=1 nf=1 m=1
M10 net3 VB1 VDD VDD pch l=0.15 w=1 nf=1 m=1
M11 net1 net3 VSS VSS nch l=0.15 w=1 nf=1 m=1
M12 net0 net0 VDD VDD pch l=0.15 w=1 nf=1 m=1
M13 net0 net3 VSS VSS nch l=0.15 w=1 nf=1 m=1
M14 VB2 net0 VDD VDD pch l=0.15 w=1 nf=1 m=1
M15 VB2 VB2 VSS VSS nch l=0.15 w=1 nf=1 m=1
M16 VX VX VDD VDD pch l=0.15 w=1 nf=1 m=1
M17 VX VB2 VSS VSS nch l=0.15 w=1 nf=1 m=1
M2 vcx phi2 net2 VSS nch l=0.15 w=1 nf=1 m=1
M3 VX net2 net4 VSS nch l=0.15 w=1 nf=1 m=1
M4 vco VSS net4 VSS nch l=0.15 w=1 nf=1 m=1
M5 net4 VB2 VSS VSS nch l=0.15 w=1 nf=1 m=1
M6 VX VX VDD VDD pch l=0.15 w=1 nf=1 m=1
M7 vco VX VDD VDD pch l=0.15 w=1 nf=1 m=1
M8 VB1 VB1 VDD VDD pch l=0.15 w=1 nf=1 m=1
M9 VB1 net3 VSS VSS nch l=0.15 w=1 nf=1 m=1
R1 net3 net1 1k
.ends dut
