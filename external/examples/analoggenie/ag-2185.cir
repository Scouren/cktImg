* official Analog Canvas netlist; PDK X cards rewritten by convert.py
.model nch nmos
.model pch pmos

.subckt Opamp VDD VSS INN VB1 VB2 INP OUT
M10 OUT VB1 net5 VDD pch l=0.15 w=1 nf=1 m=1
M11 OUT VC net0 VSS nch l=0.15 w=1 nf=1 m=1
M12 net0 OUT VSS VSS nch l=0.15 w=1 nf=1 m=1
M13 net6 VY VDD VDD pch l=0.15 w=1 nf=1 m=1
M14 OUT VB1 net6 VDD pch l=0.15 w=1 nf=1 m=1
M15 OUT VC net8 VSS nch l=0.15 w=1 nf=1 m=1
M16 net8 OUT VSS VSS nch l=0.15 w=1 nf=1 m=1
M17 VX net1 VDD VDD pch l=0.15 w=1 nf=1 m=1
M18 net1 net1 VDD VDD pch l=0.15 w=1 nf=1 m=1
M19 net1 VX VB3 VSS nch l=0.15 w=1 nf=1 m=1
M2 net7 VX VDD VDD pch l=0.15 w=1 nf=1 m=1
M20 VX VB3 VSS VSS nch l=0.15 w=1 nf=1 m=1
M21 VC net1 VDD VDD pch l=0.15 w=1 nf=1 m=1
M22 VC VC net3 VSS nch l=0.15 w=1 nf=1 m=1
M23 net3 VC VSS VSS nch l=0.15 w=1 nf=1 m=1
M3 VX VB1 net7 VDD pch l=0.15 w=1 nf=1 m=1
M4 VX INN net4 VSS nch l=0.15 w=1 nf=1 m=1
M5 net2 VY VDD VDD pch l=0.15 w=1 nf=1 m=1
M6 VY VB1 net2 VDD pch l=0.15 w=1 nf=1 m=1
M7 VY INP net4 VSS nch l=0.15 w=1 nf=1 m=1
M8 net4 VB2 VSS VSS nch l=0.15 w=1 nf=1 m=1
M9 net5 VX VDD VDD pch l=0.15 w=1 nf=1 m=1
R1 VB3 VSS 1k
.ends Opamp

.subckt dut VDD VSS Vref VIN VOUT VB1 VB2
CL VOUT net0 1p
MNP VIN net1 VOUT VSS nch l=0.15 w=1 nf=1 m=1
R1 VOUT FB 1k
R2 FB VSS 1k
R3 net0 VSS 1k
X1 VDD VSS FB VB1 VB2 Vref net1 Opamp
.ends dut
