* official Analog Canvas netlist; PDK X cards rewritten by convert.py
.model nch nmos

.subckt dut VDD VSS IOUT
IIN VDD net1 DC 1m
M1 net0 net1 VSS VSS nch l=0.15 w=1 nf=1 m=1
M2 IOUT net0 VSS VSS nch l=0.15 w=1 nf=1 m=1
R net1 net0 1k
.ends dut
