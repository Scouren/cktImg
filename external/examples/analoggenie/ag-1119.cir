* official Analog Canvas netlist; PDK X cards rewritten by convert.py
.model qnpn npn
.model qpnp pnp

.subckt dut V+ V- Vo
C2 net15 V- 1p
Cosc net6 net9 1p
Q1 net17 net13 net9 V- qnpn m=1
Q10 net11 net15 V+ qpnp m=1
Q11 V- net20 net15 qpnp m=1
Q12 net20 net8 VZ V- qnpn m=1
Q13 net11 net11 VZ V- qnpn m=1
Q14 V+ net8 VB1 V- qnpn m=1
Q15 net15 net15 net14 V- qnpn m=1
Q16 net14 net14 net5 V- qnpn m=1
Q17 net5 net5 net11 V- qnpn m=1
Q18 net17 net4 V+ qpnp m=1
Q19 net13 net1 V+ qpnp m=1
Q2 net13 net17 net6 V- qnpn m=1
Q20 net4 net4 V+ qpnp m=1
Q21 net1 net1 V+ qpnp m=1
Q22 VX net17 net4 qpnp m=1
Q23 VY net13 net1 qpnp m=1
Q24 VX VX V- V- qnpn m=1
Q25 net2 VX V- V- qnpn m=1
Q26 VY VY V- V- qnpn m=1
Q27 Vo VY V- V- qnpn m=1
Q28 net2 net2 V+ qpnp m=1
Q29 Vo net2 V+ qpnp m=1
Q3 net8 VB1 VB2 V- qnpn m=1
Q30 net17 VB1 net12 V- qnpn m=1
Q31 net9 VB1 net7 V- qnpn m=1
Q32 net6 VB1 net0 V- qnpn m=1
Q33 net13 VB1 net16 V- qnpn m=1
Q34 net12 VB2 net18 V- qnpn m=1
Q35 net7 VB2 net18 V- qnpn m=1
Q36 net0 VB2 net18 V- qnpn m=1
Q37 net16 VB2 net18 V- qnpn m=1
Q4 VZ VB1 net19 V- qnpn m=1
Q5 VB2 net19 V- V- qnpn m=1
Q6 net19 VB2 net18 V- qnpn m=1
Q7 V+ net3 net10 V- qnpn m=1
Q8 net3 net10 V- V- qnpn m=1
Q9 net8 net15 V+ qpnp m=1
R1 V- net18 1k
R2 net18 net10 1k
R3 VZ net3 100k
.ends dut
