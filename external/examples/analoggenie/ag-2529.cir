* official Analog Canvas netlist; PDK X cards rewritten by convert.py
.model nch nmos
.model pch pmos

.subckt dut VDD VSS VREF VB4 VB3 VB2 VIN VB1 VOUT
CF1 VOUT VFB 1p
Cm1 VOUT VO1 1p
Cm2 VO1 net2 1p
M1 net4 VX VIN VDD pch l=0.15 w=1 nf=1 m=1
M10 VB1 VBN VSS VSS nch l=0.15 w=1 nf=1 m=1
M11 net7 VBN VSS VSS nch l=0.15 w=1 nf=1 m=1
M12 VY VFB net7 VSS nch l=0.15 w=1 nf=1 m=1
M13 VX VREF net7 VSS nch l=0.15 w=1 nf=1 m=1
M14 VX VX VIN VDD pch l=0.15 w=1 nf=1 m=1
M15 VY VY VIN VDD pch l=0.15 w=1 nf=1 m=1
M16 VX VB4 VIN VDD pch l=0.15 w=1 nf=1 m=1
M17 VX VX VSS VSS nch l=0.15 w=1 nf=1 m=1
M18 VX VO1 VSS VSS nch l=0.15 w=1 nf=1 m=1
M2 VO1 VY VIN VDD pch l=0.15 w=1 nf=1 m=1
M20 VB1 VB1 VIN VDD pch l=0.15 w=1 nf=1 m=1
M21 net3 VO1 VSS VSS nch l=0.15 w=1 nf=1 m=1
M22 net6 VX VSS VSS nch l=0.15 w=1 nf=1 m=1
M23 net3 net3 VIN VDD pch l=0.15 w=1 nf=1 m=1
M24 net6 net3 VIN VDD pch l=0.15 w=1 nf=1 m=1
M3 net4 net4 VSS VSS nch l=0.15 w=1 nf=1 m=1
M4 VO1 net4 VSS VSS nch l=0.15 w=1 nf=1 m=1
M5 net0 net0 VSS VSS nch l=0.15 w=1 nf=1 m=1
M6 net1 net0 VSS VSS nch l=0.15 w=1 nf=1 m=1
M7 net1 net1 VIN VDD pch l=0.15 w=1 nf=1 m=1
M8 VBN net1 VIN VDD pch l=0.15 w=1 nf=1 m=1
M9 VBN VBN VSS VSS nch l=0.15 w=1 nf=1 m=1
MD1 net2 VO1 VSS VSS nch l=0.15 w=1 nf=1 m=1
MD2 net5 VB2 VSS VSS nch l=0.15 w=1 nf=1 m=1
MD3 net8 net2 net5 VSS nch l=0.15 w=1 nf=1 m=1
MD4 VY VB3 net5 VSS nch l=0.15 w=1 nf=1 m=1
MD5 net2 VY VIN VDD pch l=0.15 w=1 nf=1 m=1
MD6 net8 net8 VIN VDD pch l=0.15 w=1 nf=1 m=1
MD7 VY VY VIN VDD pch l=0.15 w=1 nf=1 m=1
MPT VOUT net6 VIN VDD pch l=0.15 w=1 nf=1 m=1
R1 VIN net0 1k
RF1 VOUT VFB 1k
RF2 VFB VSS 1k
.ends dut
