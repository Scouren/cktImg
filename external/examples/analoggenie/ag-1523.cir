* official Analog Canvas netlist; PDK X cards rewritten by convert.py
.model nch nmos
.model pch pmos
.model qnpn npn

.subckt opamp VDD VSS INN INP Z OUT
M1 Z net2 VDD VDD pch l=0.15 w=1 nf=1 m=1
M10 VB3 VP VDD VDD pch l=0.15 w=1 nf=1 m=1
M11 VP VP VDD VDD pch l=0.15 w=1 nf=1 m=1
M12 VB2 VP VDD VDD pch l=0.15 w=1 nf=1 m=1
M13 VC VP VDD VDD pch l=0.15 w=1 nf=1 m=1
M14 VB3 VB3 VSS VSS nch l=0.15 w=1 nf=1 m=1
M15 VP VB2 VB1 VSS nch l=0.15 w=1 nf=1 m=1
M16 VC VC VSS VSS nch l=0.15 w=1 nf=1 m=1
M17 VB1 VC VSS VSS nch l=0.15 w=1 nf=1 m=1
M18 VB2 VB1 VSS VSS nch l=0.15 w=1 nf=1 m=1
M2 net2 net2 VDD VDD pch l=0.15 w=1 nf=1 m=1
M3 net1 net1 VDD VDD pch l=0.15 w=1 nf=1 m=1
M4 OUT net1 VDD VDD pch l=0.15 w=1 nf=1 m=1
M5 net2 INN net0 VSS nch l=0.15 w=1 nf=1 m=1
M6 net1 INP net0 VSS nch l=0.15 w=1 nf=1 m=1
M7 Z Z VSS VSS nch l=0.15 w=1 nf=1 m=1
M8 net0 VB3 VSS VSS nch l=0.15 w=1 nf=1 m=1
M9 OUT Z VSS VSS nch l=0.15 w=1 nf=1 m=1
.ends opamp

.subckt dut VDD VSS Vout
Q1 X X VSS VSS qnpn m=1
Q2 net0 net0 VSS VSS qnpn m=1
R1 Vout X 1k
R2 Vout Y 1k
R3 Y net0 1k
X1 VDD VSS Y X net0 Vout opamp
.ends dut
