* official Analog Canvas netlist; PDK X cards rewritten by convert.py
.model nch nmos
.model pch pmos
.model qpnp pnp

.subckt dut VDD VSS IOUT
M1 net0 net0 net2 VSS nch l=0.15 w=1 nf=1 m=1
M2 net3 net0 net1 VSS nch l=0.15 w=1 nf=1 m=1
M3 net0 net3 VDD VDD pch l=0.15 w=1 nf=1 m=1
M4 net3 net3 VDD VDD pch l=0.15 w=1 nf=1 m=1
M5 IOUT net3 VDD VDD pch l=0.15 w=1 nf=1 m=1
Q1 VSS VSS net2 qpnp m=1
R net1 VSS 1k
.ends dut
