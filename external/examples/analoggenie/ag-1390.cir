* official Analog Canvas netlist; PDK X cards rewritten by convert.py
.model nch nmos
.model pch pmos

.subckt comparator VDD VSS IN+ IN- VB1 VB2 OUT VB3
M1 VB3 net0 VDD VDD pch l=0.15 w=1 nf=1 m=1
M10 VX VB4 net5 VSS nch l=0.15 w=1 nf=1 m=1
M11 net5 VB5 VSS VSS nch l=0.15 w=1 nf=1 m=1
M12 net3 VB1 VDD VDD pch l=0.15 w=1 nf=1 m=1
M13 net5 IN+ net3 VDD pch l=0.15 w=1 nf=1 m=1
M14 net1 IN- net3 VDD pch l=0.15 w=1 nf=1 m=1
M15 net2 VX VDD VDD pch l=0.15 w=1 nf=1 m=1
M16 OUT VB2 net2 VDD pch l=0.15 w=1 nf=1 m=1
M17 OUT VB4 net1 VSS nch l=0.15 w=1 nf=1 m=1
M18 net1 VB5 VSS VSS nch l=0.15 w=1 nf=1 m=1
M2 VB3 VB3 VSS VSS nch l=0.15 w=1 nf=1 m=1
M3 net0 net0 VDD VDD pch l=0.15 w=1 nf=1 m=1
M4 net0 VB3 VSS VSS nch l=0.15 w=1 nf=1 m=1
M5 VB4 net0 VDD VDD pch l=0.15 w=1 nf=1 m=1
M6 VB4 VB4 VB5 VSS nch l=0.15 w=1 nf=1 m=1
M7 VB5 VB5 VSS VSS nch l=0.15 w=1 nf=1 m=1
M8 net4 VX VDD VDD pch l=0.15 w=1 nf=1 m=1
M9 VX VB2 net4 VDD pch l=0.15 w=1 nf=1 m=1
.ends comparator

.subckt dut VDD VSS VSTO VCONT1 VCONT2 VCONT3 VOUT VB1 VB2 VB3
CL VOUT VSS 1p
CSTO VSTO VSS 1p
LRX net2 net0 1n
MN1 net2 VCONT2 VSS VSS nch l=0.15 w=1 nf=1 m=1
MN2 net0 VCONT3 VSS VSS nch l=0.15 w=1 nf=1 m=1
MP2 net0 net1 VOUT VDD pch l=0.15 w=1 nf=1 m=1
MP3 net2 VCONT1 VSTO VDD pch l=0.15 w=1 nf=1 m=1
X1 VDD VSS net1 net0 VB1 VB2 net1 VB3 comparator
.ends dut
