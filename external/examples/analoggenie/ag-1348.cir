* official Analog Canvas netlist; PDK X cards rewritten by convert.py
.model nch nmos
.model pch pmos

.subckt dut VDD VSS VIN VP VC1 VC2 VC3 VC4 VC5 VB2 VREF VB1
.model DIODE D(IS=1e-14 N=1)
CFLY VX1 VX2 1p
CO VP VN 1p
COP VP VSS 1p
D1 VN VX2 DIODE
L1 VX1 VX3 1n
M1 net1 VC1 VIN VDD pch l=0.15 w=1 nf=1 m=1
M10 net0 net0 VSS VSS nch l=0.15 w=1 nf=1 m=1
M11 net0 VB2 VSS VSS nch l=0.15 w=1 nf=1 m=1
M12 net3 VB1 VDD VDD pch l=0.15 w=1 nf=1 m=1
M13 VB1 VB1 VDD VDD pch l=0.15 w=1 nf=1 m=1
M14 net3 VREF net2 VSS nch l=0.15 w=1 nf=1 m=1
M15 VB1 VFP1 net2 VSS nch l=0.15 w=1 nf=1 m=1
M16 net2 net6 VSS VSS nch l=0.15 w=1 nf=1 m=1
M17 net6 net6 VSS VSS nch l=0.15 w=1 nf=1 m=1
M18 net6 net5 VDD VDD pch l=0.15 w=1 nf=1 m=1
M19 net5 net5 net7 VDD pch l=0.15 w=1 nf=1 m=1
M2 VX1 VC2 VIN VDD pch l=0.15 w=1 nf=1 m=1
M3 VX2 VC3 VIN VDD pch l=0.15 w=1 nf=1 m=1
M4 VX3 VC5 VP VDD pch l=0.15 w=1 nf=1 m=1
M5 VX3 VC4 VSS VSS nch l=0.15 w=1 nf=1 m=1
M6 VX1 net4 net1 VDD pch l=0.15 w=1 nf=1 m=1
M7 net4 net4 net1 VDD pch l=0.15 w=1 nf=1 m=1
M8 net0 net3 net1 VDD pch l=0.15 w=1 nf=1 m=1
M9 net4 net0 VSS VSS nch l=0.15 w=1 nf=1 m=1
R1 VP VFP1 1k
R2 VFP1 VSS 1k
R3 VDD net7 1k
R4 net5 VSS 1k
.ends dut
