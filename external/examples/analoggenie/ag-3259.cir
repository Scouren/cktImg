* official Analog Canvas netlist; PDK X cards rewritten by convert.py
.model nch nmos
.model pch pmos

.subckt dut VDD VSS vci phi1 phi2 vco VB1
C1 net2 net6 1p
C2 net5 vco 1p
M1 vci phi1 net2 VSS nch l=0.15 w=1 nf=1 m=1
M10 net0 net1 VSS VSS nch l=0.15 w=1 nf=1 m=1
M11 vco VX VSS VSS nch l=0.15 w=1 nf=1 m=1
M12 net0 net0 VDD VDD pch l=0.15 w=1 nf=1 m=1
M13 vco net0 VDD VDD pch l=0.15 w=1 nf=1 m=1
M14 VX VX VDD VDD pch l=0.15 w=1 nf=1 m=1
M15 net4 VX VDD VDD pch l=0.15 w=1 nf=1 m=1
M16 VX net4 VSS VSS nch l=0.15 w=1 nf=1 m=1
M17 net4 net4 VSS VSS nch l=0.15 w=1 nf=1 m=1
M18 VB2 VB2 VDD VDD pch l=0.15 w=1 nf=1 m=1
M19 VB1 VB2 VDD VDD pch l=0.15 w=1 nf=1 m=1
M2 net2 phi2 VSS VSS nch l=0.15 w=1 nf=1 m=1
M20 VB2 net4 VSS VSS nch l=0.15 w=1 nf=1 m=1
M21 VB1 VB1 VSS VSS nch l=0.15 w=1 nf=1 m=1
M3 net6 phi1 VSS VSS nch l=0.15 w=1 nf=1 m=1
M4 net6 phi2 net5 VSS nch l=0.15 w=1 nf=1 m=1
M5 net3 VB2 VDD VDD pch l=0.15 w=1 nf=1 m=1
M6 VX net5 net3 VDD pch l=0.15 w=1 nf=1 m=1
M7 net1 VSS net3 VDD pch l=0.15 w=1 nf=1 m=1
M8 VX VX VSS VSS nch l=0.15 w=1 nf=1 m=1
M9 net1 net1 VSS VSS nch l=0.15 w=1 nf=1 m=1
R1 VDD net4 1k
.ends dut
