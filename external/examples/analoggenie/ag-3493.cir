* official Analog Canvas netlist; PDK X cards rewritten by convert.py
.model nch nmos
.model pch pmos

.subckt opamp VDD VSS INN INP OUT
M10 OUT net2 VDD VDD pch l=0.15 w=1 nf=1 m=1
M11 net4 VB3 VSS VSS nch l=0.15 w=1 nf=1 m=1
M12 net3 net3 VSS VSS nch l=0.15 w=1 nf=1 m=1
M13 OUT net3 VSS VSS nch l=0.15 w=1 nf=1 m=1
M14 VBP VBP VDD VDD pch l=0.15 w=1 nf=1 m=1
M15 net7 VBP VDD VDD pch l=0.15 w=1 nf=1 m=1
M16 net7 net7 net6 VSS nch l=0.15 w=1 nf=1 m=1
M17 net6 net7 net1 VSS nch l=0.15 w=1 nf=1 m=1
M18 VBP net6 VSS VSS nch l=0.15 w=1 nf=1 m=1
M19 net5 VBP VDD VDD pch l=0.15 w=1 nf=1 m=1
M20 net5 net5 net1 VSS nch l=0.15 w=1 nf=1 m=1
M21 net1 net5 VB2 VSS nch l=0.15 w=1 nf=1 m=1
M22 VB2 VBP VDD VDD pch l=0.15 w=1 nf=1 m=1
M23 VB2 VB2 VSS VSS nch l=0.15 w=1 nf=1 m=1
M24 VB3 VBP VDD VDD pch l=0.15 w=1 nf=1 m=1
M25 VB3 VB3 VSS VSS nch l=0.15 w=1 nf=1 m=1
M26 VB1 VB1 VDD VDD pch l=0.15 w=1 nf=1 m=1
M27 VB1 VB3 VSS VSS nch l=0.15 w=1 nf=1 m=1
M5 net0 INN net4 VSS nch l=0.15 w=1 nf=1 m=1
M6 net2 INP net4 VSS nch l=0.15 w=1 nf=1 m=1
M7 net0 net0 VDD VDD pch l=0.15 w=1 nf=1 m=1
M8 net2 net2 VDD VDD pch l=0.15 w=1 nf=1 m=1
M9 net3 net0 VDD VDD pch l=0.15 w=1 nf=1 m=1
.ends opamp

.subckt comparator VDD VSS INP INN CLK OUT
M29 net0 CLK VDD VDD pch l=0.15 w=1 nf=1 m=1
M30 net1 CLK VDD VDD pch l=0.15 w=1 nf=1 m=1
M31 net1 OUT VDD VDD pch l=0.15 w=1 nf=1 m=1
M32 OUT net1 VDD VDD pch l=0.15 w=1 nf=1 m=1
M33 OUT CLK VDD VDD pch l=0.15 w=1 nf=1 m=1
M34 net1 OUT net0 VSS nch l=0.15 w=1 nf=1 m=1
M35 OUT net1 net2 VSS nch l=0.15 w=1 nf=1 m=1
M36 net0 INP net3 VSS nch l=0.15 w=1 nf=1 m=1
M37 net2 INN net3 VSS nch l=0.15 w=1 nf=1 m=1
M38 net3 CLK VSS VSS nch l=0.15 w=1 nf=1 m=1
M39 net2 CLK VDD VDD pch l=0.15 w=1 nf=1 m=1
.ends comparator

.subckt dut VDD VSS phi2 phi1 vout phic
C1 net1 net2 1p
C2 net0 vout 1p
C3 net0 vx 1p
M1 net0 phi2 net1 VSS nch l=0.15 w=1 nf=1 m=1
M2 net1 phi1 VSS VSS nch l=0.15 w=1 nf=1 m=1
M3 net2 phi2 VSS VSS nch l=0.15 w=1 nf=1 m=1
M4 net2 phi1 vout VSS nch l=0.15 w=1 nf=1 m=1
X1 VDD VSS net0 VSS vx opamp
X2 VDD VSS VSS vx phic vout comparator
.ends dut
