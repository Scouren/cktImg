* official Analog Canvas netlist; PDK X cards rewritten by convert.py
.model nch nmos

.subckt dut VDD VSS v1 v2 Iout1 Iout2
I1 net1 VSS DC 1m
I2 net0 VSS DC 1m
M1 Iout1 v1 net1 VSS nch l=0.15 w=1 nf=1 m=1
M2 VDD v1 net0 VSS nch l=0.15 w=1 nf=1 m=1
M3 VDD v2 net1 VSS nch l=0.15 w=1 nf=1 m=1
M4 Iout2 v2 net0 VSS nch l=0.15 w=1 nf=1 m=1
.ends dut
