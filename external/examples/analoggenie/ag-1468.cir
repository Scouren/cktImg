* official Analog Canvas netlist; PDK X cards rewritten by convert.py
.model nch nmos
.model pch pmos
.model qnpn npn

.subckt opamp VDD VSS INN INP VB1 VB2 VC OUT
M1 net5 net7 VDD VDD pch l=0.15 w=1 nf=1 m=1
M10 net0 VB1 net6 VDD pch l=0.15 w=1 nf=1 m=1
M11 net7 VB1 net5 VDD pch l=0.15 w=1 nf=1 m=1
M12 net3 VB1 net9 VDD pch l=0.15 w=1 nf=1 m=1
M13 net2 net0 VSS VSS nch l=0.15 w=1 nf=1 m=1
M14 OUT VC net4 VSS nch l=0.15 w=1 nf=1 m=1
M15 net4 net0 VSS VSS nch l=0.15 w=1 nf=1 m=1
M2 net9 net3 VDD VDD pch l=0.15 w=1 nf=1 m=1
M3 net3 INN net1 VSS nch l=0.15 w=1 nf=1 m=1
M4 net7 INP net1 VSS nch l=0.15 w=1 nf=1 m=1
M5 net8 net7 VDD VDD pch l=0.15 w=1 nf=1 m=1
M6 net6 net3 VDD VDD pch l=0.15 w=1 nf=1 m=1
M7 net1 VB2 VSS VSS nch l=0.15 w=1 nf=1 m=1
M8 net0 VC net2 VSS nch l=0.15 w=1 nf=1 m=1
M9 OUT VB1 net8 VDD pch l=0.15 w=1 nf=1 m=1
.ends opamp

.subckt dut VDD VSS Vout VB1 VB2
M16 VX VX VDD VDD pch l=0.15 w=1 nf=1 m=1
M17 VB3 VX VDD VDD pch l=0.15 w=1 nf=1 m=1
M18 net2 VX VDD VDD pch l=0.15 w=1 nf=1 m=1
M19 VC VX VDD VDD pch l=0.15 w=1 nf=1 m=1
M20 VX VB3 net0 VSS nch l=0.15 w=1 nf=1 m=1
M21 VB3 VB3 VSS VSS nch l=0.15 w=1 nf=1 m=1
M22 VC VC VQ2 VSS nch l=0.15 w=1 nf=1 m=1
M23 net0 net2 VSS VSS nch l=0.15 w=1 nf=1 m=1
M24 net2 net2 VSS VSS nch l=0.15 w=1 nf=1 m=1
M25 VQ2 VC VSS VSS nch l=0.15 w=1 nf=1 m=1
Q1 X X VSS VSS qnpn m=1
Q2 VQ2 VQ2 VSS VSS qnpn m=1
R1 Vout X 1k
R2 Vout Y 1k
R3 Y VQ2 1k
X1 VDD VSS Y X VB1 VB2 VC Vout opamp
.ends dut
