* official Analog Canvas netlist; PDK X cards rewritten by convert.py
.model nch nmos
.model pch pmos

.subckt dut VDD VSS GND vo1 vo2 Vout
VB1 net0 GND DC 1
M1 net1 vo1 VDD VDD pch l=0.15 w=1 nf=1 m=1
M2 net1 vo2 VDD VDD pch l=0.15 w=1 nf=1 m=1
M3 Vout net0 VDD VDD pch l=0.15 w=1 nf=1 m=1
M4 Vout net0 VDD VDD pch l=0.15 w=1 nf=1 m=1
M5 net1 net1 VSS VSS nch l=0.15 w=1 nf=1 m=1
M6 Vout net1 VSS VSS nch l=0.15 w=1 nf=1 m=1
.ends dut
