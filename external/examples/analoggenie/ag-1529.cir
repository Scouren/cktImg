* official Analog Canvas netlist; PDK X cards rewritten by convert.py
.model nch nmos
.model pch pmos
.model qnpn npn

.subckt dut VDD VSS Vout
M1 net5 net5 VDD VDD pch l=0.15 w=1 nf=1 m=1
M10 VBN net0 VDD VDD pch l=0.15 w=1 nf=1 m=1
M11 VBN VBN VSS VSS nch l=0.15 w=1 nf=1 m=1
M12 net0 net0 VDD VDD pch l=0.15 w=1 nf=1 m=1
M13 net0 net6 VSS VSS nch l=0.15 w=1 nf=1 m=1
M14 net3 net3 VDD VDD pch l=0.15 w=1 nf=1 m=1
M15 net3 net2 net6 VSS nch l=0.15 w=1 nf=1 m=1
M16 net2 net3 VDD VDD pch l=0.15 w=1 nf=1 m=1
M17 net2 net6 VSS VSS nch l=0.15 w=1 nf=1 m=1
M2 net1 net1 VDD VDD pch l=0.15 w=1 nf=1 m=1
M3 net1 Y net4 VSS nch l=0.15 w=1 nf=1 m=1
M4 net5 X net4 VSS nch l=0.15 w=1 nf=1 m=1
M5 Vout net5 VDD VDD pch l=0.15 w=1 nf=1 m=1
M6 Z net1 VDD VDD pch l=0.15 w=1 nf=1 m=1
M7 Vout Z VSS VSS nch l=0.15 w=1 nf=1 m=1
M8 Z Z VSS VSS nch l=0.15 w=1 nf=1 m=1
M9 net4 VBN VSS VSS nch l=0.15 w=1 nf=1 m=1
Q1 X X VSS VSS qnpn m=1
Q2 Z Z VSS VSS qnpn m=1
R1 Vout X 1k
R2 Vout Y 1k
R3 Y Z 1k
R4 net6 VSS 1k
.ends dut
