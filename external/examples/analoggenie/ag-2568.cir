* official Analog Canvas netlist; PDK X cards rewritten by convert.py
.model nch nmos
.model pch pmos

.subckt AMP1 VDD VSS INP INN OUT n1 n3
M10 net3 VB1 VDD VDD pch l=0.15 w=1 nf=1 m=1
M11 OUT VB3 net3 VDD pch l=0.15 w=1 nf=1 m=1
M12 OUT VX n1 VSS nch l=0.15 w=1 nf=1 m=1
M13 n1 n3 VSS VSS nch l=0.15 w=1 nf=1 m=1
M14 net5 INN net0 VSS nch l=0.15 w=1 nf=1 m=1
M15 net3 INP net0 VSS nch l=0.15 w=1 nf=1 m=1
M16 net0 VB2 VSS VSS nch l=0.15 w=1 nf=1 m=1
M17 VB4 net1 VDD VDD pch l=0.15 w=1 nf=1 m=1
M18 net1 net1 VDD VDD pch l=0.15 w=1 nf=1 m=1
M19 VB4 VB4 VSS VSS nch l=0.15 w=1 nf=1 m=1
M20 net1 VB4 VSS VSS nch l=0.15 w=1 nf=1 m=1
M21 VX net1 VDD VDD pch l=0.15 w=1 nf=1 m=1
M22 VX VX net4 VSS nch l=0.15 w=1 nf=1 m=1
M23 net4 VX VSS VSS nch l=0.15 w=1 nf=1 m=1
M6 net5 VB1 VDD VDD pch l=0.15 w=1 nf=1 m=1
M7 n3 VB3 net5 VDD pch l=0.15 w=1 nf=1 m=1
M8 n3 VX net2 VSS nch l=0.15 w=1 nf=1 m=1
M9 net2 n3 VSS VSS nch l=0.15 w=1 nf=1 m=1
.ends AMP1

.subckt dut VDD VSS biasp biascas biasn Vout Vref
C1 Vset VSS 1p
C2 n3 Vout 1p
M1 Vout n3 VDD VDD pch l=0.15 w=1 nf=1 m=1
M2 n1 Vset Vout VDD pch l=0.15 w=1 nf=1 m=1
M3 n1 biasn VSS VSS nch l=0.15 w=1 nf=1 m=1
M4 n3 biasp VDD VDD pch l=0.15 w=1 nf=1 m=1
M5 n3 biascas n1 VSS nch l=0.15 w=1 nf=1 m=1
R1 fb VSS 1k
R2 Vout fb 1k
X1 VDD VSS Vref fb Vset n1 n3 AMP1
.ends dut
