* official Analog Canvas netlist; PDK X cards rewritten by convert.py
.model nch nmos
.model pch pmos

.subckt dut VDD VSS phi1 vin+ vin- vout+ vout-
M1 net2 vin+ VSS VSS nch l=0.15 w=1 nf=1 m=1
M10 vout+ phi1 VDD VDD pch l=0.15 w=1 nf=1 m=1
M2 net0 vin- VSS VSS nch l=0.15 w=1 nf=1 m=1
M3 net3 vout+ net2 VSS nch l=0.15 w=1 nf=1 m=1
M4 net1 vout- net0 VSS nch l=0.15 w=1 nf=1 m=1
M5 vout- phi1 net3 VSS nch l=0.15 w=1 nf=1 m=1
M6 vout+ phi1 net1 VSS nch l=0.15 w=1 nf=1 m=1
M7 vout- vout+ VDD VDD pch l=0.15 w=1 nf=1 m=1
M8 vout+ vout- VDD VDD pch l=0.15 w=1 nf=1 m=1
M9 vout- phi1 VDD VDD pch l=0.15 w=1 nf=1 m=1
.ends dut
