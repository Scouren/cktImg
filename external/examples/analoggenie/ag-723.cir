* official Analog Canvas netlist; PDK X cards rewritten by convert.py
.model nch nmos

.subckt dut VDD VSS Vout
Iin VDD net0 DC 1m
M1 net4 net3 VSS VSS nch l=0.15 w=1 nf=1 m=1
M2 Vout net2 net4 VSS nch l=0.15 w=1 nf=1 m=1
M3 net1 net3 VSS VSS nch l=0.15 w=1 nf=1 m=1
M4 net3 net2 net1 VSS nch l=0.15 w=1 nf=1 m=1
M5 net2 net0 net3 VSS nch l=0.15 w=1 nf=1 m=1
M6 net0 net0 net2 VSS nch l=0.15 w=1 nf=1 m=1
.ends dut
