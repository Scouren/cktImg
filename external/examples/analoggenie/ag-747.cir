* official Analog Canvas netlist; PDK X cards rewritten by convert.py
.model qnpn npn

.subckt dut VDD VSS Vtrk Vout- Vout+ Vin+ Vin- Vltch
I1 net0 VSS DC 1m
Q1 net3 Vin+ net0 VSS qnpn m=1
Q2 net2 Vin- net0 VSS qnpn m=1
Q3 Vout- Vtrk net3 VSS qnpn m=1
Q4 Vout+ Vtrk net2 VSS qnpn m=1
Q5 net1 Vltch net3 VSS qnpn m=1
Q6 net1 Vltch net2 VSS qnpn m=1
Q7 Vout- Vout+ net1 VSS qnpn m=1
Q8 Vout+ Vout- net1 VSS qnpn m=1
R1 VDD Vout- 1k
R2 VDD Vout+ 1k
.ends dut
