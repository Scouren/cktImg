* official Analog Canvas netlist; PDK X cards rewritten by convert.py
.model nch nmos
.model pch pmos

.subckt Opamp VDD VSS VB1 VB2 INP INN OUT
M1 net0 VX VDD VDD pch l=0.15 w=1 nf=1 m=1
M10 OUT VB3 net4 VSS nch l=0.15 w=1 nf=1 m=1
M11 net1 VB4 VSS VSS nch l=0.15 w=1 nf=1 m=1
M12 net4 VB4 VSS VSS nch l=0.15 w=1 nf=1 m=1
M13 net3 net3 net6 VDD pch l=0.15 w=1 nf=1 m=1
M14 VB3 net3 VDD VDD pch l=0.15 w=1 nf=1 m=1
M15 VB3 VB3 VB4 VSS nch l=0.15 w=1 nf=1 m=1
M16 VB4 VB4 VSS VSS nch l=0.15 w=1 nf=1 m=1
M2 net2 VX VDD VDD pch l=0.15 w=1 nf=1 m=1
M3 net5 VB1 VDD VDD pch l=0.15 w=1 nf=1 m=1
M5 VX VB2 net0 VDD pch l=0.15 w=1 nf=1 m=1
M6 OUT VB2 net2 VDD pch l=0.15 w=1 nf=1 m=1
M7 net1 INP net5 net7 pch l=0.15 w=1 nf=1 m=1
M8 net4 INN net5 net7 pch l=0.15 w=1 nf=1 m=1
M9 VX VB3 net1 VSS nch l=0.15 w=1 nf=1 m=1
R4 VDD net6 1k
R5 net3 VSS 1k
.ends Opamp

.subckt dut VDD VSS VIN VB1 VB2 Vref VOUT
CL VOUT net0 1p
MNP VIN net1 VOUT VOUT nch l=0.15 w=1 nf=1 m=1
R1 VOUT FB 1k
R2 FB VSS 1k
R3 net0 VSS 1k
X1 VDD VSS VB1 VB2 Vref FB net1 Opamp
.ends dut
