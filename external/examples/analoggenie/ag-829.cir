* official Analog Canvas netlist; PDK X cards rewritten by convert.py
.model qnpn npn

.subckt dut VCC VSS vo
VB1 net2 VSS DC 5V
Q1 VCC net0 net1 VSS qnpn m=1
Q2 VCC net1 vo VSS qnpn m=1
R1 net1 vo 1kΩ
R2 vo VSS 50Ω
vi net0 net2 DC 1
.ends dut
