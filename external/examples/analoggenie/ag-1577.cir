* official Analog Canvas netlist; PDK X cards rewritten by convert.py
.model nch nmos
.model pch pmos
.model qpnp pnp

.subckt opamp VDD VSS INN INP OUT
M1 net4 VB1 VDD VDD pch l=0.15 w=1 nf=1 m=1
M10 net6 INP net1 VSS nch l=0.15 w=1 nf=1 m=1
M11 net1 VB6 VSS VSS nch l=0.15 w=1 nf=1 m=1
M12 VB5 VX VDD VDD pch l=0.15 w=1 nf=1 m=1
M13 VB5 VB5 VB6 VSS nch l=0.15 w=1 nf=1 m=1
M14 VB6 VB6 VSS VSS nch l=0.15 w=1 nf=1 m=1
M15 net0 VX VDD VDD pch l=0.15 w=1 nf=1 m=1
M16 VX VX VDD VDD pch l=0.15 w=1 nf=1 m=1
M17 VB4 VX VDD VDD pch l=0.15 w=1 nf=1 m=1
M18 net0 net0 VSS VSS nch l=0.15 w=1 nf=1 m=1
M19 VX VB4 VB3 VSS nch l=0.15 w=1 nf=1 m=1
M2 net6 VB1 VDD VDD pch l=0.15 w=1 nf=1 m=1
M20 VB3 net0 VSS VSS nch l=0.15 w=1 nf=1 m=1
M21 VB4 VB3 VSS VSS nch l=0.15 w=1 nf=1 m=1
M3 net5 VB2 net4 VDD pch l=0.15 w=1 nf=1 m=1
M4 OUT VB2 net6 VDD pch l=0.15 w=1 nf=1 m=1
M5 net5 VB5 net3 VSS nch l=0.15 w=1 nf=1 m=1
M6 OUT VB5 net2 VSS nch l=0.15 w=1 nf=1 m=1
M7 net3 net5 VSS VSS nch l=0.15 w=1 nf=1 m=1
M8 net2 net5 VSS VSS nch l=0.15 w=1 nf=1 m=1
M9 net4 INN net1 VSS nch l=0.15 w=1 nf=1 m=1
.ends opamp

.subckt dut VDD VSS Vout
Q1 VSS VSS X qpnp m=1
Q2 VSS VSS net0 qpnp m=1
R1 Vout X 1k
R2 Vout Y 1k
R3 Y net0 1k
X1 VDD VSS Y X Vout opamp
.ends dut
