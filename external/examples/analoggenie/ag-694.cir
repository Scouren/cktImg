* official Analog Canvas netlist; PDK X cards rewritten by convert.py
.model nch nmos

.subckt dut VDD VSS vi vo
Cs net0 VSS 1p
M1 vo vi net0 VSS nch l=0.15 w=1 nf=1 m=1
RL VDD vo 1k
Rs net0 VSS 1k
.ends dut
