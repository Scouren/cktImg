* official Analog Canvas netlist; PDK X cards rewritten by convert.py
.model nch nmos
.model pch pmos

.subckt dut VDD VSS Vout Vb1 GS1 GS2
L1 VDD Vout 1n
M1 Vout Vb1 net1 VSS nch l=0.15 w=1 nf=1 m=1
M2a Vout GS1 VDD VDD pch l=0.15 w=1 nf=1 m=1
M2b Vout GS2 VDD VDD pch l=0.15 w=1 nf=1 m=1
R1 VDD Vout 1k
RS net0 net1 1k
Vin net0 VSS DC 1
.ends dut
