* official Analog Canvas netlist; PDK X cards rewritten by convert.py
.model nch nmos

.subckt dut VDD VSS VIN VOUT
IIN VDD VIN DC 1m
M1 net0 net0 VSS VSS nch l=0.15 w=1 nf=1 m=1
M2 VOUT VIN net0 VSS nch l=0.15 w=1 nf=1 m=1
M3 net1 net0 VSS VSS nch l=0.15 w=1 nf=1 m=1
M4 VIN VIN net1 VSS nch l=0.15 w=1 nf=1 m=1
.ends dut
