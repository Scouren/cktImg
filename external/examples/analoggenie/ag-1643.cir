* official Analog Canvas netlist; PDK X cards rewritten by convert.py
.model nch nmos
.model pch pmos
.model qpnp pnp

.subckt opamp VDD VSS VB1 VB2 OUT VE VN VP
M1 net5 net6 VDD VDD pch l=0.15 w=1 nf=1 m=1
M10 VX VB1 net8 VDD pch l=0.15 w=1 nf=1 m=1
M11 net6 VB1 net5 VDD pch l=0.15 w=1 nf=1 m=1
M12 net3 VB1 net9 VDD pch l=0.15 w=1 nf=1 m=1
M13 OUT VB3 VE VSS nch l=0.15 w=1 nf=1 m=1
M14 VX VB3 net0 VSS nch l=0.15 w=1 nf=1 m=1
M15 VE VX VSS VSS nch l=0.15 w=1 nf=1 m=1
M16 net1 net1 VDD VDD pch l=0.15 w=1 nf=1 m=1
M17 VB3 net1 VDD VDD pch l=0.15 w=1 nf=1 m=1
M18 VB3 VB3 net4 VSS nch l=0.15 w=1 nf=1 m=1
M19 net4 VB3 VSS VSS nch l=0.15 w=1 nf=1 m=1
M2 net9 net3 VDD VDD pch l=0.15 w=1 nf=1 m=1
M3 net3 VN net7 VSS nch l=0.15 w=1 nf=1 m=1
M4 net6 VP net7 VSS nch l=0.15 w=1 nf=1 m=1
M5 net2 net6 VDD VDD pch l=0.15 w=1 nf=1 m=1
M6 net8 net3 VDD VDD pch l=0.15 w=1 nf=1 m=1
M7 net7 VB2 VSS VSS nch l=0.15 w=1 nf=1 m=1
M8 net0 VX VSS VSS nch l=0.15 w=1 nf=1 m=1
M9 OUT VB1 net2 VDD pch l=0.15 w=1 nf=1 m=1
R1 net1 VSS 1k
.ends opamp

.subckt dut VDD VSS Vout VB1 VB2
Q1 VSS VSS net1 qpnp m=1
Q2 net1 net1 X qpnp m=1
Q3 VSS VSS net2 qpnp m=1
Q4 net2 net2 net0 qpnp m=1
R1 Vout X 1k
R2 Vout Y 1k
R3 Y net0 1k
X1 VDD VSS VB1 VB2 Vout net0 Y X opamp
.ends dut
