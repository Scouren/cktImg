* official Analog Canvas netlist; PDK X cards rewritten by convert.py
.model nch nmos
.model pch pmos

.subckt bias VDD VSS VB
M13 VB VB1 VDD VDD pch l=0.15 w=1 nf=1 m=1
M14 VB1 VB1 VDD VDD pch l=0.15 w=1 nf=1 m=1
M15 VB VB VSS VSS nch l=0.15 w=1 nf=1 m=1
M16 VB1 net0 VSS VSS nch l=0.15 w=1 nf=1 m=1
M17 net0 VB2 VDD VDD pch l=0.15 w=1 nf=1 m=1
M18 net0 net0 VSS VSS nch l=0.15 w=1 nf=1 m=1
M19 VB2 VB2 VDD VDD pch l=0.15 w=1 nf=1 m=1
M20 net2 VB2 VDD VDD pch l=0.15 w=1 nf=1 m=1
M21 VB2 net0 net1 VSS nch l=0.15 w=1 nf=1 m=1
M22 net1 net2 VSS VSS nch l=0.15 w=1 nf=1 m=1
M23 net2 net2 VSS VSS nch l=0.15 w=1 nf=1 m=1
.ends bias

.subckt dut VDD VSS VREF VIN VOUT VERR
M1 net1 VEA VIN VDD pch l=0.15 w=1 nf=1 m=1
M10 VEA VEA VSS VSS nch l=0.15 w=1 nf=1 m=1
M11 net0 VEA net3 VSS nch l=0.15 w=1 nf=1 m=1
M12 net3 net4 VSS VSS nch l=0.15 w=1 nf=1 m=1
M2 VX VX net1 VDD pch l=0.15 w=1 nf=1 m=1
M3 VX nb VSS VSS nch l=0.15 w=1 nf=1 m=1
M4 net5 net5 VDD VDD pch l=0.15 w=1 nf=1 m=1
M5 VEA net5 VDD VDD pch l=0.15 w=1 nf=1 m=1
M6 VEA net0 VDD VDD pch l=0.15 w=1 nf=1 m=1
M7 net0 net0 VDD VDD pch l=0.15 w=1 nf=1 m=1
M8 net5 VREF net3 VSS nch l=0.15 w=1 nf=1 m=1
M9 VEA VEA VSS VSS nch l=0.15 w=1 nf=1 m=1
MBIAS VERR nb VSS VSS nch l=0.15 w=1 nf=1 m=1
MCHG net2 pb VIN VDD pch l=0.15 w=1 nf=1 m=1
MCTRL VERR VX VOUT VDD pch l=0.15 w=1 nf=1 m=1
MGEN net6 net6 VSS VSS nch l=0.15 w=1 nf=1 m=1
MINJ VERR net6 VSS VSS nch l=0.15 w=1 nf=1 m=1
MRES VOUT VERR VIN VDD pch l=0.15 w=1 nf=1 m=1
MSEN net6 VEA net2 VDD pch l=0.15 w=1 nf=1 m=1
X1 VDD VSS net4 bias
.ends dut
