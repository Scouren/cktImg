* official Analog Canvas netlist; PDK X cards rewritten by convert.py
.model pch pmos

.subckt dut VDD VSS Vcont
.model DIODE D(IS=1e-14 N=1)
D1 X Vcont DIODE
D2 Y Vcont DIODE
I1 VDD net0 DC 1m
L1 X VSS 1n
L2 Y VSS 1n
M1 X Y net0 VDD pch l=0.15 w=1 nf=1 m=1
M2 Y X net0 VDD pch l=0.15 w=1 nf=1 m=1
.ends dut
