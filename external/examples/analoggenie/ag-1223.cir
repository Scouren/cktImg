* official Analog Canvas netlist; PDK X cards rewritten by convert.py
.model nch nmos
.model pch pmos

.subckt dut VDD VSS VIN VCONT1 VCONT2 VCONT3 VCONT5 VCONT4 VP VB5 VB2 VB3
.model DIODE D(IS=1e-14 N=1)
CFLY VX1 VX2 1p
CO VP VN 1p
COP VP VSS 1p
D1 VN VX2 DIODE
L1 VX1 VX3 1n
M1 VX1 VCONT2 VIN VDD pch l=0.15 w=1 nf=1 m=1
M10 VX VX VSS VSS nch l=0.15 w=1 nf=1 m=1
M11 VX VB5 VSS VSS nch l=0.15 w=1 nf=1 m=1
M12 net2 VB1 VDD VDD pch l=0.15 w=1 nf=1 m=1
M13 net3 VB1 VDD VDD pch l=0.15 w=1 nf=1 m=1
M14 net1 VB3 net2 VDD pch l=0.15 w=1 nf=1 m=1
M15 VEA VB3 net3 VDD pch l=0.15 w=1 nf=1 m=1
M16 net2 VFP1 net6 VSS nch l=0.15 w=1 nf=1 m=1
M17 net3 VREF net6 VSS nch l=0.15 w=1 nf=1 m=1
M18 net6 VB2 VSS VSS nch l=0.15 w=1 nf=1 m=1
M19 net1 VBN VX VSS nch l=0.15 w=1 nf=1 m=1
M2 VX2 VCONT3 VIN VDD pch l=0.15 w=1 nf=1 m=1
M20 VEA VBN net5 VSS nch l=0.15 w=1 nf=1 m=1
M21 VX net1 VSS VSS nch l=0.15 w=1 nf=1 m=1
M22 net5 net1 VSS VSS nch l=0.15 w=1 nf=1 m=1
M23 VBN net7 VDD VDD pch l=0.15 w=1 nf=1 m=1
M24 net7 net7 VDD VDD pch l=0.15 w=1 nf=1 m=1
M25 VB4 net7 VDD VDD pch l=0.15 w=1 nf=1 m=1
M26 net7 VB4 VX2 VSS nch l=0.15 w=1 nf=1 m=1
M27 VB4 VB4 VSS VSS nch l=0.15 w=1 nf=1 m=1
M28 VBN VBN net4 VSS nch l=0.15 w=1 nf=1 m=1
M29 net4 VBN VSS VSS nch l=0.15 w=1 nf=1 m=1
M3 VP VCONT5 VX3 VDD pch l=0.15 w=1 nf=1 m=1
M4 VX3 VCONT4 VSS VSS nch l=0.15 w=1 nf=1 m=1
M5 net8 VCONT1 VIN VDD pch l=0.15 w=1 nf=1 m=1
M6 VX1 net0 net8 VDD pch l=0.15 w=1 nf=1 m=1
M7 net0 net0 net8 VDD pch l=0.15 w=1 nf=1 m=1
M8 VX VEA net8 VDD pch l=0.15 w=1 nf=1 m=1
M9 net0 VX VSS VSS nch l=0.15 w=1 nf=1 m=1
R1 VP VFP1 1k
R2 VFP1 VSS 1k
RBIAS VX2 VSS 1k
.ends dut
