* official Analog Canvas netlist; PDK X cards rewritten by convert.py
.model nch nmos
.model pch pmos
.model qpnp pnp

.subckt opamp VDD VSS VB2 VB1 INP INN Z OUT
M1 net2 VB1 VDD VDD pch l=0.15 w=1 nf=1 m=1
M10 Z VB5 VSS VSS nch l=0.15 w=1 nf=1 m=1
M11 net5 VB5 VSS VSS nch l=0.15 w=1 nf=1 m=1
M12 VB4 net4 VDD VDD pch l=0.15 w=1 nf=1 m=1
M13 net4 net4 VDD VDD pch l=0.15 w=1 nf=1 m=1
M14 VB3 net4 VDD VDD pch l=0.15 w=1 nf=1 m=1
M15 net4 VB3 VSS VSS nch l=0.15 w=1 nf=1 m=1
M16 net1 VB3 VSS VSS nch l=0.15 w=1 nf=1 m=1
M17 VB4 VB4 VB5 VSS nch l=0.15 w=1 nf=1 m=1
M18 VB5 VB5 VSS VSS nch l=0.15 w=1 nf=1 m=1
M2 Z INP net2 VDD pch l=0.15 w=1 nf=1 m=1
M3 net5 INN net2 VDD pch l=0.15 w=1 nf=1 m=1
M4 net3 net0 VDD VDD pch l=0.15 w=1 nf=1 m=1
M5 INP net0 VDD VDD pch l=0.15 w=1 nf=1 m=1
M6 net0 VB2 net3 VDD pch l=0.15 w=1 nf=1 m=1
M7 OUT VB2 INP VDD pch l=0.15 w=1 nf=1 m=1
M8 net0 VB4 Z VSS nch l=0.15 w=1 nf=1 m=1
M9 OUT VB4 net5 VSS nch l=0.15 w=1 nf=1 m=1
R4 VB3 net1 1k
.ends opamp

.subckt dut VDD VSS Vout VB1 VB2
Q1 VSS VSS Z qpnp m=1
Q2 Z Z X qpnp m=1
Q3 VSS VSS net1 qpnp m=1
Q4 net1 net1 net0 qpnp m=1
R1 Vout X 1k
R2 Vout Y 1k
R3 Y net0 1k
X1 VDD VSS VB2 VB1 X Y Z Vout opamp
.ends dut
