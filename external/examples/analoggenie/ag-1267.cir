* official Analog Canvas netlist; PDK X cards rewritten by convert.py
.model nch nmos
.model pch pmos

.subckt dut VDD VSS VG5 VG1 VG2 VG3 VG4 VIN VP VREF VB3 VB1 VB2
.model DIODE D(IS=1e-14 N=1)
CFLY VX1 VX2 1p
CO VP VN 1p
COP VP VSS 1p
D1 VN VX2 DIODE
L1 VX1 VX3 1n
M1 VX1 VG1 VIN VDD pch l=0.15 w=1 nf=1 m=1
M2 VX2 VG2 VIN VDD pch l=0.15 w=1 nf=1 m=1
M3 VP VG3 VX3 VDD pch l=0.15 w=1 nf=1 m=1
M4 VX3 VG4 VSS VSS nch l=0.15 w=1 nf=1 m=1
M5 VS5 VG5 VIN VDD pch l=0.15 w=1 nf=1 m=1
MN1 net4 VFP1 net6 VSS nch l=0.15 w=1 nf=1 m=1
MN10 VBN VBN VSS VSS nch l=0.15 w=1 nf=1 m=1
MN11 net1 net5 VSS VSS nch l=0.15 w=1 nf=1 m=1
MN12 net5 net5 VSS VSS nch l=0.15 w=1 nf=1 m=1
MN13 VB2 net5 VSS VSS nch l=0.15 w=1 nf=1 m=1
MN2 VX3 VREF net6 VSS nch l=0.15 w=1 nf=1 m=1
MN3 net3 net3 VSS VSS nch l=0.15 w=1 nf=1 m=1
MN4 net6 VBN VSS VSS nch l=0.15 w=1 nf=1 m=1
MN5 VCTRL net3 VSS VSS nch l=0.15 w=1 nf=1 m=1
MN6 net2 net0 VSS VSS nch l=0.15 w=1 nf=1 m=1
MN7 net0 net0 VSS VSS nch l=0.15 w=1 nf=1 m=1
MN8 net0 VB3 VSS VSS nch l=0.15 w=1 nf=1 m=1
MN9 VB1 VBN VSS VSS nch l=0.15 w=1 nf=1 m=1
MP1 net4 net4 VDD VDD pch l=0.15 w=1 nf=1 m=1
MP10 net5 VB2 VDD VDD pch l=0.15 w=1 nf=1 m=1
MP11 VB2 VB2 VDD VDD pch l=0.15 w=1 nf=1 m=1
MP12 VCTRL VX3 VDD VDD pch l=0.15 w=1 nf=1 m=1
MP2 net3 net4 VDD VDD pch l=0.15 w=1 nf=1 m=1
MP3 VX3 VX3 VDD VDD pch l=0.15 w=1 nf=1 m=1
MP4 net2 net2 VS5 VDD pch l=0.15 w=1 nf=1 m=1
MP5 VX1 net2 VS5 VDD pch l=0.15 w=1 nf=1 m=1
MP6 net0 VCTRL VS5 VDD pch l=0.15 w=1 nf=1 m=1
MP7 VB1 VB1 VDD VDD pch l=0.15 w=1 nf=1 m=1
MP8 VBN net1 VDD VDD pch l=0.15 w=1 nf=1 m=1
MP9 net1 net1 VDD VDD pch l=0.15 w=1 nf=1 m=1
R1 VP VFP1 1k
R2 VFP1 VSS 1k
.ends dut
