* official Analog Canvas netlist; PDK X cards rewritten by convert.py
.model nch nmos

.subckt dut VDD VSS iOUT VB1 VB2
IIN VDD net1 DC 1m
M1 net0 VDD VSS net0 nch l=0.15 w=1 nf=1 m=1
M2 net2 VDD VSS net0 nch l=0.15 w=1 nf=1 m=1
M3 net1 VB1 net0 net1 nch l=0.15 w=1 nf=1 m=1
M4 iOUT VB2 net2 net1 nch l=0.15 w=1 nf=1 m=1
.ends dut
