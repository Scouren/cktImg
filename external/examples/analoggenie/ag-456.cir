* official Analog Canvas netlist; PDK X cards rewritten by convert.py
.model nch nmos
.model pch pmos

.subckt dut VDD VSS Vb Vin Vout
I1 Vin VSS DC 1m
M1 net0 Vb Vin VSS nch l=0.15 w=1 nf=1 m=1
M2 Vin net0 VDD Vout pch l=0.15 w=1 nf=1 m=1
RD VDD net0 1k
.ends dut
