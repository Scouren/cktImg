* official Analog Canvas netlist; PDK X cards rewritten by convert.py
.model nch nmos
.model pch pmos

.subckt AEA VDD VSS OUT VB1 VB2 VREF VC
M10 net5 VC VSS VSS nch l=0.15 w=1 nf=1 m=1
M11 net4 VC VSS VSS nch l=0.15 w=1 nf=1 m=1
M12 net0 OUT net6 VSS nch l=0.15 w=1 nf=1 m=1
M13 net1 VREF net6 VSS nch l=0.15 w=1 nf=1 m=1
M14 net6 VBN VSS VSS nch l=0.15 w=1 nf=1 m=1
M15 VCN net2 VDD VDD pch l=0.15 w=1 nf=1 m=1
M16 VCN VCN VBN VSS nch l=0.15 w=1 nf=1 m=1
M17 VBN VBN VSS VSS nch l=0.15 w=1 nf=1 m=1
M18 net2 net2 VDD VDD pch l=0.15 w=1 nf=1 m=1
M19 net2 VB3 VSS VSS nch l=0.15 w=1 nf=1 m=1
M20 VB3 net2 VDD VDD pch l=0.15 w=1 nf=1 m=1
M21 net3 VB3 VSS VSS nch l=0.15 w=1 nf=1 m=1
M4 net1 VB1 VDD VDD pch l=0.15 w=1 nf=1 m=1
M5 net0 VB1 VDD VDD pch l=0.15 w=1 nf=1 m=1
M6 OUT VB2 net1 VDD pch l=0.15 w=1 nf=1 m=1
M7 VC VB2 net0 VDD pch l=0.15 w=1 nf=1 m=1
M8 OUT VCN net5 VSS nch l=0.15 w=1 nf=1 m=1
M9 VC VCN net4 VSS nch l=0.15 w=1 nf=1 m=1
R1 VB3 net3 1k
.ends AEA

.subckt dut VDD VSS VREF VIN pb nb VOUT VERR VB1 VB2
M1 net2 VEAOUT VIN VDD pch l=0.15 w=1 nf=1 m=1
M2 VC VC net2 VDD pch l=0.15 w=1 nf=1 m=1
M3 VC nb VSS VSS nch l=0.15 w=1 nf=1 m=1
MBIAS VERR nb VSS VSS nch l=0.15 w=1 nf=1 m=1
MCHG net0 pb VIN VDD pch l=0.15 w=1 nf=1 m=1
MCTRL VERR VC VOUT VDD pch l=0.15 w=1 nf=1 m=1
MGEN net1 net1 VSS VSS nch l=0.15 w=1 nf=1 m=1
MINJ VERR net1 VSS VSS nch l=0.15 w=1 nf=1 m=1
MRES VOUT VERR VIN VDD pch l=0.15 w=1 nf=1 m=1
MSEN net1 VEAOUT net0 VDD pch l=0.15 w=1 nf=1 m=1
X1 VDD VSS VEAOUT VB1 VB2 VREF VC AEA
.ends dut
