* official Analog Canvas netlist; PDK X cards rewritten by convert.py
.model nch nmos
.model pch pmos

.subckt AMP1 VDD VSS N3 INN INP OUT
M10 net2 VB2 net0 VDD pch l=0.15 w=1 nf=1 m=1
M11 net2 VC net5 VSS nch l=0.15 w=1 nf=1 m=1
M12 net5 VN VSS VSS nch l=0.15 w=1 nf=1 m=1
M13 net3 net2 VDD VDD pch l=0.15 w=1 nf=1 m=1
M14 OUT VB2 net3 VDD pch l=0.15 w=1 nf=1 m=1
M15 OUT VC VX VSS nch l=0.15 w=1 nf=1 m=1
M16 VX VN VSS VSS nch l=0.15 w=1 nf=1 m=1
M17 VC VP VDD VDD pch l=0.15 w=1 nf=1 m=1
M18 VC VC VN VSS nch l=0.15 w=1 nf=1 m=1
M19 VN VN VSS VSS nch l=0.15 w=1 nf=1 m=1
M20 VP VP VDD VDD pch l=0.15 w=1 nf=1 m=1
M21 VP net6 net1 VSS nch l=0.15 w=1 nf=1 m=1
M22 net1 net4 VSS VSS nch l=0.15 w=1 nf=1 m=1
M23 net6 VP VDD VDD pch l=0.15 w=1 nf=1 m=1
M24 net6 net6 VSS VSS nch l=0.15 w=1 nf=1 m=1
M25 net4 VP VDD VDD pch l=0.15 w=1 nf=1 m=1
M26 net4 net4 VSS VSS nch l=0.15 w=1 nf=1 m=1
M6 N3 VB1 VDD VDD pch l=0.15 w=1 nf=1 m=1
M7 VX INN N3 VDD pch l=0.15 w=1 nf=1 m=1
M8 net5 INP N3 VDD pch l=0.15 w=1 nf=1 m=1
M9 net0 net2 VDD VDD pch l=0.15 w=1 nf=1 m=1
.ends AMP1

.subckt dut VDD VSS Vref Vout biasp biascas biasn
C1 Vset VSS 1p
C2 n3 Vout 1p
M1 Vout n3 VDD VDD pch l=0.15 w=1 nf=1 m=1
M2 n1 Vset Vout VDD pch l=0.15 w=1 nf=1 m=1
M3 n1 biasn VSS VSS nch l=0.15 w=1 nf=1 m=1
M4 n3 biasp VDD VDD pch l=0.15 w=1 nf=1 m=1
M5 n3 biascas n1 VSS nch l=0.15 w=1 nf=1 m=1
R1 fb VSS 1k
R2 Vout fb 1k
X1 VDD VSS n3 fb Vref Vset AMP1
.ends dut
