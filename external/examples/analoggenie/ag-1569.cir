* official Analog Canvas netlist; PDK X cards rewritten by convert.py
.model nch nmos
.model pch pmos
.model qpnp pnp

.subckt opamp VDD VSS INN INP OUT VB1 VB2
M1 net3 VB1 VDD VDD pch l=0.15 w=1 nf=1 m=1
M10 net0 INP net2 VSS nch l=0.15 w=1 nf=1 m=1
M11 net2 VB5 VSS VSS nch l=0.15 w=1 nf=1 m=1
M12 VB4 net4 VDD VDD pch l=0.15 w=1 nf=1 m=1
M13 VB4 VB4 VB5 VSS nch l=0.15 w=1 nf=1 m=1
M14 VB5 VB5 VSS VSS nch l=0.15 w=1 nf=1 m=1
M15 net4 net4 VDD VDD pch l=0.15 w=1 nf=1 m=1
M16 net4 VB3 VSS VSS nch l=0.15 w=1 nf=1 m=1
M17 VB3 net4 VDD VDD pch l=0.15 w=1 nf=1 m=1
M18 VB3 VB3 VSS VSS nch l=0.15 w=1 nf=1 m=1
M2 net0 VB1 VDD VDD pch l=0.15 w=1 nf=1 m=1
M3 net1 VB2 net3 VDD pch l=0.15 w=1 nf=1 m=1
M4 OUT VB2 net0 VDD pch l=0.15 w=1 nf=1 m=1
M5 net1 VB4 net6 VSS nch l=0.15 w=1 nf=1 m=1
M6 OUT VB4 net5 VSS nch l=0.15 w=1 nf=1 m=1
M7 net6 net1 VSS VSS nch l=0.15 w=1 nf=1 m=1
M8 net5 net1 VSS VSS nch l=0.15 w=1 nf=1 m=1
M9 net3 INN net2 VSS nch l=0.15 w=1 nf=1 m=1
.ends opamp

.subckt dut VDD VSS Vout VB1 VB2
Q1 VSS VSS X qpnp m=1
Q2 VSS VSS net0 qpnp m=1
R1 Vout X 1k
R2 Vout Y 1k
R3 Y net0 1k
X1 VDD VSS Y X Vout VB1 VB2 opamp
.ends dut
