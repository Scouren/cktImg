* official Analog Canvas netlist; PDK X cards rewritten by convert.py
.model nch nmos
.model pch pmos
.model qpnp pnp

.subckt opamp VDD VSS INP INN OUT VB1 VB2 VB3
M1 INP VB1 VDD VDD pch l=0.15 w=1 nf=1 m=1
M10 net1 net5 VSS VSS nch l=0.15 w=1 nf=1 m=1
M11 net0 net5 VSS VSS nch l=0.15 w=1 nf=1 m=1
M12 net4 net4 VDD VDD pch l=0.15 w=1 nf=1 m=1
M13 VB4 net4 VDD VDD pch l=0.15 w=1 nf=1 m=1
M14 VB4 VB4 net2 VSS nch l=0.15 w=1 nf=1 m=1
M15 net2 VB4 VSS VSS nch l=0.15 w=1 nf=1 m=1
M2 net3 VB1 VDD VDD pch l=0.15 w=1 nf=1 m=1
M3 net5 VB3 INP VDD pch l=0.15 w=1 nf=1 m=1
M4 OUT VB3 net3 VDD pch l=0.15 w=1 nf=1 m=1
M5 INP INP net6 VSS nch l=0.15 w=1 nf=1 m=1
M6 net3 INN net6 VSS nch l=0.15 w=1 nf=1 m=1
M7 net6 VB2 VSS VSS nch l=0.15 w=1 nf=1 m=1
M8 net5 VB4 net1 VSS nch l=0.15 w=1 nf=1 m=1
M9 OUT VB4 net0 VSS nch l=0.15 w=1 nf=1 m=1
R4 net4 VSS 1k
.ends opamp

.subckt dut VDD VSS Vout VB1 VB2 VB3
Q1 VSS VSS net2 qpnp m=1
Q2 net2 net2 net0 qpnp m=1
Q3 VSS VSS net1 qpnp m=1
Q4 net1 net1 Y qpnp m=1
R1 Vout X 1k
R2 Vout Y 1k
R3 X net0 1k
X1 VDD VSS X Y Vout VB1 VB2 VB3 opamp
.ends dut
