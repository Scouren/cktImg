* official Analog Canvas netlist; PDK X cards rewritten by convert.py
.model qnpn npn

.subckt dut VSS Vout1 Vout2
I1 net2 VSS DC 1mA
I2 net1 VSS DC 50uA
I3 net0 VSS DC 50uA
Q1 Vout1 VSS net1 VSS qnpn m=1
Q2 Vout2 net1 net2 VSS qnpn m=1
Q3 Vout1 net0 net2 VSS qnpn m=1
Q4 Vout2 VSS net0 VSS qnpn m=1
.ends dut
