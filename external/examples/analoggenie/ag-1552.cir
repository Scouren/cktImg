* official Analog Canvas netlist; PDK X cards rewritten by convert.py
.model nch nmos
.model pch pmos
.model qpnp pnp

.subckt opamp VDD VSS INN INP OUT VB1 VB2
M1 net3 INN net11 VSS nch l=0.15 w=1 nf=1 m=1
M10 net0 VB1 net12 VDD pch l=0.15 w=1 nf=1 m=1
M11 OUT VB1 net2 VDD pch l=0.15 w=1 nf=1 m=1
M12 net0 VB4 net1 VSS nch l=0.15 w=1 nf=1 m=1
M13 OUT VB4 net9 VSS nch l=0.15 w=1 nf=1 m=1
M14 net1 net0 VSS VSS nch l=0.15 w=1 nf=1 m=1
M15 net9 net0 VSS VSS nch l=0.15 w=1 nf=1 m=1
M16 VB4 net4 VDD VDD pch l=0.15 w=1 nf=1 m=1
M17 VB4 VB4 net10 VSS nch l=0.15 w=1 nf=1 m=1
M18 net10 VB4 VSS VSS nch l=0.15 w=1 nf=1 m=1
M19 net4 net4 VDD VDD pch l=0.15 w=1 nf=1 m=1
M2 net7 INP net11 VSS nch l=0.15 w=1 nf=1 m=1
M20 net4 VB3 VSS VSS nch l=0.15 w=1 nf=1 m=1
M21 VB3 net4 VDD VDD pch l=0.15 w=1 nf=1 m=1
M22 net8 VB3 VSS VSS nch l=0.15 w=1 nf=1 m=1
M3 net11 VB2 VSS VSS nch l=0.15 w=1 nf=1 m=1
M4 net6 net3 VDD VDD pch l=0.15 w=1 nf=1 m=1
M5 net5 net7 VDD VDD pch l=0.15 w=1 nf=1 m=1
M6 net12 net3 VDD VDD pch l=0.15 w=1 nf=1 m=1
M7 net2 net7 VDD VDD pch l=0.15 w=1 nf=1 m=1
M8 net3 VB1 net6 VDD pch l=0.15 w=1 nf=1 m=1
M9 net7 VB1 net5 VDD pch l=0.15 w=1 nf=1 m=1
R4 VB3 net8 1k
.ends opamp

.subckt dut VDD VSS Vout VB1 VB2
Q1 VSS VSS X qpnp m=1
Q2 VSS VSS net0 qpnp m=1
R1 Vout X 1k
R2 Vout Y 1k
R3 Y net0 1k
X1 VDD VSS Y X Vout VB1 VB2 opamp
.ends dut
