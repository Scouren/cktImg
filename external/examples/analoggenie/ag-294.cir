* official Analog Canvas netlist; PDK X cards rewritten by convert.py
.model nch nmos
.model pch pmos

.subckt dut VDD VSS Vb3 Vb2 Vb1 Vb4 Vout1 Vout2 Vin1 Vin2
ISS VDD net1 DC 1m
M1 X Vin1 net1 VDD pch l=0.15 w=1 nf=1 m=1
M10 net0 Vb3 VDD VDD pch l=0.15 w=1 nf=1 m=1
M2 Y Vin2 net1 VDD pch l=0.15 w=1 nf=1 m=1
M3 Vout1 Vb1 X VSS nch l=0.15 w=1 nf=1 m=1
M4 Vout2 Vb1 Y VSS nch l=0.15 w=1 nf=1 m=1
M5 X Vb4 VSS VSS nch l=0.15 w=1 nf=1 m=1
M6 Y Vb4 VSS VSS nch l=0.15 w=1 nf=1 m=1
M7 Vout1 Vb2 net2 VDD pch l=0.15 w=1 nf=1 m=1
M8 Vout2 Vb2 net0 VDD pch l=0.15 w=1 nf=1 m=1
M9 net2 Vb3 VDD VDD pch l=0.15 w=1 nf=1 m=1
.ends dut
