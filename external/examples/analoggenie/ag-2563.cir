* official Analog Canvas netlist; PDK X cards rewritten by convert.py
.model nch nmos
.model pch pmos

.subckt AMP1 VDD VSS INN INP OUT n1 n3
M10 n3 VB2 net3 VDD pch l=0.15 w=1 nf=1 m=1
M11 OUT VCN n1 VSS nch l=0.15 w=1 nf=1 m=1
M12 n3 VCN net2 VSS nch l=0.15 w=1 nf=1 m=1
M13 n1 n3 VSS VSS nch l=0.15 w=1 nf=1 m=1
M14 net2 n3 VSS VSS nch l=0.15 w=1 nf=1 m=1
M15 net4 INP net1 VSS nch l=0.15 w=1 nf=1 m=1
M16 net1 VBN VSS VSS nch l=0.15 w=1 nf=1 m=1
M17 n3 net5 VDD VDD pch l=0.15 w=1 nf=1 m=1
M18 net5 net5 VDD VDD pch l=0.15 w=1 nf=1 m=1
M19 VCN net5 VDD VDD pch l=0.15 w=1 nf=1 m=1
M20 net5 n3 net0 VSS nch l=0.15 w=1 nf=1 m=1
M21 n3 net0 VSS VSS nch l=0.15 w=1 nf=1 m=1
M22 VCN VCN VBN VSS nch l=0.15 w=1 nf=1 m=1
M23 VBN VBN VSS VSS nch l=0.15 w=1 nf=1 m=1
M6 net3 INN net1 VSS nch l=0.15 w=1 nf=1 m=1
M7 net4 VB1 VDD VDD pch l=0.15 w=1 nf=1 m=1
M8 net3 VB1 VDD VDD pch l=0.15 w=1 nf=1 m=1
M9 OUT VB2 net4 VDD pch l=0.15 w=1 nf=1 m=1
R3 net0 VSS 1k
.ends AMP1

.subckt dut VDD VSS Vref Vout biasp biascas biasn
C1 Vset VSS 1p
C2 n3 Vout 1p
M1 Vout n3 VDD VDD pch l=0.15 w=1 nf=1 m=1
M2 n1 Vset Vout VDD pch l=0.15 w=1 nf=1 m=1
M3 n1 biasn VSS VSS nch l=0.15 w=1 nf=1 m=1
M4 n3 biasp VDD VDD pch l=0.15 w=1 nf=1 m=1
M5 n3 biascas n1 VSS nch l=0.15 w=1 nf=1 m=1
R1 fb VSS 1k
R2 Vout fb 1k
X1 VDD VSS fb Vref Vset n1 n3 AMP1
.ends dut
