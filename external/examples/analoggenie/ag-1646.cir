* official Analog Canvas netlist; PDK X cards rewritten by convert.py
.model nch nmos
.model pch pmos
.model qpnp pnp

.subckt dut VDD VSS Vout VB2
M1 net3 X net5 VSS nch l=0.15 w=1 nf=1 m=1
M10 net4 VB4 net7 VSS nch l=0.15 w=1 nf=1 m=1
M11 net7 net4 VSS VSS nch l=0.15 w=1 nf=1 m=1
M12 net6 VA VDD VDD pch l=0.15 w=1 nf=1 m=1
M13 Vout VB1 net6 VDD pch l=0.15 w=1 nf=1 m=1
M14 Vout VB4 VE VSS nch l=0.15 w=1 nf=1 m=1
M15 VE net4 VSS VSS nch l=0.15 w=1 nf=1 m=1
M16 VB3 net10 VDD VDD pch l=0.15 w=1 nf=1 m=1
M17 net10 net10 VDD VDD pch l=0.15 w=1 nf=1 m=1
M18 VB4 net10 VDD VDD pch l=0.15 w=1 nf=1 m=1
M19 VB3 VB3 VSS VSS nch l=0.15 w=1 nf=1 m=1
M2 VA Y net5 VSS nch l=0.15 w=1 nf=1 m=1
M20 net10 VB3 net12 VSS nch l=0.15 w=1 nf=1 m=1
M21 VB4 VB4 net1 VSS nch l=0.15 w=1 nf=1 m=1
M22 net1 VB4 VSS VSS nch l=0.15 w=1 nf=1 m=1
M3 net5 VB2 VSS VSS nch l=0.15 w=1 nf=1 m=1
M4 net2 net3 VDD VDD pch l=0.15 w=1 nf=1 m=1
M5 net9 VA VDD VDD pch l=0.15 w=1 nf=1 m=1
M6 net3 VB1 net2 VDD pch l=0.15 w=1 nf=1 m=1
M7 VA VB1 net9 VDD pch l=0.15 w=1 nf=1 m=1
M8 net8 net3 VDD VDD pch l=0.15 w=1 nf=1 m=1
M9 net4 VB1 net8 VDD pch l=0.15 w=1 nf=1 m=1
Q1 VSS VSS net11 qpnp m=1
Q2 net11 net11 VE qpnp m=1
Q3 VSS VSS net0 qpnp m=1
Q4 net0 net0 Y qpnp m=1
R1 Vout X 1k
R2 Vout Y 1k
R3 X VE 1k
R4 net12 VSS 1k
.ends dut
