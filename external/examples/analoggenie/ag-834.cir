* official Analog Canvas netlist; PDK X cards rewritten by convert.py
.model qnpn npn

.subckt dut VCC VSS IOUT1 IOUT2
IIN VCC net3 DC 1m
Q1 net3 net0 net1 VSS qnpn m=1
Q2 VCC net3 net0 VSS qnpn m=1
Q3 IOUT1 net0 net2 VSS qnpn m=1
Q4 IOUT2 net0 net4 VSS qnpn m=1
R1 net1 VSS 1k
R3 net2 VSS 1k
R4 net4 VSS 1k
.ends dut
