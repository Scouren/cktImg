* official Analog Canvas netlist; PDK X cards rewritten by convert.py
.model nch nmos
.model pch pmos
.model qpnp pnp

.subckt opamp VDD VSS OUT INN INP VE
M10 VE INP net3 VDD pch l=0.15 w=1 nf=1 m=1
M11 VX VB1 net4 VDD pch l=0.15 w=1 nf=1 m=1
M12 OUT VB4 net7 VSS nch l=0.15 w=1 nf=1 m=1
M13 net10 VB4 net0 VSS nch l=0.15 w=1 nf=1 m=1
M14 VE VB4 net2 VSS nch l=0.15 w=1 nf=1 m=1
M15 VX VB4 net5 VSS nch l=0.15 w=1 nf=1 m=1
M16 net7 net10 VSS VSS nch l=0.15 w=1 nf=1 m=1
M17 net0 net10 VSS VSS nch l=0.15 w=1 nf=1 m=1
M18 net2 VE VSS VSS nch l=0.15 w=1 nf=1 m=1
M19 net5 VE VSS VSS nch l=0.15 w=1 nf=1 m=1
M20 VB4 net8 VDD VDD pch l=0.15 w=1 nf=1 m=1
M21 net8 net8 VDD VDD pch l=0.15 w=1 nf=1 m=1
M22 VB3 net8 VDD VDD pch l=0.15 w=1 nf=1 m=1
M23 VB4 VB4 net6 VSS nch l=0.15 w=1 nf=1 m=1
M24 net8 VB3 net9 VSS nch l=0.15 w=1 nf=1 m=1
M25 VB3 VB3 VSS VSS nch l=0.15 w=1 nf=1 m=1
M26 net6 VB4 VSS VSS nch l=0.15 w=1 nf=1 m=1
M5 net1 VX VDD VDD pch l=0.15 w=1 nf=1 m=1
M6 net3 VB2 VDD VDD pch l=0.15 w=1 nf=1 m=1
M7 net4 VX VDD VDD pch l=0.15 w=1 nf=1 m=1
M8 OUT VB1 net1 VDD pch l=0.15 w=1 nf=1 m=1
M9 net10 INN net3 VDD pch l=0.15 w=1 nf=1 m=1
R3 net9 VSS 1k
.ends opamp

.subckt dut VDD VSS Vout
M1 net0 net1 VDD VDD pch l=0.15 w=1 nf=1 m=1
M2 Vout net1 VDD VDD pch l=0.15 w=1 nf=1 m=1
M3 net3 net1 VDD VDD pch l=0.15 w=1 nf=1 m=1
M4 net4 net1 VDD VDD pch l=0.15 w=1 nf=1 m=1
Q1 VSS VSS net3 qpnp m=1
Q2 VSS net3 net0 qpnp m=1
Q3 VSS VSS net4 qpnp m=1
Q4 VSS net4 VE qpnp m=1
R1 net2 VE 1k
R2 Vout net2 1k
X1 VDD VSS net1 net0 net2 VE opamp
.ends dut
