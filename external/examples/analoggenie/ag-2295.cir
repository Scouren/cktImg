* official Analog Canvas netlist; PDK X cards rewritten by convert.py
.model nch nmos
.model pch pmos

.subckt dut VDD VSS VB1 VB2 VREF VB4 IBUF VIN VOUT VB3
CL VOUT net0 1p
M1 VB6 VB6 VSS VSS nch l=0.15 w=1 nf=1 m=1
M10 EAO VB2 net9 VDD pch l=0.15 w=1 nf=1 m=1
M11 net11 VB1 VDD VDD pch l=0.15 w=1 nf=1 m=1
M12 net9 VB1 VDD VDD pch l=0.15 w=1 nf=1 m=1
M13 net12 VB4 VDD VDD pch l=0.15 w=1 nf=1 m=1
M14 net7 EAO net12 VDD pch l=0.15 w=1 nf=1 m=1
M15 net7 net7 VSS VSS nch l=0.15 w=1 nf=1 m=1
M16 GATE net7 VSS VSS nch l=0.15 w=1 nf=1 m=1
M17 VDD net12 GATE VSS nch l=0.15 w=1 nf=1 m=1
M18 net6 EAO IBUF VSS nch l=0.15 w=1 nf=1 m=1
M19 net6 net6 VDD VDD pch l=0.15 w=1 nf=1 m=1
M2 net10 VB6 VSS VSS nch l=0.15 w=1 nf=1 m=1
M20 GATE net6 VDD VDD pch l=0.15 w=1 nf=1 m=1
M21 VSS IBUF GATE VDD pch l=0.15 w=1 nf=1 m=1
M22 VB5 VB5 VB6 VSS nch l=0.15 w=1 nf=1 m=1
M23 VB5 VBP VDD VDD pch l=0.15 w=1 nf=1 m=1
M24 VBP VBP VDD VDD pch l=0.15 w=1 nf=1 m=1
M25 VBP net1 VSS VSS nch l=0.15 w=1 nf=1 m=1
M26 net5 VBP VDD VDD pch l=0.15 w=1 nf=1 m=1
M27 net5 net5 net1 VSS nch l=0.15 w=1 nf=1 m=1
M28 net1 net5 net13 VSS nch l=0.15 w=1 nf=1 m=1
M29 net4 VBP VDD VDD pch l=0.15 w=1 nf=1 m=1
M3 net9 VREF net10 VSS nch l=0.15 w=1 nf=1 m=1
M30 net4 net4 net13 VSS nch l=0.15 w=1 nf=1 m=1
M31 net13 net4 VB3 VSS nch l=0.15 w=1 nf=1 m=1
M32 VB3 VBP VDD VDD pch l=0.15 w=1 nf=1 m=1
M33 VB3 VB3 VSS VSS nch l=0.15 w=1 nf=1 m=1
M4 net11 FB net10 VSS nch l=0.15 w=1 nf=1 m=1
M5 net3 net8 VSS VSS nch l=0.15 w=1 nf=1 m=1
M6 net2 net8 VSS VSS nch l=0.15 w=1 nf=1 m=1
M7 net8 VB5 net3 VSS nch l=0.15 w=1 nf=1 m=1
M8 EAO VB5 net2 VSS nch l=0.15 w=1 nf=1 m=1
M9 net8 VB2 net11 VDD pch l=0.15 w=1 nf=1 m=1
MNP VIN GATE VOUT VSS nch l=0.15 w=1 nf=1 m=1
R1 FB VSS 1k
R2 VOUT FB 1k
R3 net0 VSS 1k
RL VOUT VSS 1k
.ends dut
