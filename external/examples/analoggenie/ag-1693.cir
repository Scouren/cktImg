* official Analog Canvas netlist; PDK X cards rewritten by convert.py
.model nch nmos
.model pch pmos
.model qpnp pnp

.subckt dut VDD VSS Vout VB1 VB3 VB2 VB4
M1 net3 VC VDD VDD pch l=0.15 w=1 nf=1 m=1
M10 Z X net7 VDD pch l=0.15 w=1 nf=1 m=1
M11 net4 Y net7 VDD pch l=0.15 w=1 nf=1 m=1
M12 VN VP VDD VDD pch l=0.15 w=1 nf=1 m=1
M13 VN VN net0 VSS nch l=0.15 w=1 nf=1 m=1
M14 net0 VN VSS VSS nch l=0.15 w=1 nf=1 m=1
M15 VP VP VDD VDD pch l=0.15 w=1 nf=1 m=1
M16 VP VB4 net6 VSS nch l=0.15 w=1 nf=1 m=1
M17 net6 net5 VSS VSS nch l=0.15 w=1 nf=1 m=1
M18 net5 VP VDD VDD pch l=0.15 w=1 nf=1 m=1
M19 net5 net5 VSS VSS nch l=0.15 w=1 nf=1 m=1
M2 VC VB3 net3 VDD pch l=0.15 w=1 nf=1 m=1
M20 VB4 VP VDD VDD pch l=0.15 w=1 nf=1 m=1
M21 VB4 VB4 VSS VSS nch l=0.15 w=1 nf=1 m=1
M3 VC VN Z VSS nch l=0.15 w=1 nf=1 m=1
M4 Z VB2 VSS VSS nch l=0.15 w=1 nf=1 m=1
M5 X VC VDD VDD pch l=0.15 w=1 nf=1 m=1
M6 Vout VB3 X VDD pch l=0.15 w=1 nf=1 m=1
M7 Vout VN net4 VSS nch l=0.15 w=1 nf=1 m=1
M8 net4 VB2 VSS VSS nch l=0.15 w=1 nf=1 m=1
M9 net7 VB1 VDD VDD pch l=0.15 w=1 nf=1 m=1
Q1 VSS VSS Z qpnp m=1
Q2 Z Z X qpnp m=1
Q3 VSS VSS net2 qpnp m=1
Q4 net2 net2 net1 qpnp m=1
R1 Vout X 1k
R2 Vout Y 1k
R3 Y net1 1k
.ends dut
