* official Analog Canvas netlist; PDK X cards rewritten by convert.py
.model nch nmos

.subckt dut VSS VLO VLO_bar VRF+ VRF- Vout1 Vout2
M1 Vout1 VLO VRF+ VSS nch l=0.15 w=1 nf=1 m=1
M2 Vout2 VLO_bar VRF+ VSS nch l=0.15 w=1 nf=1 m=1
M3 Vout1 VLO_bar VRF- VSS nch l=0.15 w=1 nf=1 m=1
M4 Vout2 VLO VRF- VSS nch l=0.15 w=1 nf=1 m=1
RL1 VSS Vout1 1k
RL2 Vout2 VSS 1k
.ends dut
