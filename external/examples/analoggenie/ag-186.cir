* official Analog Canvas netlist; PDK X cards rewritten by convert.py
.model nch nmos

.subckt dut VDD VSS Vin Vout Vb
C0 net0 VSS 1p
I1 VDD net0 DC 1m
In2 Vin VSS DC 1m
M0 net0 net0 VSS VSS nch l=0.15 w=1 nf=1 m=1
M1 Vout Vb Vin VSS nch l=0.15 w=1 nf=1 m=1
M2 Vin net0 VSS VSS nch l=0.15 w=1 nf=1 m=1
RD VDD Vout 1k
.ends dut
