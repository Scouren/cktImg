* official Analog Canvas netlist; PDK X cards rewritten by convert.py
.model nch nmos
.model pch pmos

.subckt dut VDD VSS VIN VP VCONT1 VCONT2 VCONT3 VCONT4 VCONT5 VB4 VREF VB1 VB2 VB3
.model DIODE D(IS=1e-14 N=1)
CFLY VX1 VX2 1p
CO VP VN 1p
COP VP VSS 1p
D1 VN VX2 DIODE
L1 VX1 VX3 1n
MN1 net2 net2 VSS VSS nch l=0.15 w=1 nf=1 m=1
MN10 VB1 VB1 VSS VSS nch l=0.15 w=1 nf=1 m=1
MN11 net3 VB3 VB2 VSS nch l=0.15 w=1 nf=1 m=1
MN12 VB3 VB2 VSS VSS nch l=0.15 w=1 nf=1 m=1
MN13 VB2 VX2 VSS VSS nch l=0.15 w=1 nf=1 m=1
MN14 VX2 VX2 VSS VSS nch l=0.15 w=1 nf=1 m=1
MN2 VX2 VX2 VSS VSS nch l=0.15 w=1 nf=1 m=1
MN3 net0 VX2 VSS VSS nch l=0.15 w=1 nf=1 m=1
MN4 VEA net2 VSS VSS nch l=0.15 w=1 nf=1 m=1
MN6 net1 net4 VSS VSS nch l=0.15 w=1 nf=1 m=1
MN7 net4 net4 VSS VSS nch l=0.15 w=1 nf=1 m=1
MN8 net4 VB4 VSS VSS nch l=0.15 w=1 nf=1 m=1
MN9 VBP VB1 VSS VSS nch l=0.15 w=1 nf=1 m=1
MP1 net0 net0 VDD VDD pch l=0.15 w=1 nf=1 m=1
MP10 VB1 net3 VDD VDD pch l=0.15 w=1 nf=1 m=1
MP11 net3 net3 VDD VDD pch l=0.15 w=1 nf=1 m=1
MP12 VB3 net3 VDD VDD pch l=0.15 w=1 nf=1 m=1
MP13 VX2 net3 VDD VDD pch l=0.15 w=1 nf=1 m=1
MP2 VEA net0 VDD VDD pch l=0.15 w=1 nf=1 m=1
MP3 net6 VBP VDD VDD pch l=0.15 w=1 nf=1 m=1
MP4 net1 net1 net7 net7 pch l=0.15 w=1 nf=1 m=1
MP5 VX1 net1 net7 net7 pch l=0.15 w=1 nf=1 m=1
MP6 net4 VEA net7 net7 pch l=0.15 w=1 nf=1 m=1
MP7 net2 VFP1 net6 net5 pch l=0.15 w=1 nf=1 m=1
MP8 VX2 VREF net6 net5 pch l=0.15 w=1 nf=1 m=1
MP9 VBP VBP VDD VDD pch l=0.15 w=1 nf=1 m=1
MS1 VX1 VCONT2 VIN VIN pch l=0.15 w=1 nf=1 m=1
MS2 VX2 VCONT3 VIN VIN pch l=0.15 w=1 nf=1 m=1
MS3 VX3 VCONT5 VP VP pch l=0.15 w=1 nf=1 m=1
MS4 VX3 VCONT4 VSS VSS nch l=0.15 w=1 nf=1 m=1
MS5 net7 VCONT1 VIN VIN pch l=0.15 w=1 nf=1 m=1
R1 VP VFP1 1k
R2 VFP1 VSS 1k
.ends dut
