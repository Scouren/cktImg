* official Analog Canvas netlist; PDK X cards rewritten by convert.py
.model nch nmos
.model pch pmos
.model qpnp pnp

.subckt dut VDD VSS Vout VB1 VB2
M1 net5 VC VDD VDD pch l=0.15 w=1 nf=1 m=1
M10 VP X net3 VDD pch l=0.15 w=1 nf=1 m=1
M11 net2 Y net3 VDD pch l=0.15 w=1 nf=1 m=1
M12 net1 VBP VDD VDD pch l=0.15 w=1 nf=1 m=1
M13 net1 net1 VSS VSS nch l=0.15 w=1 nf=1 m=1
M14 VBP VBP VDD VDD pch l=0.15 w=1 nf=1 m=1
M15 VBP VB4 VB3 VSS nch l=0.15 w=1 nf=1 m=1
M16 VB3 net1 VSS VSS nch l=0.15 w=1 nf=1 m=1
M17 VB4 VBP VDD VDD pch l=0.15 w=1 nf=1 m=1
M18 VB4 VB3 VSS VSS nch l=0.15 w=1 nf=1 m=1
M19 VB5 VBP VDD VDD pch l=0.15 w=1 nf=1 m=1
M2 X VC VDD VDD pch l=0.15 w=1 nf=1 m=1
M20 VB5 VB5 VB6 VSS nch l=0.15 w=1 nf=1 m=1
M21 VB6 VB6 VSS VSS nch l=0.15 w=1 nf=1 m=1
M3 VC VB2 net5 VDD pch l=0.15 w=1 nf=1 m=1
M4 Vout VB2 X VDD pch l=0.15 w=1 nf=1 m=1
M5 VC VB5 VP VSS nch l=0.15 w=1 nf=1 m=1
M6 Vout VB5 net2 VSS nch l=0.15 w=1 nf=1 m=1
M7 VP VB6 VSS VSS nch l=0.15 w=1 nf=1 m=1
M8 net2 VB6 VSS VSS nch l=0.15 w=1 nf=1 m=1
M9 net3 VB1 VDD VDD pch l=0.15 w=1 nf=1 m=1
Q1 VSS VSS VP qpnp m=1
Q2 VP VP X qpnp m=1
Q3 VSS VSS net4 qpnp m=1
Q4 net4 net4 net0 qpnp m=1
R1 Vout X 1k
R2 Vout Y 1k
R3 Y net0 1k
.ends dut
