* official Analog Canvas netlist; PDK X cards rewritten by convert.py
.model nch nmos
.model pch pmos

.subckt amp VDD VSS VB1 INN INP OUT VB3 VB2 n3
M10 net5 VB3 net2 VDD pch l=0.15 w=1 nf=1 m=1
M11 net5 VX net6 VSS nch l=0.15 w=1 nf=1 m=1
M12 net6 VB2 VSS VSS nch l=0.15 w=1 nf=1 m=1
M13 net0 net5 VDD VDD pch l=0.15 w=1 nf=1 m=1
M14 OUT VB3 net0 VDD pch l=0.15 w=1 nf=1 m=1
M15 OUT VX net4 VSS nch l=0.15 w=1 nf=1 m=1
M16 net4 VB2 VSS VSS nch l=0.15 w=1 nf=1 m=1
M17 VB5 VY VDD VDD pch l=0.15 w=1 nf=1 m=1
M18 VB5 VB4 VSS VSS nch l=0.15 w=1 nf=1 m=1
M19 VY VY VDD VDD pch l=0.15 w=1 nf=1 m=1
M20 VY VB5 VB4 VSS nch l=0.15 w=1 nf=1 m=1
M21 VB4 net1 VSS VSS nch l=0.15 w=1 nf=1 m=1
M22 net1 VY VDD VDD pch l=0.15 w=1 nf=1 m=1
M23 net1 net1 VSS VSS nch l=0.15 w=1 nf=1 m=1
M24 VX VY VDD VDD pch l=0.15 w=1 nf=1 m=1
M25 VX VX net3 VSS nch l=0.15 w=1 nf=1 m=1
M26 net3 VX VSS VSS nch l=0.15 w=1 nf=1 m=1
M6 n3 VB1 VDD VDD pch l=0.15 w=1 nf=1 m=1
M7 net6 INP n3 VDD pch l=0.15 w=1 nf=1 m=1
M8 net4 INN n3 VDD pch l=0.15 w=1 nf=1 m=1
M9 net2 net5 VDD VDD pch l=0.15 w=1 nf=1 m=1
.ends amp

.subckt dut VDD VSS biasp biascas biasn Vref Vout VB2 VB1 VB3
C1 Vset VSS 1p
C2 n3 Vout 1p
M1 Vout n3 VDD VDD pch l=0.15 w=1 nf=1 m=1
M2 n1 Vset Vout VDD pch l=0.15 w=1 nf=1 m=1
M3 n1 biasn VSS VSS nch l=0.15 w=1 nf=1 m=1
M4 n3 biasp VDD VDD pch l=0.15 w=1 nf=1 m=1
M5 n3 biascas n1 VSS nch l=0.15 w=1 nf=1 m=1
R1 fb VSS 1k
R2 Vout fb 1k
X1 VDD VSS VB1 fb Vref Vset VB3 VB2 n3 amp
.ends dut
