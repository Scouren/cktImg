* official Analog Canvas netlist; PDK X cards rewritten by convert.py
.model nch nmos
.model pch pmos

.subckt opamp VDD VSS VP VN VO
M1 net0 VB1 VDD VDD pch l=0.15 w=1 nf=1 m=1
M10 net2 VX VSS VSS nch l=0.15 w=1 nf=1 m=1
M11 VO VB6 VSS VSS nch l=0.15 w=1 nf=1 m=1
M12 VB5 VB7 VDD VDD pch l=0.15 w=1 nf=1 m=1
M13 VB5 VB5 VB6 VSS nch l=0.15 w=1 nf=1 m=1
M14 VB6 VB6 VSS VSS nch l=0.15 w=1 nf=1 m=1
M15 VB4 VB7 VDD VDD pch l=0.15 w=1 nf=1 m=1
M16 VB7 VB7 VDD VDD pch l=0.15 w=1 nf=1 m=1
M17 net3 VB7 VDD VDD pch l=0.15 w=1 nf=1 m=1
M18 VB7 VB4 VB3 VSS nch l=0.15 w=1 nf=1 m=1
M19 VB3 net3 VSS VSS nch l=0.15 w=1 nf=1 m=1
M2 net4 VB1 VDD VDD pch l=0.15 w=1 nf=1 m=1
M20 VB4 VB3 VSS VSS nch l=0.15 w=1 nf=1 m=1
M21 net3 net3 VSS VSS nch l=0.15 w=1 nf=1 m=1
M3 net0 VP VO VSS nch l=0.15 w=1 nf=1 m=1
M4 net4 VN VO VSS nch l=0.15 w=1 nf=1 m=1
M5 VO VB2 net0 VDD pch l=0.15 w=1 nf=1 m=1
M6 VX VB2 net4 VDD pch l=0.15 w=1 nf=1 m=1
M7 VO VB5 net1 VSS nch l=0.15 w=1 nf=1 m=1
M8 VX VB5 net2 VSS nch l=0.15 w=1 nf=1 m=1
M9 net1 VX VSS VSS nch l=0.15 w=1 nf=1 m=1
.ends opamp

.subckt dut VDD VSS Vref VIN VOUT
CL VOUT net1 1p
MNP VIN net0 VOUT VSS nch l=0.15 w=1 nf=1 m=1
R1 VOUT FB 1k
R2 FB VSS 1k
R3 net1 VSS 1k
X1 VDD VSS Vref FB net0 opamp
.ends dut
