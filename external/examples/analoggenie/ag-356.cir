* official Analog Canvas netlist; PDK X cards rewritten by convert.py
.model nch nmos
.model pch pmos

.subckt dut VDD VSS Vin1 Vin2 Vout1 Vout2 Vb1 Vb2
IREF1 VDD net1 DC 1m
IREF2 Vb3 VSS DC 1m
M1 net2 Vin1 net5 VSS nch l=0.15 w=1 nf=1 m=1
M2 net0 Vin2 net5 VSS nch l=0.15 w=1 nf=1 m=1
M3 Vout1 Vb2 net2 VSS nch l=0.15 w=1 nf=1 m=1
M4 Vout2 Vb2 net0 VSS nch l=0.15 w=1 nf=1 m=1
M5 Vout1 Vb1 net4 VDD pch l=0.15 w=1 nf=1 m=1
M6 Vout2 Vb1 net3 VDD pch l=0.15 w=1 nf=1 m=1
M7 net4 Vb3 VDD VDD pch l=0.15 w=1 nf=1 m=1
M8 net3 Vb3 VDD VDD pch l=0.15 w=1 nf=1 m=1
M9 net5 net1 VSS VSS nch l=0.15 w=1 nf=1 m=1
Mb1 net1 net1 VSS VSS nch l=0.15 w=1 nf=1 m=1
Mb2 Vb3 Vb3 VDD VDD pch l=0.15 w=1 nf=1 m=1
.ends dut
