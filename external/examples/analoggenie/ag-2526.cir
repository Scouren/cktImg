* official Analog Canvas netlist; PDK X cards rewritten by convert.py
.model nch nmos
.model pch pmos

.subckt dut VDD VSS VREF VIN VB4 VB3 VB2 VOUT VB1
CF1 VOUT VFB 1p
Cm1 VOUT V1 1p
Cm2 V1 net4 1p
M11 net2 VBN VSS VSS nch l=0.15 w=1 nf=1 m=1
M12 VC VFB net2 VSS nch l=0.15 w=1 nf=1 m=1
M13 VA VREF net2 VSS nch l=0.15 w=1 nf=1 m=1
M14 VA VA VIN VDD pch l=0.15 w=1 nf=1 m=1
M15 VC VC VIN VDD pch l=0.15 w=1 nf=1 m=1
M16 VA VB4 VIN VDD pch l=0.15 w=1 nf=1 m=1
M17 VA V1 VSS VSS nch l=0.15 w=1 nf=1 m=1
M18 VA VA VSS VSS nch l=0.15 w=1 nf=1 m=1
M19 net7 VA VIN VDD pch l=0.15 w=1 nf=1 m=1
M20 V1 VC VIN VDD pch l=0.15 w=1 nf=1 m=1
M21 net3 V1 VSS VSS nch l=0.15 w=1 nf=1 m=1
M22 net9 VA VSS VSS nch l=0.15 w=1 nf=1 m=1
M23 net3 net3 VIN VDD pch l=0.15 w=1 nf=1 m=1
M24 net9 net3 VIN VDD pch l=0.15 w=1 nf=1 m=1
M25 net7 net7 VSS VSS nch l=0.15 w=1 nf=1 m=1
M26 V1 net7 VSS VSS nch l=0.15 w=1 nf=1 m=1
MB1 net1 net6 VSS VSS nch l=0.15 w=1 nf=1 m=1
MB2 net6 net1 VIN VDD pch l=0.15 w=1 nf=1 m=1
MB3 net6 net6 VSS VSS nch l=0.15 w=1 nf=1 m=1
MB4 net5 net6 VSS VSS nch l=0.15 w=1 nf=1 m=1
MB5 net5 net5 VIN VDD pch l=0.15 w=1 nf=1 m=1
MB6 VBN net5 VIN VDD pch l=0.15 w=1 nf=1 m=1
MB7 VBN VBN VSS VSS nch l=0.15 w=1 nf=1 m=1
MB8 VB1 VBN VSS VSS nch l=0.15 w=1 nf=1 m=1
MB9 VB1 VB1 VIN VDD pch l=0.15 w=1 nf=1 m=1
MD1 net4 V1 VSS VSS nch l=0.15 w=1 nf=1 m=1
MD2 net0 VB2 VSS VSS nch l=0.15 w=1 nf=1 m=1
MD3 net8 net4 net0 VSS nch l=0.15 w=1 nf=1 m=1
MD4 VC VB3 net0 VSS nch l=0.15 w=1 nf=1 m=1
MD5 net4 VC VIN VDD pch l=0.15 w=1 nf=1 m=1
MD6 VC VC VIN VDD pch l=0.15 w=1 nf=1 m=1
MD7 net8 net8 VIN VDD pch l=0.15 w=1 nf=1 m=1
MPT VOUT net9 VIN VDD pch l=0.15 w=1 nf=1 m=1
RB1 VIN net1 1k
RB2 VIN net6 1k
RF1 VOUT VFB 1k
RF2 VFB VSS 1k
.ends dut
