* official Analog Canvas netlist; PDK X cards rewritten by convert.py
.model nch nmos
.model pch pmos

.subckt dut VDD VSS Vin1 Vin2 Vout1 Vout2
ISS net1 VSS DC 1m
M1 X Vin1 net1 VSS nch l=0.15 w=1 nf=1 m=1
M2 Y Vin2 net1 VSS nch l=0.15 w=1 nf=1 m=1
M3 X net0 VDD VDD pch l=0.15 w=1 nf=1 m=1
M4 Y net0 VDD VDD pch l=0.15 w=1 nf=1 m=1
M5 Vout1 X VDD VDD pch l=0.15 w=1 nf=1 m=1
M6 Vout2 Y VDD VDD pch l=0.15 w=1 nf=1 m=1
M7 Vout1 Q VSS VSS nch l=0.15 w=1 nf=1 m=1
M8 Vout2 Q VSS VSS nch l=0.15 w=1 nf=1 m=1
R1 X net0 1k
R2 net0 Y 1k
R3 Vout1 Q 1k
R4 Q Vout2 1k
.ends dut
