* official Analog Canvas netlist; PDK X cards rewritten by convert.py
.model nch nmos
.model pch pmos

.subckt dut VDD VSS Vn Vn-1 Vin PHI1 Qn
MD1 net5 net5 net2 VSS nch l=0.15 w=1 nf=1 m=1
MD2 net2 net2 net5 VSS nch l=0.15 w=1 nf=1 m=1
MN1 net5 net5 VSS VSS nch l=0.15 w=1 nf=1 m=1
MN10 net6 net4 VSS VSS nch l=0.15 w=1 nf=1 m=1
MN11 Qn net3 VSS VSS nch l=0.15 w=1 nf=1 m=1
MN2 net2 net5 VSS VSS nch l=0.15 w=1 nf=1 m=1
MN3 net7 net8 VSS VSS nch l=0.15 w=1 nf=1 m=1
MN4 net8 net7 VSS VSS nch l=0.15 w=1 nf=1 m=1
MN5 net7 net2 VSS VSS nch l=0.15 w=1 nf=1 m=1
MN6 net8 net5 VSS VSS nch l=0.15 w=1 nf=1 m=1
MN7 net4 PHI1 net7 VSS nch l=0.15 w=1 nf=1 m=1
MN8 net3 PHI1 net8 VSS nch l=0.15 w=1 nf=1 m=1
MN9 net1 net1 VSS VSS nch l=0.15 w=1 nf=1 m=1
MP1 net5 Vn net0 VDD pch l=0.15 w=1 nf=1 m=1
MP10 Qn net3 VDD VDD pch l=0.15 w=1 nf=1 m=1
MP2 net2 Vin net0 VDD pch l=0.15 w=1 nf=1 m=1
MP3 net4 net3 VDD VDD pch l=0.15 w=1 nf=1 m=1
MP4 net3 net4 VDD VDD pch l=0.15 w=1 nf=1 m=1
MP5 net4 PHI1 VDD VDD pch l=0.15 w=1 nf=1 m=1
MP6 net3 PHI1 VDD VDD pch l=0.15 w=1 nf=1 m=1
MP7 net1 net1 VDD VDD pch l=0.15 w=1 nf=1 m=1
MP8 net0 net1 VDD VDD pch l=0.15 w=1 nf=1 m=1
MP9 net6 net4 VDD VDD pch l=0.15 w=1 nf=1 m=1
R1 Vn Vn-1 1k
.ends dut
