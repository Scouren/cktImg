* official Analog Canvas netlist; PDK X cards rewritten by convert.py

.subckt dut VSS Vin Vout
C1 Vout VSS 1nF
R1 Vin Vout 15.9kΩ
.ends dut
