* official Analog Canvas netlist; PDK X cards rewritten by convert.py
.model nch nmos
.model pch pmos

.subckt opamp VDD VSS INP INN OUT
C3 net5 OUT 1p
M10 net3 net3 VDD VDD pch l=0.15 w=1 nf=1 m=1
M11 VB1 net3 VDD VDD pch l=0.15 w=1 nf=1 m=1
M12 VB3 VB3 VDD VDD pch l=0.15 w=1 nf=1 m=1
M13 net3 VB4 VSS VSS nch l=0.15 w=1 nf=1 m=1
M14 VB1 VB1 VSS VSS nch l=0.15 w=1 nf=1 m=1
M15 VB3 VB1 VSS VSS nch l=0.15 w=1 nf=1 m=1
M16 VB2 VB2 VDD VDD pch l=0.15 w=1 nf=1 m=1
M17 VB4 VB2 VDD VDD pch l=0.15 w=1 nf=1 m=1
M18 net1 VB2 VDD VDD pch l=0.15 w=1 nf=1 m=1
M19 net6 VB2 VDD VDD pch l=0.15 w=1 nf=1 m=1
M20 VB2 VX VSS VSS nch l=0.15 w=1 nf=1 m=1
M21 VB4 VB4 VSS VSS nch l=0.15 w=1 nf=1 m=1
M22 net1 net1 net4 VSS nch l=0.15 w=1 nf=1 m=1
M23 net4 net1 VB4 VSS nch l=0.15 w=1 nf=1 m=1
M24 net6 net6 VX VSS nch l=0.15 w=1 nf=1 m=1
M25 VX net6 net4 VSS nch l=0.15 w=1 nf=1 m=1
M3 net0 VB3 VDD VDD pch l=0.15 w=1 nf=1 m=1
M4 net2 INP net0 VDD pch l=0.15 w=1 nf=1 m=1
M5 net5 INN net0 VDD pch l=0.15 w=1 nf=1 m=1
M6 net2 net2 VSS VSS nch l=0.15 w=1 nf=1 m=1
M7 net5 net2 VSS VSS nch l=0.15 w=1 nf=1 m=1
M8 OUT VB3 VDD VDD pch l=0.15 w=1 nf=1 m=1
M9 OUT net5 VSS VSS nch l=0.15 w=1 nf=1 m=1
.ends opamp

.subckt dut VDD VSS vci phi1 phi2 vco
C1 vcx VSS 1p
C2 net0 vco 1p
M1 vci phi1 vcx VSS nch l=0.15 w=1 nf=1 m=1
M2 vcx phi2 net0 VSS nch l=0.15 w=1 nf=1 m=1
X1 VDD VSS VSS net0 vco opamp
.ends dut
