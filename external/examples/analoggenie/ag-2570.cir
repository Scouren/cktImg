* official Analog Canvas netlist; PDK X cards rewritten by convert.py
.model nch nmos
.model pch pmos

.subckt dut VDD VSS Vout biasp biascas biasn Vref VB1 VB3 VB2
C1 Vset VSS 1p
C2 n3 Vout 1p
M1 Vout n3 VDD VDD pch l=0.15 w=1 nf=1 m=1
M10 net0 VB2 VSS VSS nch l=0.15 w=1 nf=1 m=1
M11 Vset VB3 net1 VDD pch l=0.15 w=1 nf=1 m=1
M12 n3 VB3 net5 VDD pch l=0.15 w=1 nf=1 m=1
M13 Vset VX n1 VSS nch l=0.15 w=1 nf=1 m=1
M14 n3 VX net4 VSS nch l=0.15 w=1 nf=1 m=1
M15 n1 n3 VSS VSS nch l=0.15 w=1 nf=1 m=1
M16 net4 n3 VSS VSS nch l=0.15 w=1 nf=1 m=1
M17 net2 net2 VDD VDD pch l=0.15 w=1 nf=1 m=1
M18 VX net2 VDD VDD pch l=0.15 w=1 nf=1 m=1
M19 VX VX net3 VSS nch l=0.15 w=1 nf=1 m=1
M2 n1 Vset Vout VDD pch l=0.15 w=1 nf=1 m=1
M20 net3 VX VSS VSS nch l=0.15 w=1 nf=1 m=1
M3 n1 biasn VSS VSS nch l=0.15 w=1 nf=1 m=1
M4 n3 biasp VDD VDD pch l=0.15 w=1 nf=1 m=1
M5 n3 biascas n1 VSS nch l=0.15 w=1 nf=1 m=1
M6 net1 VB1 VDD VDD pch l=0.15 w=1 nf=1 m=1
M7 net5 VB1 VDD VDD pch l=0.15 w=1 nf=1 m=1
M8 net1 Vref net0 VSS nch l=0.15 w=1 nf=1 m=1
M9 net5 fb net0 VSS nch l=0.15 w=1 nf=1 m=1
R1 fb VSS 1k
R2 Vout fb 1k
R3 net2 VSS 1k
.ends dut
