* official Analog Canvas netlist; PDK X cards rewritten by convert.py
.model nch nmos
.model qpnp pnp

.subckt dut VDD VSS IOUT1
IBIAS VDD net0 DC 1m
IIN VDD net1 DC 1m
M1 net1 net0 VSS VSS nch l=0.15 w=1 nf=1 m=1
M2 IOUT1 net0 VSS VSS nch l=0.15 w=1 nf=1 m=1
Q3 VSS net1 net0 qpnp m=1
.ends dut
