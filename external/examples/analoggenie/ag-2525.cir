* official Analog Canvas netlist; PDK X cards rewritten by convert.py
.model nch nmos
.model pch pmos

.subckt dut VDD VSS VB1 VREF VB4 VB3 VB2 VOUT VIN
CF1 VOUT VFB 1p
Cm1 VOUT VO1 1p
Cm2 VO1 net3 1p
M11 net6 VBN VSS VSS nch l=0.15 w=1 nf=1 m=1
M12 VY VFB net6 VSS nch l=0.15 w=1 nf=1 m=1
M13 VX VREF net6 VSS nch l=0.15 w=1 nf=1 m=1
M14 VX VX VIN VDD pch l=0.15 w=1 nf=1 m=1
M15 VY VY VIN VDD pch l=0.15 w=1 nf=1 m=1
M16 VX VB4 VIN VDD pch l=0.15 w=1 nf=1 m=1
M17 VX VO1 VSS VSS nch l=0.15 w=1 nf=1 m=1
M18 VX VX VSS VSS nch l=0.15 w=1 nf=1 m=1
M21 net1 VO1 VSS VSS nch l=0.15 w=1 nf=1 m=1
M22 net7 VX VSS VSS nch l=0.15 w=1 nf=1 m=1
M23 net1 net1 VIN VDD pch l=0.15 w=1 nf=1 m=1
M24 net7 net1 VIN VDD pch l=0.15 w=1 nf=1 m=1
M31 VZ VX VIN VDD pch l=0.15 w=1 nf=1 m=1
M32 VO1 VY VIN VDD pch l=0.15 w=1 nf=1 m=1
M33 VZ VZ VSS VSS nch l=0.15 w=1 nf=1 m=1
M34 VO1 VZ VSS VSS nch l=0.15 w=1 nf=1 m=1
M41 VB1 VB1 VIN VDD pch l=0.15 w=1 nf=1 m=1
M42 VB1 VBN VSS VSS nch l=0.15 w=1 nf=1 m=1
M43 VBN net5 VIN VDD pch l=0.15 w=1 nf=1 m=1
M44 VBN VBN VSS VSS nch l=0.15 w=1 nf=1 m=1
M45 net5 net5 VIN VDD pch l=0.15 w=1 nf=1 m=1
M46 net5 net2 VSS VSS nch l=0.15 w=1 nf=1 m=1
M47 net2 VZ VIN VDD pch l=0.15 w=1 nf=1 m=1
M48 net2 net2 VSS VSS nch l=0.15 w=1 nf=1 m=1
M49 VZ VZ VIN VDD pch l=0.15 w=1 nf=1 m=1
M50 VZ net2 VSS VSS nch l=0.15 w=1 nf=1 m=1
MD1 net3 VO1 VSS VSS nch l=0.15 w=1 nf=1 m=1
MD2 net4 VB2 VSS VSS nch l=0.15 w=1 nf=1 m=1
MD3 net0 net3 net4 VSS nch l=0.15 w=1 nf=1 m=1
MD4 VY VB3 net4 VSS nch l=0.15 w=1 nf=1 m=1
MD5 net3 VY VIN VDD pch l=0.15 w=1 nf=1 m=1
MD6 VY VY VIN VDD pch l=0.15 w=1 nf=1 m=1
MD7 net0 net0 VIN VDD pch l=0.15 w=1 nf=1 m=1
MPT VOUT net7 VIN VDD pch l=0.15 w=1 nf=1 m=1
RB VIN net2 1k
RF1 VOUT VFB 1k
RF2 VFB VSS 1k
.ends dut
