* official Analog Canvas netlist; PDK X cards rewritten by convert.py
.model nch nmos
.model pch pmos

.subckt opamp VDD VSS INN INP OUT VB1
M10 net4 INN net0 VSS nch l=0.15 w=1 nf=1 m=1
M11 INN INP net0 VSS nch l=0.15 w=1 nf=1 m=1
M12 net0 VBN VSS VSS nch l=0.15 w=1 nf=1 m=1
M13 net1 net1 VSS VSS nch l=0.15 w=1 nf=1 m=1
M14 OUT net1 VSS VSS nch l=0.15 w=1 nf=1 m=1
M15 VBP VBP VDD VDD pch l=0.15 w=1 nf=1 m=1
M16 net2 VBP VDD VDD pch l=0.15 w=1 nf=1 m=1
M17 VB1 VBP VDD VDD pch l=0.15 w=1 nf=1 m=1
M18 VBN VBP VDD VDD pch l=0.15 w=1 nf=1 m=1
M19 VBP VB1 net3 VSS nch l=0.15 w=1 nf=1 m=1
M20 net3 net2 VSS VSS nch l=0.15 w=1 nf=1 m=1
M21 net2 net2 VSS VSS nch l=0.15 w=1 nf=1 m=1
M22 VB1 VB1 VSS VSS nch l=0.15 w=1 nf=1 m=1
M23 VBN VBN VSS VSS nch l=0.15 w=1 nf=1 m=1
M6 net1 net4 VDD VDD pch l=0.15 w=1 nf=1 m=1
M7 net4 net4 VDD VDD pch l=0.15 w=1 nf=1 m=1
M8 INN INN VDD VDD pch l=0.15 w=1 nf=1 m=1
M9 OUT INN VDD VDD pch l=0.15 w=1 nf=1 m=1
.ends opamp

.subckt dut VDD VSS biasp biascas biasn Vref VB1 Vout
C1 Vset VSS 1p
C2 n3 Vout 1p
M1 Vout n3 VDD VDD pch l=0.15 w=1 nf=1 m=1
M2 n1 Vset Vout VDD pch l=0.15 w=1 nf=1 m=1
M3 n1 biasn VSS VSS nch l=0.15 w=1 nf=1 m=1
M4 n3 biasp VDD VDD pch l=0.15 w=1 nf=1 m=1
M5 n3 biascas n1 VSS nch l=0.15 w=1 nf=1 m=1
R1 fb VSS 1k
R2 Vout fb 1k
X1 VDD VSS fb Vref Vset VB1 opamp
.ends dut
