* official Analog Canvas netlist; PDK X cards rewritten by convert.py
.model nch nmos
.model pch pmos

.subckt dut VDD VSS VIN VREF VB3 VB5 VOUT VB1 VB2 VB4
CF1 VOUT VFB 1p
Cm1 VOUT V1 1p
Cm2 V1 net4 1p
M11 net6 VBN VSS VSS nch l=0.15 w=1 nf=1 m=1
M12 VA VFB net6 VSS nch l=0.15 w=1 nf=1 m=1
M13 VC VREF net6 VSS nch l=0.15 w=1 nf=1 m=1
M14 VA VA VIN VDD pch l=0.15 w=1 nf=1 m=1
M15 VC VC VIN VDD pch l=0.15 w=1 nf=1 m=1
M16 net1 VC VIN VDD pch l=0.15 w=1 nf=1 m=1
M17 net1 net1 VSS VSS nch l=0.15 w=1 nf=1 m=1
M18 V1 net1 VSS VSS nch l=0.15 w=1 nf=1 m=1
M19 V1 VA VIN VDD pch l=0.15 w=1 nf=1 m=1
M21 net2 V1 VSS VSS nch l=0.15 w=1 nf=1 m=1
M22 net3 VC VSS VSS nch l=0.15 w=1 nf=1 m=1
M23 net2 net2 VIN VDD pch l=0.15 w=1 nf=1 m=1
M24 net3 net2 VIN VDD pch l=0.15 w=1 nf=1 m=1
M25 VC VB4 VIN VDD pch l=0.15 w=1 nf=1 m=1
M26 VC V1 VSS VSS nch l=0.15 w=1 nf=1 m=1
M27 VC VC VSS VSS nch l=0.15 w=1 nf=1 m=1
M28 VB1 VBN VSS VSS nch l=0.15 w=1 nf=1 m=1
M29 VBN VBN VSS VSS nch l=0.15 w=1 nf=1 m=1
M30 VB1 VB1 VIN VDD pch l=0.15 w=1 nf=1 m=1
M31 VBN net5 VIN VDD pch l=0.15 w=1 nf=1 m=1
M32 net5 VB2 VSS VSS nch l=0.15 w=1 nf=1 m=1
M33 net0 VB2 VSS VSS nch l=0.15 w=1 nf=1 m=1
M34 net5 net5 VIN VDD pch l=0.15 w=1 nf=1 m=1
M35 VB2 net5 VIN VDD pch l=0.15 w=1 nf=1 m=1
MD1 net4 V1 VSS VSS nch l=0.15 w=1 nf=1 m=1
MD2 net8 VB5 VSS VSS nch l=0.15 w=1 nf=1 m=1
MD3 net7 net4 net8 VSS nch l=0.15 w=1 nf=1 m=1
MD4 VA VB3 net8 VSS nch l=0.15 w=1 nf=1 m=1
MD5 net4 VA VIN VDD pch l=0.15 w=1 nf=1 m=1
MD6 VA VA VIN VDD pch l=0.15 w=1 nf=1 m=1
MD7 net7 net7 VIN VDD pch l=0.15 w=1 nf=1 m=1
MPT VOUT net3 VIN VDD pch l=0.15 w=1 nf=1 m=1
R1 VB2 net0 1k
RF1 VOUT VFB 1k
RF2 VFB VSS 1k
.ends dut
