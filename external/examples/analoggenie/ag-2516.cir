* official Analog Canvas netlist; PDK X cards rewritten by convert.py
.model nch nmos
.model pch pmos

.subckt bias VDD VSS VIN VBN
MB1 VB1 VB1 VIN VDD pch l=0.15 w=1 nf=1 m=1
MB2 VB1 net0 VSS VSS nch l=0.15 w=1 nf=1 m=1
MB3 VBN VB1 VIN VDD pch l=0.15 w=1 nf=1 m=1
MB4 VBN VBN VSS VSS nch l=0.15 w=1 nf=1 m=1
MB5 VB2 VB2 VIN VDD pch l=0.15 w=1 nf=1 m=1
MB6 VB2 net0 VSS VSS nch l=0.15 w=1 nf=1 m=1
MB7 net0 VB2 VIN VDD pch l=0.15 w=1 nf=1 m=1
MB8 net0 net0 VSS VSS nch l=0.15 w=1 nf=1 m=1
.ends bias

.subckt dut VDD VSS VREF VB4 VB3 VB5 VOUT VIN
CF1 VOUT VFB 1p
Cm1 VOUT VO1 1p
Cm2 VO1 net2 1p
M11 net3 VBN VSS VSS nch l=0.15 w=1 nf=1 m=1
M12 VY VFB net3 VSS nch l=0.15 w=1 nf=1 m=1
M13 VX VREF net3 VSS nch l=0.15 w=1 nf=1 m=1
M14 VY VY VIN VDD pch l=0.15 w=1 nf=1 m=1
M15 VX VX VIN VDD pch l=0.15 w=1 nf=1 m=1
M16 VX VB4 VIN VDD pch l=0.15 w=1 nf=1 m=1
M17 VX VX VSS VSS nch l=0.15 w=1 nf=1 m=1
M18 VX VO1 VSS VSS nch l=0.15 w=1 nf=1 m=1
M19 net4 VX VIN VDD pch l=0.15 w=1 nf=1 m=1
M20 VO1 VY VIN VDD pch l=0.15 w=1 nf=1 m=1
M21 net0 VO1 VSS VSS nch l=0.15 w=1 nf=1 m=1
M22 net5 VX VSS VSS nch l=0.15 w=1 nf=1 m=1
M23 net0 net0 VIN VDD pch l=0.15 w=1 nf=1 m=1
M24 net5 net0 VIN VDD pch l=0.15 w=1 nf=1 m=1
M25 net4 net4 VSS VSS nch l=0.15 w=1 nf=1 m=1
M26 VO1 net4 VSS VSS nch l=0.15 w=1 nf=1 m=1
MD1 net2 VO1 VSS VSS nch l=0.15 w=1 nf=1 m=1
MD2 net1 VB5 VSS VSS nch l=0.15 w=1 nf=1 m=1
MD3 net6 net2 net1 VSS nch l=0.15 w=1 nf=1 m=1
MD4 VY VB3 net1 VSS nch l=0.15 w=1 nf=1 m=1
MD5 net2 VY VIN VDD pch l=0.15 w=1 nf=1 m=1
MD6 net6 net6 VIN VDD pch l=0.15 w=1 nf=1 m=1
MD7 VY VY VIN VDD pch l=0.15 w=1 nf=1 m=1
MPT VOUT net5 VIN VDD pch l=0.15 w=1 nf=1 m=1
RF1 VOUT VFB 1k
RF2 VFB VSS 1k
X1 VDD VSS VIN VBN bias
.ends dut
