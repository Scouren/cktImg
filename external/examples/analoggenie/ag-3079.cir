* official Analog Canvas netlist; PDK X cards rewritten by convert.py
.model nch nmos
.model pch pmos

.subckt dut VDD VSS vci phi1 phi2 vco VB1 VB2
C1 vcx VSS 1p
C2 VX vco 1p
M1 vci phi1 vcx VSS nch l=0.15 w=1 nf=1 m=1
M10 VB3 VB3 VDD VDD pch l=0.15 w=1 nf=1 m=1
M11 VB3 net1 VSS VSS nch l=0.15 w=1 nf=1 m=1
M12 net1 net0 VDD VDD pch l=0.15 w=1 nf=1 m=1
M13 net1 net1 VSS VSS nch l=0.15 w=1 nf=1 m=1
M14 net0 net0 VDD VDD pch l=0.15 w=1 nf=1 m=1
M15 net0 VX VB2 VSS nch l=0.15 w=1 nf=1 m=1
M16 VX net0 VDD VDD pch l=0.15 w=1 nf=1 m=1
M17 VX VB2 VSS VSS nch l=0.15 w=1 nf=1 m=1
M2 vcx phi2 VX VSS nch l=0.15 w=1 nf=1 m=1
M3 net2 VB3 VDD VDD pch l=0.15 w=1 nf=1 m=1
M4 VX VSS net2 VDD pch l=0.15 w=1 nf=1 m=1
M5 vco VX net2 VDD pch l=0.15 w=1 nf=1 m=1
M6 VX VX VSS VSS nch l=0.15 w=1 nf=1 m=1
M7 vco VX VSS VSS nch l=0.15 w=1 nf=1 m=1
M8 VB1 VB3 VDD VDD pch l=0.15 w=1 nf=1 m=1
M9 VB1 VB1 VSS VSS nch l=0.15 w=1 nf=1 m=1
R1 VB2 VSS 1k
.ends dut
