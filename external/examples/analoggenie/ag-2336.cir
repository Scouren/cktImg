* official Analog Canvas netlist; PDK X cards rewritten by convert.py
.model nch nmos
.model pch pmos

.subckt dut VDD VSS VB1 VB2 VREF VB4 IBUF VIN VOUT
CL VOUT net3 1p
M1 net0 net0 VDD VDD pch l=0.15 w=1 nf=1 m=1
M11 net1 net2 VDD VDD pch l=0.15 w=1 nf=1 m=1
M12 EAO net0 VDD VDD pch l=0.15 w=1 nf=1 m=1
M13 net4 VB4 VDD VDD pch l=0.15 w=1 nf=1 m=1
M14 VT EAO net4 VDD pch l=0.15 w=1 nf=1 m=1
M15 VT VT VSS VSS nch l=0.15 w=1 nf=1 m=1
M16 GATE VT VSS VSS nch l=0.15 w=1 nf=1 m=1
M17 VDD net4 GATE VSS nch l=0.15 w=1 nf=1 m=1
M18 net5 EAO IBUF VSS nch l=0.15 w=1 nf=1 m=1
M19 net5 net5 VDD VDD pch l=0.15 w=1 nf=1 m=1
M2 net2 net2 VDD VDD pch l=0.15 w=1 nf=1 m=1
M20 GATE net5 VDD VDD pch l=0.15 w=1 nf=1 m=1
M21 VSS IBUF GATE VDD pch l=0.15 w=1 nf=1 m=1
M22 VB1 VB1 VDD VDD pch l=0.15 w=1 nf=1 m=1
M23 VBN VB1 VDD VDD pch l=0.15 w=1 nf=1 m=1
M24 VB1 VX VSS VSS nch l=0.15 w=1 nf=1 m=1
M25 VBN VBN VSS VSS nch l=0.15 w=1 nf=1 m=1
M26 VB2 VB2 VDD VDD pch l=0.15 w=1 nf=1 m=1
M27 VX VB2 VDD VDD pch l=0.15 w=1 nf=1 m=1
M28 VB2 VX VSS VSS nch l=0.15 w=1 nf=1 m=1
M29 VX VX VSS VSS nch l=0.15 w=1 nf=1 m=1
M3 net0 VREF VT VSS nch l=0.15 w=1 nf=1 m=1
M4 net2 FB VT VSS nch l=0.15 w=1 nf=1 m=1
M5 net1 net1 VSS VSS nch l=0.15 w=1 nf=1 m=1
M6 EAO net1 VSS VSS nch l=0.15 w=1 nf=1 m=1
M7 VT VBN VSS VSS nch l=0.15 w=1 nf=1 m=1
MNP VIN GATE VOUT VSS nch l=0.15 w=1 nf=1 m=1
R1 FB VSS 1k
R2 VOUT FB 1k
R3 net3 VSS 1k
RL VOUT VSS 1k
.ends dut
