* official Analog Canvas netlist; PDK X cards rewritten by convert.py
.model nch nmos
.model pch pmos

* Crystal: Butterworth-Van Dyke model, fs = 1/(2*pi*sqrt(lm*cm))
.subckt crystal n1 n2 params: rm=25 lm=12.7m cm=20f c0=5p
Rm n1 nr {rm}
Lm nr nl {lm}
Cm nl n2 {cm}
C0 n1 n2 {c0}
.ends crystal

.subckt dut +3.3V VSS
C1 net2 VSS 10pF
C2 net1 VSS 10pF
M1 net0 net2 +3.3V +3.3V pch l=0.15 w=1 nf=1 m=1
M2 net0 net2 VSS VSS nch l=0.15 w=1 nf=1 m=1
R1 net2 net1 1Meg
R2 net0 net1 10kΩ
X1 net2 net1 crystal c0=5p cm=20f lm=12.7m rm=25
.ends dut
