* official Analog Canvas netlist; PDK X cards rewritten by convert.py
.model nch nmos

.subckt dut VDD VSS IOUT
IIN VDD net3 DC 1m
M1 net4 net1 VSS VSS nch l=0.15 w=1 nf=1 m=1
M2 net2 net0 net4 VSS nch l=0.15 w=1 nf=1 m=1
M3 IOUT net3 net2 VSS nch l=0.15 w=1 nf=1 m=1
M4 net1 net1 VSS VSS nch l=0.15 w=1 nf=1 m=1
M5 net0 net0 net1 VSS nch l=0.15 w=1 nf=1 m=1
M6 net3 net3 net0 VSS nch l=0.15 w=1 nf=1 m=1
.ends dut
