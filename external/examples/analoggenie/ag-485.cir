* official Analog Canvas netlist; PDK X cards rewritten by convert.py
.model nch nmos

.subckt dut VDD VSS Vin Vb Vout1 Vout2
C1 net0 VSS 1p
I1 P VSS DC 1m
LP P net0 1n
M1 Vout1 Vin P VSS nch l=0.15 w=1 nf=1 m=1
M2 Vout2 Vb P VSS nch l=0.15 w=1 nf=1 m=1
R1 VDD Vout1 1k
R2 VDD Vout2 1k
.ends dut
