* official Analog Canvas netlist; PDK X cards rewritten by convert.py
.model pch pmos
.model qpnp pnp

.subckt dut VDD VSS Vb 2VBE
M1 net0 Vb VDD VDD pch l=0.15 w=1 nf=1 m=1
M2 2VBE Vb VDD VDD pch l=0.15 w=1 nf=1 m=1
Q1 VSS VSS net0 qpnp m=1
Q2 VSS net0 2VBE qpnp m=1
.ends dut
