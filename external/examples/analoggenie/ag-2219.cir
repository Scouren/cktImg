* official Analog Canvas netlist; PDK X cards rewritten by convert.py
.model nch nmos
.model pch pmos

.subckt Opamp VDD VSS INP INN OUT
M1 net5 INP net0 VDD pch l=0.15 w=1 nf=1 m=1
M10 net5 VB4 VSS VSS nch l=0.15 w=1 nf=1 m=1
M11 net3 VB4 VSS VSS nch l=0.15 w=1 nf=1 m=1
M12 net4 net4 VDD VDD pch l=0.15 w=1 nf=1 m=1
M13 VB3 net4 VDD VDD pch l=0.15 w=1 nf=1 m=1
M14 VB3 VB3 VB4 VSS nch l=0.15 w=1 nf=1 m=1
M15 VB4 VB4 VSS VSS nch l=0.15 w=1 nf=1 m=1
M2 net3 INN net0 VDD pch l=0.15 w=1 nf=1 m=1
M3 net0 VB1 VDD VDD pch l=0.15 w=1 nf=1 m=1
M4 net1 net2 VDD VDD pch l=0.15 w=1 nf=1 m=1
M5 net6 net2 VDD VDD pch l=0.15 w=1 nf=1 m=1
M6 net2 VB2 net1 VDD pch l=0.15 w=1 nf=1 m=1
M7 OUT VB2 net6 VDD pch l=0.15 w=1 nf=1 m=1
M8 net2 VB3 net5 VSS nch l=0.15 w=1 nf=1 m=1
M9 OUT VB3 net3 VSS nch l=0.15 w=1 nf=1 m=1
R1 net4 VSS 1k
.ends Opamp

.subckt dut VDD VSS Vref VIN VOUT
CL VOUT net1 1p
MNP VIN net0 VOUT VSS nch l=0.15 w=1 nf=1 m=1
R1 VOUT FB 1k
R2 FB VSS 1k
R3 net1 VSS 1k
X1 VDD VSS Vref FB net0 Opamp
.ends dut
