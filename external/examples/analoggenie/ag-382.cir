* official Analog Canvas netlist; PDK X cards rewritten by convert.py
.model nch nmos
.model pch pmos

.subckt dut VDD VSS
M1 net2 net0 VSS VSS nch l=0.15 w=1 nf=1 m=1
M2 net1 net2 VSS VSS nch l=0.15 w=1 nf=1 m=1
M3 net1 net1 VDD VDD pch l=0.15 w=1 nf=1 m=1
M4 net0 net1 VDD VDD pch l=0.15 w=1 nf=1 m=1
RS net0 net2 1k
.ends dut
