* official Analog Canvas netlist; PDK X cards rewritten by convert.py
.model nch nmos
.model pch pmos
.model qpnp pnp

.subckt opamp VDD VSS VB2 INN INP OUT Z VB1
M1 net3 VB2 VDD VDD pch l=0.15 w=1 nf=1 m=1
M10 net7 VB4 net8 VSS nch l=0.15 w=1 nf=1 m=1
M11 net8 net6 VSS VSS nch l=0.15 w=1 nf=1 m=1
M12 net9 net7 VDD VDD pch l=0.15 w=1 nf=1 m=1
M13 OUT VB1 net9 VDD pch l=0.15 w=1 nf=1 m=1
M14 OUT VB4 Z VSS nch l=0.15 w=1 nf=1 m=1
M15 Z VA VSS VSS nch l=0.15 w=1 nf=1 m=1
M16 VB4 net1 VDD VDD pch l=0.15 w=1 nf=1 m=1
M17 net1 net1 VDD VDD pch l=0.15 w=1 nf=1 m=1
M18 VB3 net1 VDD VDD pch l=0.15 w=1 nf=1 m=1
M19 VB4 VB4 net4 VSS nch l=0.15 w=1 nf=1 m=1
M2 VA INN net3 VDD pch l=0.15 w=1 nf=1 m=1
M20 net4 VB4 VSS VSS nch l=0.15 w=1 nf=1 m=1
M21 net1 VB3 net0 VSS nch l=0.15 w=1 nf=1 m=1
M22 VB3 VB3 VSS VSS nch l=0.15 w=1 nf=1 m=1
M3 net6 INP net3 VDD pch l=0.15 w=1 nf=1 m=1
M4 VA VB4 net5 VSS nch l=0.15 w=1 nf=1 m=1
M5 net5 VA VSS VSS nch l=0.15 w=1 nf=1 m=1
M6 net6 VB4 INN VSS nch l=0.15 w=1 nf=1 m=1
M7 INN net6 VSS VSS nch l=0.15 w=1 nf=1 m=1
M8 net2 net7 VDD VDD pch l=0.15 w=1 nf=1 m=1
M9 net7 VB1 net2 VDD pch l=0.15 w=1 nf=1 m=1
R4 net0 VSS 1k
.ends opamp

.subckt dut VDD VSS Vout VB1 VB2
Q1 VSS VSS Z qpnp m=1
Q2 Z Z net1 qpnp m=1
Q3 VSS VSS net3 qpnp m=1
Q4 net3 net3 net0 qpnp m=1
R1 Vout net1 1k
R2 Vout net2 1k
R3 net2 net0 1k
X1 VDD VSS VB2 net2 net1 Vout Z VB1 opamp
.ends dut
