* official Analog Canvas netlist; PDK X cards rewritten by convert.py
.model nch nmos
.model pch pmos

.subckt dut VDD VSS vci phi1 phi2 vco
C1 vcx VSS 1p
C2 net0 vco 1p
M1 vci phi1 vcx VSS nch l=0.15 w=1 nf=1 m=1
M10 net4 VB4 VDD VDD pch l=0.15 w=1 nf=1 m=1
M11 VB5 VB4 VDD VDD pch l=0.15 w=1 nf=1 m=1
M12 VB4 net4 net2 VSS nch l=0.15 w=1 nf=1 m=1
M13 net4 net2 VSS VSS nch l=0.15 w=1 nf=1 m=1
M14 net2 net5 VSS VSS nch l=0.15 w=1 nf=1 m=1
M15 net5 net5 VSS VSS nch l=0.15 w=1 nf=1 m=1
M16 VB5 VB5 VSS VSS nch l=0.15 w=1 nf=1 m=1
M2 vcx phi2 net0 VSS nch l=0.15 w=1 nf=1 m=1
M3 net1 net0 net3 VSS nch l=0.15 w=1 nf=1 m=1
M4 vco VSS net3 VSS nch l=0.15 w=1 nf=1 m=1
M5 net1 net1 VDD VDD pch l=0.15 w=1 nf=1 m=1
M6 vco net1 VDD VDD pch l=0.15 w=1 nf=1 m=1
M7 net3 VB5 VSS VSS nch l=0.15 w=1 nf=1 m=1
M8 net5 VB4 VDD VDD pch l=0.15 w=1 nf=1 m=1
M9 VB4 VB4 VDD VDD pch l=0.15 w=1 nf=1 m=1
.ends dut
