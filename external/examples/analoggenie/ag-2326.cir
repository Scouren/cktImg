* official Analog Canvas netlist; PDK X cards rewritten by convert.py
.model nch nmos
.model pch pmos

.subckt bias VDD VSS VBN
M19 net0 net0 VDD VDD pch l=0.15 w=1 nf=1 m=1
M20 net1 net0 VDD VDD pch l=0.15 w=1 nf=1 m=1
M21 VBN net0 VDD VDD pch l=0.15 w=1 nf=1 m=1
M22 net0 net1 VSS VSS nch l=0.15 w=1 nf=1 m=1
M23 net2 net1 VSS VSS nch l=0.15 w=1 nf=1 m=1
M24 VBN VBN VSS VSS nch l=0.15 w=1 nf=1 m=1
R3 net1 net2 1k
.ends bias

.subckt dut VDD VSS VREF VB2 IB VIN VOUT
CL VOUT net4 1p
M1 net3 net3 VDD VDD pch l=0.15 w=1 nf=1 m=1
M10 net2 VB2 VDD VDD pch l=0.15 w=1 nf=1 m=1
M11 VT EAO net2 VDD pch l=0.15 w=1 nf=1 m=1
M12 VT VT VSS VSS nch l=0.15 w=1 nf=1 m=1
M13 VDD net2 GATE VSS nch l=0.15 w=1 nf=1 m=1
M14 GATE VT VSS VSS nch l=0.15 w=1 nf=1 m=1
M15 GATE net5 VDD VDD pch l=0.15 w=1 nf=1 m=1
M16 VSS IB GATE VDD pch l=0.15 w=1 nf=1 m=1
M17 net5 net5 VDD VDD pch l=0.15 w=1 nf=1 m=1
M18 net5 EAO IB VSS nch l=0.15 w=1 nf=1 m=1
M2 net1 net1 VDD VDD pch l=0.15 w=1 nf=1 m=1
M3 net3 VREF VT VSS nch l=0.15 w=1 nf=1 m=1
M4 net1 FB VT VSS nch l=0.15 w=1 nf=1 m=1
M5 VT VBN VSS VSS nch l=0.15 w=1 nf=1 m=1
M6 EAO net3 VDD VDD pch l=0.15 w=1 nf=1 m=1
M7 net0 net1 VDD VDD pch l=0.15 w=1 nf=1 m=1
M8 net0 net0 VSS VSS nch l=0.15 w=1 nf=1 m=1
M9 EAO net0 VSS VSS nch l=0.15 w=1 nf=1 m=1
MNP VIN GATE VOUT VSS nch l=0.15 w=1 nf=1 m=1
R1 FB VSS 1k
R2 VOUT FB 1k
RESR net4 VSS 1k
RL VOUT VSS 1k
X1 VDD VSS VBN bias
.ends dut
