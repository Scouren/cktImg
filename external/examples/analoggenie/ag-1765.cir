* official Analog Canvas netlist; PDK X cards rewritten by convert.py
.model nch nmos
.model pch pmos
.model qpnp pnp

.subckt opamp VDD VSS OUT INN INP VZ
M10 OUT VB3 net3 VDD pch l=0.15 w=1 nf=1 m=1
M11 VZ VB3 net7 VDD pch l=0.15 w=1 nf=1 m=1
M12 OUT VB5 net1 VSS nch l=0.15 w=1 nf=1 m=1
M13 VZ VB5 net5 VSS nch l=0.15 w=1 nf=1 m=1
M14 net1 VZ VSS VSS nch l=0.15 w=1 nf=1 m=1
M15 net5 VZ VSS VSS nch l=0.15 w=1 nf=1 m=1
M16 net4 net0 VDD VDD pch l=0.15 w=1 nf=1 m=1
M17 net0 net0 VDD VDD pch l=0.15 w=1 nf=1 m=1
M18 VB4 net0 VDD VDD pch l=0.15 w=1 nf=1 m=1
M19 VB5 net0 VDD VDD pch l=0.15 w=1 nf=1 m=1
M20 net0 VB4 net2 VSS nch l=0.15 w=1 nf=1 m=1
M21 VB4 VB4 VSS VSS nch l=0.15 w=1 nf=1 m=1
M22 net2 net4 VSS VSS nch l=0.15 w=1 nf=1 m=1
M23 net4 net4 VSS VSS nch l=0.15 w=1 nf=1 m=1
M24 VB5 VB5 net6 VSS nch l=0.15 w=1 nf=1 m=1
M25 net6 VB5 VSS VSS nch l=0.15 w=1 nf=1 m=1
M5 net7 INN INP VSS nch l=0.15 w=1 nf=1 m=1
M6 net3 INP INP VSS nch l=0.15 w=1 nf=1 m=1
M7 INP VB2 VSS VSS nch l=0.15 w=1 nf=1 m=1
M8 net3 VB1 VDD VDD pch l=0.15 w=1 nf=1 m=1
M9 net7 VB1 VDD VDD pch l=0.15 w=1 nf=1 m=1
.ends opamp

.subckt dut VDD VSS Vout
M1 net3 net0 VDD VDD pch l=0.15 w=1 nf=1 m=1
M2 Vout net0 VDD VDD pch l=0.15 w=1 nf=1 m=1
M3 net2 net0 VDD VDD pch l=0.15 w=1 nf=1 m=1
M4 VZ net0 VDD VDD pch l=0.15 w=1 nf=1 m=1
Q1 VSS VSS net2 qpnp m=1
Q2 VSS net2 net3 qpnp m=1
Q3 VSS VSS VZ qpnp m=1
Q4 VSS VZ net1 qpnp m=1
R1 net4 net1 1k
R2 Vout net4 1k
X1 VDD VSS net0 net3 net4 VZ opamp
.ends dut
