* official Analog Canvas netlist; PDK X cards rewritten by convert.py
.model nch nmos
.model pch pmos
.model qpnp pnp

.global VDD

.subckt opamp VSS INP INN OUT VB1 VB2 VB3
M1 net2 INP net8 VDD pch l=0.15 w=1 nf=1 m=1
M10 net5 VB2 VSS VSS nch l=0.15 w=1 nf=1 m=1
M11 net8 VB1 VDD VDD pch l=0.15 w=1 nf=1 m=1
M12 net1 VY VDD VDD pch l=0.15 w=1 nf=1 m=1
M13 net1 net1 VSS VSS nch l=0.15 w=1 nf=1 m=1
M14 VY VY VDD VDD pch l=0.15 w=1 nf=1 m=1
M15 VY net7 net4 VSS nch l=0.15 w=1 nf=1 m=1
M16 net4 net1 VSS VSS nch l=0.15 w=1 nf=1 m=1
M17 net7 VY VDD VDD pch l=0.15 w=1 nf=1 m=1
M18 net7 net4 VSS VSS nch l=0.15 w=1 nf=1 m=1
M19 VC VY VDD VDD pch l=0.15 w=1 nf=1 m=1
M2 net5 INN net8 VDD pch l=0.15 w=1 nf=1 m=1
M20 VC VC net0 VSS nch l=0.15 w=1 nf=1 m=1
M21 net0 VC VSS VSS nch l=0.15 w=1 nf=1 m=1
M3 net6 VP VDD VDD pch l=0.15 w=1 nf=1 m=1
M4 net3 VP VDD VDD pch l=0.15 w=1 nf=1 m=1
M5 VP VB3 net6 VDD pch l=0.15 w=1 nf=1 m=1
M6 OUT VB3 net3 VDD pch l=0.15 w=1 nf=1 m=1
M7 VP VC net2 VSS nch l=0.15 w=1 nf=1 m=1
M8 OUT VC net5 VSS nch l=0.15 w=1 nf=1 m=1
M9 net2 VB2 VSS VSS nch l=0.15 w=1 nf=1 m=1
.ends opamp

.subckt dut VSS Vout VB1 VB2 VB3
Q1 VSS VSS X qpnp m=1
Q2 VSS VSS net0 qpnp m=1
R1 Vout X 1k
R2 Vout Y 1k
R3 Y net0 1k
X1 VSS X Y Vout VB1 VB2 VB3 opamp
.ends dut
