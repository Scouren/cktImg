* official Analog Canvas netlist; PDK X cards rewritten by convert.py
.model nch nmos

.subckt dut VDD VSS Iin Iout
I1 VDD net0 DC 1m
I2 VDD net1 DC 1m
I3 VDD Iout DC 1m
M1 net0 net0 VSS VSS nch l=0.15 w=1 nf=1 m=1
M2 Iin net0 VSS VSS nch l=0.15 w=1 nf=1 m=1
M3 net1 Iin VSS VSS nch l=0.15 w=1 nf=1 m=1
M4 Iout net1 Iin VSS nch l=0.15 w=1 nf=1 m=1
.ends dut
