* official Analog Canvas netlist; PDK X cards rewritten by convert.py
.model nch nmos
.model pch pmos
.model qnpn npn

.subckt opamp VDD VSS INN INP OUT VB FB
M1 net0 net0 VDD VDD pch l=0.15 w=1 nf=1 m=1
M2 net1 net1 VDD VDD pch l=0.15 w=1 nf=1 m=1
M3 net1 INN net2 VSS nch l=0.15 w=1 nf=1 m=1
M4 net0 INP net2 VSS nch l=0.15 w=1 nf=1 m=1
M5 OUT net0 VDD VDD pch l=0.15 w=1 nf=1 m=1
M6 FB net1 VDD VDD pch l=0.15 w=1 nf=1 m=1
M7 OUT FB VSS VSS nch l=0.15 w=1 nf=1 m=1
M8 FB FB VSS VSS nch l=0.15 w=1 nf=1 m=1
M9 net2 VB VSS VSS nch l=0.15 w=1 nf=1 m=1
.ends opamp

.subckt dut VDD VSS VB1 Vout
M10 net4 net4 net2 VSS nch l=0.15 w=1 nf=1 m=1
M11 net1 net1 VDD VDD pch l=0.15 w=1 nf=1 m=1
M12 net1 net4 VSS VSS nch l=0.15 w=1 nf=1 m=1
M13 VB2 net1 VDD VDD pch l=0.15 w=1 nf=1 m=1
M14 VB2 VB2 VSS VSS nch l=0.15 w=1 nf=1 m=1
M15 VB1 VB1 VDD VDD pch l=0.15 w=1 nf=1 m=1
M16 VB1 VB2 VSS VSS nch l=0.15 w=1 nf=1 m=1
Q1 net0 net0 VSS VSS qnpn m=1
Q2 net3 net3 VSS VSS qnpn m=1
R1 Vout net0 1k
R2 Vout net5 1k
R3 net5 net3 1k
R4 VDD net4 1k
R5 net2 VSS 1k
X1 VDD VSS net5 net0 Vout VB2 net3 opamp
.ends dut
