* official Analog Canvas netlist; PDK X cards rewritten by convert.py
.model nch nmos
.model pch pmos
.model qnpn npn

.global VDD

.subckt A1 VSS INN INP OUT VQ
M1 net2 INP net5 VSS nch l=0.15 w=1 nf=1 m=1
M10 net1 net1 VDD VDD pch l=0.15 w=1 nf=1 m=1
M11 VB3 net1 VDD VDD pch l=0.15 w=1 nf=1 m=1
M12 VB3 VB3 VSS VSS nch l=0.15 w=1 nf=1 m=1
M13 VB1 VB1 VDD VDD pch l=0.15 w=1 nf=1 m=1
M14 VB1 VB3 VSS VSS nch l=0.15 w=1 nf=1 m=1
M15 net1 VB4 VSS VSS nch l=0.15 w=1 nf=1 m=1
M16 VB4 VB4 VSS VSS nch l=0.15 w=1 nf=1 m=1
M17 VB4 VB2 VDD VDD pch l=0.15 w=1 nf=1 m=1
M18 VB2 VB4 net4 VSS nch l=0.15 w=1 nf=1 m=1
M19 VB2 VB2 VDD VDD pch l=0.15 w=1 nf=1 m=1
M2 net0 INN net5 VSS nch l=0.15 w=1 nf=1 m=1
M20 net4 net3 VSS VSS nch l=0.15 w=1 nf=1 m=1
M21 net3 net3 VSS VSS nch l=0.15 w=1 nf=1 m=1
M22 net3 VB2 VDD VDD pch l=0.15 w=1 nf=1 m=1
M3 net2 net2 VDD VDD pch l=0.15 w=1 nf=1 m=1
M4 net0 net0 VDD VDD pch l=0.15 w=1 nf=1 m=1
M5 net5 VB3 VSS VSS nch l=0.15 w=1 nf=1 m=1
M6 OUT net2 VDD VDD pch l=0.15 w=1 nf=1 m=1
M7 VQ net0 VDD VDD pch l=0.15 w=1 nf=1 m=1
M8 OUT VQ VSS VSS nch l=0.15 w=1 nf=1 m=1
M9 VQ VQ VSS VSS nch l=0.15 w=1 nf=1 m=1
.ends A1

.subckt dut VSS Vout
Q1 X X VSS VSS qnpn m=1
Q2 net0 net0 VSS VSS qnpn m=1
R1 Vout X 1k
R2 Vout Y 1k
R3 Y net0 1k
X1 VSS Y X Vout net0 A1
.ends dut
