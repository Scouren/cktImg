* official Analog Canvas netlist; PDK X cards rewritten by convert.py
.model nch nmos

.subckt dut VDD VSS Vin
C1 net1 net0 1p
C2 net0 VSS 1p
C3 X net1 1p
L1 VDD X 1n
L2 net0 VSS 1n
L3 net1 net0 1n
M1 X Vin VSS VSS nch l=0.15 w=1 nf=1 m=1
RL net0 VSS 1k
.ends dut
