* official Analog Canvas netlist; PDK X cards rewritten by convert.py
.model nch nmos
.model pch pmos

.subckt dut VDD VSS VB2 VB1 VIN1 VOUT1
M1 net0 VIN1 VSS VSS nch l=0.15 w=1 nf=1 m=1
M2 VOUT1 VB1 net0 VSS nch l=0.15 w=1 nf=1 m=1
M3 VOUT1 VB2 VDD VDD pch l=0.15 w=1 nf=1 m=1
.ends dut
