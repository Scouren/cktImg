* official Analog Canvas netlist; PDK X cards rewritten by convert.py
.model nch nmos
.model pch pmos

.subckt dut VDD VSS VREF VB2 VB4 VB6 VB5 VOUT VIN
CF1 VOUT VFB 1p
Cm1 VOUT VO1 1p
Cm2 net1 VO1 1p
M11 net2 VB2 VSS VSS nch l=0.15 w=1 nf=1 m=1
M12 net3 VFB net2 VSS nch l=0.15 w=1 nf=1 m=1
M13 VX VREF net2 VSS nch l=0.15 w=1 nf=1 m=1
M14 net11 net4 VSS VSS nch l=0.15 w=1 nf=1 m=1
M15 net7 net4 VSS VSS nch l=0.15 w=1 nf=1 m=1
M16 VG VB4 VIN VDD pch l=0.15 w=1 nf=1 m=1
M17 VG VO1 VSS VSS nch l=0.15 w=1 nf=1 m=1
M18 VG VG VSS VSS nch l=0.15 w=1 nf=1 m=1
M19 VX VB1 VIN VDD pch l=0.15 w=1 nf=1 m=1
M20 net3 VB1 VIN VDD pch l=0.15 w=1 nf=1 m=1
M21 net9 VO1 VSS VSS nch l=0.15 w=1 nf=1 m=1
M22 net5 VG VSS VSS nch l=0.15 w=1 nf=1 m=1
M23 net9 net9 VIN VDD pch l=0.15 w=1 nf=1 m=1
M24 net5 net9 VIN VDD pch l=0.15 w=1 nf=1 m=1
M25 net4 VB3 VX VDD pch l=0.15 w=1 nf=1 m=1
M26 VO1 VB3 net3 VDD pch l=0.15 w=1 nf=1 m=1
M27 net4 VBN net7 VSS nch l=0.15 w=1 nf=1 m=1
M28 VO1 VBN net11 VSS nch l=0.15 w=1 nf=1 m=1
M29 net8 VBN VSS VSS nch l=0.15 w=1 nf=1 m=1
M30 VBN VBN net8 VSS nch l=0.15 w=1 nf=1 m=1
M31 VBN net10 VIN VDD pch l=0.15 w=1 nf=1 m=1
M32 net10 net10 net12 VDD pch l=0.15 w=1 nf=1 m=1
MD1 net1 VO1 VSS VSS nch l=0.15 w=1 nf=1 m=1
MD2 net0 VB5 VSS VSS nch l=0.15 w=1 nf=1 m=1
MD3 VX net1 net0 VSS nch l=0.15 w=1 nf=1 m=1
MD4 net6 VB6 net0 VSS nch l=0.15 w=1 nf=1 m=1
MD5 net1 net6 VIN VDD pch l=0.15 w=1 nf=1 m=1
MD6 net6 net6 VIN VDD pch l=0.15 w=1 nf=1 m=1
MD7 VX VX VIN VDD pch l=0.15 w=1 nf=1 m=1
MPT VOUT net5 VIN VDD pch l=0.15 w=1 nf=1 m=1
R1 VIN net12 1k
R2 net10 VSS 1k
RF1 VOUT VFB 1k
RF2 VFB VSS 1k
.ends dut
