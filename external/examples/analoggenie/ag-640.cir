* official Analog Canvas netlist; PDK X cards rewritten by convert.py
.model nch nmos
.model pch pmos

.subckt dut Vcc VSS Threshold Trigger_bar FM Reset_bar Discharge Output
M1 net0 Threshold net2 VSS nch l=0.15 w=1 nf=1 m=1
M10 net8 Trigger_bar net6 net6 pch l=0.15 w=1 nf=1 m=1
M11 net5 net5 VSS VSS nch l=0.15 w=1 nf=1 m=1
M12 net8 net5 VSS VSS nch l=0.15 w=1 nf=1 m=1
M13 net11 net0 Vcc Vcc pch l=0.15 w=1 nf=1 m=1
M14 net11 net4 VSS VSS nch l=0.15 w=1 nf=1 m=1
M15 net8 Reset_bar Vcc Vcc pch l=0.15 w=1 nf=1 m=1
M16 net1 net11 VSS VSS nch l=0.15 w=1 nf=1 m=1
M17 net3 net8 VSS VSS nch l=0.15 w=1 nf=1 m=1
M18 net3 VB Vcc Vcc pch l=0.15 w=1 nf=1 m=1
M19 net1 VB Vcc Vcc pch l=0.15 w=1 nf=1 m=1
M2 net9 FM net2 VSS nch l=0.15 w=1 nf=1 m=1
M20 net3 net1 VSS VSS nch l=0.15 w=1 nf=1 m=1
M21 net1 net3 VSS VSS nch l=0.15 w=1 nf=1 m=1
M22 net7 net1 Vcc Vcc pch l=0.15 w=1 nf=1 m=1
M23 net7 net1 VSS VSS nch l=0.15 w=1 nf=1 m=1
M24 Discharge net7 VSS VSS nch l=0.15 w=1 nf=1 m=1
M25 Output net7 Vcc Vcc pch l=0.15 w=1 nf=1 m=10
M26 Output net7 VSS VSS nch l=0.15 w=1 nf=1 m=5
M3 net0 net9 Vcc Vcc pch l=0.15 w=1 nf=1 m=1
M4 net9 net9 Vcc Vcc pch l=0.15 w=1 nf=1 m=1
M5 net2 net4 VSS VSS nch l=0.15 w=1 nf=1 m=1
M6 VB VB Vcc Vcc pch l=0.15 w=1 nf=1 m=1
M7 net4 net4 VSS VSS nch l=0.15 w=1 nf=1 m=1
M8 net6 VB Vcc Vcc pch l=0.15 w=1 nf=1 m=1
M9 net5 net10 net6 net6 pch l=0.15 w=1 nf=1 m=1
R1 VB net4 100kΩ
R2 Vcc FM 40kΩ
R3 FM net10 40kΩ
R4 net10 VSS 40kΩ
.ends dut
