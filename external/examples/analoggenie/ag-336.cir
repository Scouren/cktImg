* official Analog Canvas netlist; PDK X cards rewritten by convert.py
.model nch nmos
.model pch pmos

.subckt dut VDD VSS Vin1 Vin2 Vb Vout1 Vout2
I1 VDD net3 DC 1m
I2 VDD net0 DC 1m
M1 net1 Vin1 net0 VDD pch l=0.15 w=1 nf=1 m=1
M1P Vout2 Vin1 net3 VDD pch l=0.15 w=1 nf=1 m=1
M2 net2 Vin2 net0 VDD pch l=0.15 w=1 nf=1 m=1
M2P Vout1 Vin2 net3 VDD pch l=0.15 w=1 nf=1 m=1
M3 net1 Vb VSS VSS nch l=0.15 w=1 nf=1 m=1
M4 net2 Vb VSS VSS nch l=0.15 w=1 nf=1 m=1
M5 Vout1 net1 VSS VSS nch l=0.15 w=1 nf=1 m=1
M6 Vout2 net2 VSS VSS nch l=0.15 w=1 nf=1 m=1
M7 Vout1 Vb VDD VDD pch l=0.15 w=1 nf=1 m=1
M8 Vout2 Vb VDD VDD pch l=0.15 w=1 nf=1 m=1
.ends dut
