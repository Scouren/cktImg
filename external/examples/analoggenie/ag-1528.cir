* official Analog Canvas netlist; PDK X cards rewritten by convert.py
.model nch nmos
.model pch pmos
.model qnpn npn

.subckt dut VDD VSS Vout
M10 net2 net2 VSS VSS nch l=0.15 w=1 nf=1 m=1
M11 Vout net2 VSS VSS nch l=0.15 w=1 nf=1 m=1
M12 net0 net0 VSS VSS nch l=0.15 w=1 nf=1 m=1
M13 VB1 net0 VSS VSS nch l=0.15 w=1 nf=1 m=1
M14 VB1 VB1 VDD VDD pch l=0.15 w=1 nf=1 m=1
M15 VB2 VB1 VDD VDD pch l=0.15 w=1 nf=1 m=1
M16 VB2 VB2 VSS VSS nch l=0.15 w=1 nf=1 m=1
M3 net2 net1 VDD VDD pch l=0.15 w=1 nf=1 m=1
M4 net1 net1 VDD VDD pch l=0.15 w=1 nf=1 m=1
M5 net3 net3 VDD VDD pch l=0.15 w=1 nf=1 m=1
M6 Vout net3 VDD VDD pch l=0.15 w=1 nf=1 m=1
M7 net1 Y net4 VSS nch l=0.15 w=1 nf=1 m=1
M8 net3 X net4 VSS nch l=0.15 w=1 nf=1 m=1
M9 net4 VB2 VSS VSS nch l=0.15 w=1 nf=1 m=1
Q1 X X VSS VSS qnpn m=1
Q2 net2 net2 VSS VSS qnpn m=1
R1 Vout X 1k
R2 Vout Y 1k
R3 Y net2 1k
R4 VDD net0 1k
.ends dut
