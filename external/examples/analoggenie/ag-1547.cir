* official Analog Canvas netlist; PDK X cards rewritten by convert.py
.model nch nmos
.model pch pmos
.model qnpn npn

.subckt dut VDD VSS VB2 VB1 Vout
M1 net3 net3 VDD VDD pch l=0.15 w=1 nf=1 m=1
M10 VB2 net1 VDD VDD pch l=0.15 w=1 nf=1 m=1
M11 net0 VB2 VSS VSS nch l=0.15 w=1 nf=1 m=1
M12 net1 net1 VDD VDD pch l=0.15 w=1 nf=1 m=1
M13 net1 VB2 VSS VSS nch l=0.15 w=1 nf=1 m=1
M14 VB3 net1 VDD VDD pch l=0.15 w=1 nf=1 m=1
M15 VB3 VB3 VSS VSS nch l=0.15 w=1 nf=1 m=1
M16 VB1 VB1 VDD VDD pch l=0.15 w=1 nf=1 m=1
M17 VB1 VB3 VSS VSS nch l=0.15 w=1 nf=1 m=1
M2 net3 X net2 VSS nch l=0.15 w=1 nf=1 m=1
M3 net4 Y net2 VSS nch l=0.15 w=1 nf=1 m=1
M4 net4 net4 VDD VDD pch l=0.15 w=1 nf=1 m=1
M5 net2 VB3 VSS VSS nch l=0.15 w=1 nf=1 m=1
M6 Z net4 VDD VDD pch l=0.15 w=1 nf=1 m=1
M7 Z Z VSS VSS nch l=0.15 w=1 nf=1 m=1
M8 Vout net3 VDD VDD pch l=0.15 w=1 nf=1 m=1
M9 Vout Z VSS VSS nch l=0.15 w=1 nf=1 m=1
Q1 X X VSS VSS qnpn m=1
Q2 Z Z VSS VSS qnpn m=1
R1 Vout X 1k
R2 Vout Y 1k
R3 Y Z 1k
R4 VB2 net0 1k
.ends dut
