* official Analog Canvas netlist; PDK X cards rewritten by convert.py
.model nch nmos
.model pch pmos
.model qnpn npn

.subckt A1 VDD VSS INN INP VB2 VB1 OUT VQ
M1 VP INN net6 VSS nch l=0.15 w=1 nf=1 m=1
M10 OUT VB1 net4 VDD pch l=0.15 w=1 nf=1 m=1
M11 net6 VB2 VSS VSS nch l=0.15 w=1 nf=1 m=1
M12 VN VC net2 VSS nch l=0.15 w=1 nf=1 m=1
M13 net2 VN VSS VSS nch l=0.15 w=1 nf=1 m=1
M14 OUT VC net3 VSS nch l=0.15 w=1 nf=1 m=1
M15 net3 VN VSS VSS nch l=0.15 w=1 nf=1 m=1
M16 VC VC VQ VSS nch l=0.15 w=1 nf=1 m=1
M17 VQ VC VSS VSS nch l=0.15 w=1 nf=1 m=1
M18 VC net5 VDD VDD pch l=0.15 w=1 nf=1 m=1
M19 net5 net5 VDD VDD pch l=0.15 w=1 nf=1 m=1
M2 net8 INP net6 VSS nch l=0.15 w=1 nf=1 m=1
M20 VP net5 VDD VDD pch l=0.15 w=1 nf=1 m=1
M21 net5 VP VB3 VSS nch l=0.15 w=1 nf=1 m=1
M22 VP VB3 VSS VSS nch l=0.15 w=1 nf=1 m=1
M3 net7 VP VDD VDD pch l=0.15 w=1 nf=1 m=1
M4 net0 net8 VDD VDD pch l=0.15 w=1 nf=1 m=1
M5 net1 VP VDD VDD pch l=0.15 w=1 nf=1 m=1
M6 net4 net8 VDD VDD pch l=0.15 w=1 nf=1 m=1
M7 VP VB1 net7 VDD pch l=0.15 w=1 nf=1 m=1
M8 net8 VB1 net0 VDD pch l=0.15 w=1 nf=1 m=1
M9 VN VB1 net1 VDD pch l=0.15 w=1 nf=1 m=1
R4 VB3 VSS 1k
.ends A1

.subckt dut VDD VSS Vout VB1 VB2
Q1 X X VSS VSS qnpn m=1
Q2 net0 net0 VSS VSS qnpn m=1
R1 Vout X 1k
R2 Vout Y 1k
R3 Y net0 1k
X1 VDD VSS Y X VB2 VB1 Vout net0 A1
.ends dut
