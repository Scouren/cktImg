* official Analog Canvas netlist; PDK X cards rewritten by convert.py
.model nch nmos

.subckt dut VDD VSS CK CK_bar
I1 net11 VSS DC 1m
I2 net13 VSS DC 1m
L1 VDD net3 1n
L2 VDD net0 1n
L3 VDD net2 1n
L4 VDD net1 1n
M1 net6 net4 net8 VSS nch l=0.15 w=1 nf=1 m=1
M10 net5 CK_bar net11 VSS nch l=0.15 w=1 nf=1 m=1
M11 net12 CK_bar net13 VSS nch l=0.15 w=1 nf=1 m=1
M12 net10 CK net13 VSS nch l=0.15 w=1 nf=1 m=1
M2 net7 net9 net8 VSS nch l=0.15 w=1 nf=1 m=1
M3 net7 net6 net5 VSS nch l=0.15 w=1 nf=1 m=1
M4 net6 net7 net5 VSS nch l=0.15 w=1 nf=1 m=1
M5 net9 net6 net12 VSS nch l=0.15 w=1 nf=1 m=1
M6 net4 net7 net12 VSS nch l=0.15 w=1 nf=1 m=1
M7 net4 net9 net10 VSS nch l=0.15 w=1 nf=1 m=1
M8 net9 net4 net10 VSS nch l=0.15 w=1 nf=1 m=1
M9 net8 CK net11 VSS nch l=0.15 w=1 nf=1 m=1
R1 net3 net7 1k
R2 net0 net6 1k
R3 net2 net4 1k
R4 net1 net9 1k
.ends dut
