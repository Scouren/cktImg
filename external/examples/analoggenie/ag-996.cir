* official Analog Canvas netlist; PDK X cards rewritten by convert.py
.model nch nmos
.model pch pmos

.subckt icm_opamp_vdd_vss VDD VSS VIP VIN VOUT params: gain=1e6
Blin nlin 0 V={gain*(V(VIP)-V(VIN))}
Bcore VOUT 0 V={0.5*(V(VDD)+(0.5*(V(VSS)+V(nlin)+sqrt((V(nlin)-V(VSS))*(V(nlin)-V(VSS))+(1e-4*(V(VDD)-V(VSS)))*(1e-4*(V(VDD)-V(VSS)))+1e-12)))-sqrt((V(VDD)-(0.5*(V(VSS)+V(nlin)+sqrt((V(nlin)-V(VSS))*(V(nlin)-V(VSS))+(1e-4*(V(VDD)-V(VSS)))*(1e-4*(V(VDD)-V(VSS)))+1e-12))))*(V(VDD)-(0.5*(V(VSS)+V(nlin)+sqrt((V(nlin)-V(VSS))*(V(nlin)-V(VSS))+(1e-4*(V(VDD)-V(VSS)))*(1e-4*(V(VDD)-V(VSS)))+1e-12))))+(1e-4*(V(VDD)-V(VSS)))*(1e-4*(V(VDD)-V(VSS)))+1e-12))}
.ends icm_opamp_vdd_vss

.subckt dut VDD VSS Vinp Vinn VBIASN VBIASP vout
Cc net1 net7 1p
Cc1 vout net2 1p
Cc2 net10 vout 1p
M1 VX net1 net9 VSS nch l=0.15 w=1 nf=1 m=1
M10 net5 net5 net0 VSS nch l=0.15 w=1 nf=1 m=1
M11 net0 net0 VSS VSS nch l=0.15 w=1 nf=1 m=1
M12 VS net0 VSS VSS nch l=0.15 w=1 nf=1 m=1
M13 VS VBIASN VSS VSS nch l=0.15 w=1 nf=1 m=1
M16 net1 net7 VDD VDD pch l=0.15 w=1 nf=1 m=1
M17 VF VBIASN VSS VSS nch l=0.15 w=1 nf=1 m=1
M1A VY VF net13 VDD pch l=0.15 w=1 nf=1 m=1
M2 net6 vout net9 VSS nch l=0.15 w=1 nf=1 m=1
M2A net11 VS net13 VDD pch l=0.15 w=1 nf=1 m=1
M3 VX net6 VDD VDD pch l=0.15 w=1 nf=1 m=1
M3A VY net11 VSS VSS nch l=0.15 w=1 nf=1 m=1
M3H VX VBIASP VDD VDD pch l=0.15 w=1 nf=1 m=1
M3HA VY VBIASN VSS VSS nch l=0.15 w=1 nf=1 m=1
M4 net6 net6 VDD VDD pch l=0.15 w=1 nf=1 m=1
M4A net11 net11 VSS VSS nch l=0.15 w=1 nf=1 m=1
M4H net6 VBIASP VDD VDD pch l=0.15 w=1 nf=1 m=1
M4HA net11 VBIASN VSS VSS nch l=0.15 w=1 nf=1 m=1
M5 net9 VBIASN VSS VSS nch l=0.15 w=1 nf=1 m=1
M5A net13 VBIASP VDD VDD pch l=0.15 w=1 nf=1 m=1
M6 vout VX VDD VDD pch l=0.15 w=1 nf=1 m=1
M6A vout VY VSS VSS nch l=0.15 w=1 nf=1 m=1
M8 net1 net1 VF VSS nch l=0.15 w=1 nf=1 m=1
M8A VDD vout VS VSS nch l=0.15 w=1 nf=1 m=1
M9 net5 VX VDD VDD pch l=0.15 w=1 nf=1 m=1
MN3 net3 VBIASN VSS VSS nch l=0.15 w=1 nf=1 m=1
MN3A net12 VY VSS VSS nch l=0.15 w=1 nf=1 m=1
MN4 net4 net3 VSS VSS nch l=0.15 w=1 nf=1 m=1
MN4A net8 VBIASN VSS VSS nch l=0.15 w=1 nf=1 m=1
MN5A VY net8 VSS VSS nch l=0.15 w=1 nf=1 m=1
MP3 net3 VX VDD VDD pch l=0.15 w=1 nf=1 m=1
MP3A net12 VBIASP VDD VDD pch l=0.15 w=1 nf=1 m=1
MP4 net4 VBIASP VDD VDD pch l=0.15 w=1 nf=1 m=1
MP4A net8 net12 VDD VDD pch l=0.15 w=1 nf=1 m=1
MP5 VX net4 VDD VDD pch l=0.15 w=1 nf=1 m=1
MR1 net2 VSS VX VDD pch l=0.15 w=1 nf=1 m=1
MR2 VY VDD net10 VSS nch l=0.15 w=1 nf=1 m=1
X1 VDD VSS Vinp Vinn net7 icm_opamp_vdd_vss gain=1e6
.ends dut
