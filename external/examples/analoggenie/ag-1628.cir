* official Analog Canvas netlist; PDK X cards rewritten by convert.py
.model nch nmos
.model pch pmos
.model qpnp pnp

.subckt opamp VDD VSS INN INP OUT
M10 OUT VM VSS VSS nch l=0.15 w=1 nf=1 m=1
M11 net2 net2 VDD VDD pch l=0.15 w=1 nf=1 m=1
M12 net2 VB4 VSS VSS nch l=0.15 w=1 nf=1 m=1
M13 VB4 net2 VDD VDD pch l=0.15 w=1 nf=1 m=1
M14 net5 VB4 VSS VSS nch l=0.15 w=1 nf=1 m=1
M15 net0 net0 VDD VDD pch l=0.15 w=1 nf=1 m=1
M16 net0 VB4 VSS VSS nch l=0.15 w=1 nf=1 m=1
M17 VB3 net0 VDD VDD pch l=0.15 w=1 nf=1 m=1
M18 VB3 VB3 VSS VSS nch l=0.15 w=1 nf=1 m=1
M19 net1 net1 VDD VDD pch l=0.15 w=1 nf=1 m=1
M2 net4 INP net6 VSS nch l=0.15 w=1 nf=1 m=1
M20 net1 VB3 VSS VSS nch l=0.15 w=1 nf=1 m=1
M3 net3 INN net6 VSS nch l=0.15 w=1 nf=1 m=1
M4 net3 net3 VDD VDD pch l=0.15 w=1 nf=1 m=1
M5 net4 net4 VDD VDD pch l=0.15 w=1 nf=1 m=1
M6 VM net3 VDD VDD pch l=0.15 w=1 nf=1 m=1
M7 OUT net4 VDD VDD pch l=0.15 w=1 nf=1 m=1
M8 net6 VB3 VSS VSS nch l=0.15 w=1 nf=1 m=1
M9 VM VM VSS VSS nch l=0.15 w=1 nf=1 m=1
R4 VB4 net5 1k
.ends opamp

.subckt dut VDD VSS Vout
Q1 VSS VSS X qpnp m=1
Q2 VSS VSS net0 qpnp m=1
R1 Vout X 1k
R2 Vout Y 1k
R3 Y net0 1k
X1 VDD VSS Y X Vout opamp
.ends dut
