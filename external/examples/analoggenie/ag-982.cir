* official Analog Canvas netlist; PDK X cards rewritten by convert.py
.model nch nmos
.model pch pmos

.subckt dut VDD VSS Vinp Vinn VPBias2 VNBias1
M1 net8 Vinp net1 VSS nch l=0.15 w=1 nf=1 m=1
M2 net5 Vinn net1 VSS nch l=0.15 w=1 nf=1 m=1
M3 net4 net2 VDD VDD pch l=0.15 w=1 nf=1 m=1
M4 net6 net2 VDD VDD pch l=0.15 w=1 nf=1 m=1
M5 net1 VNBias1 VSS VSS nch l=0.15 w=1 nf=1 m=1
MB1 net0 Vinp net1 VSS nch l=0.15 w=1 nf=1 m=1
MB2 net0 Vinn net1 VSS nch l=0.15 w=1 nf=1 m=1
MB3 net0 net0 VDD VDD pch l=0.15 w=1 nf=1 m=1
MB4 net3 net0 VDD VDD pch l=0.15 w=1 nf=1 m=1
MB5 net3 net3 net1 VSS nch l=0.15 w=1 nf=1 m=1
MC1 net2 net3 net8 VSS nch l=0.15 w=1 nf=1 m=1
MC2 net7 net3 net5 VSS nch l=0.15 w=1 nf=1 m=1
MC3 net2 VPBias2 net4 VDD pch l=0.15 w=1 nf=1 m=1
MC4 net7 VPBias2 net6 VDD pch l=0.15 w=1 nf=1 m=1
.ends dut
