* official Analog Canvas netlist; PDK X cards rewritten by convert.py
.model nch nmos
.model pch pmos

.subckt EA VDD VSS VFP1 VX1 VN VREF VEA
MN1 net7 VFP1 net1 VSS nch l=0.15 w=1 nf=1 m=1
MN10 VEA VB5 net6 VSS nch l=0.15 w=1 nf=1 m=1
MN11 VX1 net8 VSS VSS nch l=0.15 w=1 nf=1 m=1
MN12 net6 net8 VSS VSS nch l=0.15 w=1 nf=1 m=1
MN13 net5 VB3 VSS VSS nch l=0.15 w=1 nf=1 m=1
MN14 VB5 VB5 net3 VSS nch l=0.15 w=1 nf=1 m=1
MN15 net3 VB5 VSS VSS nch l=0.15 w=1 nf=1 m=1
MN2 net2 VREF net1 VSS nch l=0.15 w=1 nf=1 m=1
MN3 net0 VB3 VSS VSS nch l=0.15 w=1 nf=1 m=1
MN4 net1 VB2 VSS VSS nch l=0.15 w=1 nf=1 m=1
MN9 net8 VB5 VX1 VSS nch l=0.15 w=1 nf=1 m=1
MP1 net4 net7 VDD VDD pch l=0.15 w=1 nf=1 m=1
MP10 net2 VB1 VN VDD pch l=0.15 w=1 nf=1 m=1
MP11 net8 VB1 VFP1 VDD pch l=0.15 w=1 nf=1 m=1
MP12 VEA VB1 net9 VDD pch l=0.15 w=1 nf=1 m=1
MP13 net0 net0 VDD VDD pch l=0.15 w=1 nf=1 m=1
MP14 VB3 net0 VDD VDD pch l=0.15 w=1 nf=1 m=1
MP15 VB5 net0 VDD VDD pch l=0.15 w=1 nf=1 m=1
MP2 VN net2 VDD VDD pch l=0.15 w=1 nf=1 m=1
MP7 VFP1 net7 VDD VDD pch l=0.15 w=1 nf=1 m=1
MP8 net9 net2 VDD VDD pch l=0.15 w=1 nf=1 m=1
MP9 net7 VB1 net4 VDD pch l=0.15 w=1 nf=1 m=1
R3 VB3 net5 1k
.ends EA

.subckt dut VDD VSS VS5 VS1 VIN VS3 VS4 VP VB4 VS2 VREF
.model DIODE D(IS=1e-14 N=1)
CFLY VX1 VX2 1p
CO VP VN 1p
COP VP VSS 1p
D1 VN VX2 DIODE
L1 VX1 VX3 1n
M1 VIN VS1 VX1 VDD pch l=0.15 w=1 nf=1 m=1
M2 VX2 VS2 VIN VDD pch l=0.15 w=1 nf=1 m=1
M3 VX3 VS3 VP VDD pch l=0.15 w=1 nf=1 m=1
M4 VX3 VS4 VSS VSS nch l=0.15 w=1 nf=1 m=1
M5 VIN VS5 net0 VDD pch l=0.15 w=1 nf=1 m=1
MN5 net1 VB4 VSS VSS nch l=0.15 w=1 nf=1 m=1
MN6 net2 net1 VSS VSS nch l=0.15 w=1 nf=1 m=1
MN7 net1 net1 VSS VSS nch l=0.15 w=1 nf=1 m=1
MP3 net1 net3 net0 VDD pch l=0.15 w=1 nf=1 m=1
MP4 net2 net2 net0 VDD pch l=0.15 w=1 nf=1 m=1
MP5 VX1 net2 net0 VDD pch l=0.15 w=1 nf=1 m=1
R1 VP VFP1 1k
R2 VFP1 VSS 1k
X1 VDD VSS VFP1 VX1 VN VREF net3 EA
.ends dut
