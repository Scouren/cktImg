* official Analog Canvas netlist; PDK X cards rewritten by convert.py
.model nch nmos
.model pch pmos
.model qnpn npn

.subckt opamp VDD VSS INN INP OUT
M1 net0 VB1 VDD VDD pch l=0.15 w=1 nf=1 m=1
M10 net4 VX VSS VSS nch l=0.15 w=1 nf=1 m=1
M11 net3 VX VSS VSS nch l=0.15 w=1 nf=1 m=1
M12 VX net1 VDD VDD pch l=0.15 w=1 nf=1 m=1
M13 net1 net1 VDD VDD pch l=0.15 w=1 nf=1 m=1
M14 VB4 net1 VDD VDD pch l=0.15 w=1 nf=1 m=1
M15 net1 VX net6 VSS nch l=0.15 w=1 nf=1 m=1
M16 VX net6 VSS VSS nch l=0.15 w=1 nf=1 m=1
M17 VB4 VB4 VB5 VSS nch l=0.15 w=1 nf=1 m=1
M18 VB5 VB5 VSS VSS nch l=0.15 w=1 nf=1 m=1
M2 net2 VB1 VDD VDD pch l=0.15 w=1 nf=1 m=1
M3 VX VB2 net0 VDD pch l=0.15 w=1 nf=1 m=1
M4 OUT VB2 net2 VDD pch l=0.15 w=1 nf=1 m=1
M5 net0 INN net5 VSS nch l=0.15 w=1 nf=1 m=1
M6 net2 INP net5 VSS nch l=0.15 w=1 nf=1 m=1
M7 net5 VB5 VSS VSS nch l=0.15 w=1 nf=1 m=1
M8 VX VB4 net4 VSS nch l=0.15 w=1 nf=1 m=1
M9 OUT VB4 net3 VSS nch l=0.15 w=1 nf=1 m=1
R4 net6 VSS 1k
.ends opamp

.subckt dut VDD VSS Vout
Q1 X X VSS VSS qnpn m=1
Q2 net0 net0 VSS VSS qnpn m=1
R1 Vout X 1k
R2 Vout Y 1k
R3 Y net0 1k
X1 VDD VSS Y X Vout opamp
.ends dut
