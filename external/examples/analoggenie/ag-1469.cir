* official Analog Canvas netlist; PDK X cards rewritten by convert.py
.model nch nmos
.model pch pmos
.model qnpn npn

.subckt opamp VDD VSS INN INP VB1 VB2 VB5 OUT
M1 net4 net8 VDD VDD pch l=0.15 w=1 nf=1 m=1
M10 net3 VB5 net6 VSS nch l=0.15 w=1 nf=1 m=1
M11 OUT VB5 net2 VSS nch l=0.15 w=1 nf=1 m=1
M12 net0 INP net9 VSS nch l=0.15 w=1 nf=1 m=1
M13 net6 net3 VSS VSS nch l=0.15 w=1 nf=1 m=1
M14 net2 net3 VSS VSS nch l=0.15 w=1 nf=1 m=1
M15 net9 VB2 VSS VSS nch l=0.15 w=1 nf=1 m=1
M2 net5 net8 VDD VDD pch l=0.15 w=1 nf=1 m=1
M3 net1 net0 VDD VDD pch l=0.15 w=1 nf=1 m=1
M4 net7 net0 VDD VDD pch l=0.15 w=1 nf=1 m=1
M5 net8 VB1 net4 VDD pch l=0.15 w=1 nf=1 m=1
M6 net3 VB1 net5 VDD pch l=0.15 w=1 nf=1 m=1
M7 OUT VB1 net1 VDD pch l=0.15 w=1 nf=1 m=1
M8 net0 VB1 net7 VDD pch l=0.15 w=1 nf=1 m=1
M9 net8 INN net9 VSS nch l=0.15 w=1 nf=1 m=1
.ends opamp

.subckt dut VDD VSS Vout VB1 VB2
M17 net0 VP VDD VDD pch l=0.15 w=1 nf=1 m=1
M18 VP VP VDD VDD pch l=0.15 w=1 nf=1 m=1
M19 VB4 VP VDD VDD pch l=0.15 w=1 nf=1 m=1
M20 VB5 VP VDD VDD pch l=0.15 w=1 nf=1 m=1
M21 net0 net0 VSS VSS nch l=0.15 w=1 nf=1 m=1
M22 VP VB4 VB3 VSS nch l=0.15 w=1 nf=1 m=1
M23 VB3 net0 VSS VSS nch l=0.15 w=1 nf=1 m=1
M24 VB4 VB3 VSS VSS nch l=0.15 w=1 nf=1 m=1
M25 VB5 VB5 Z VSS nch l=0.15 w=1 nf=1 m=1
M26 Z VB5 VSS VSS nch l=0.15 w=1 nf=1 m=1
Q1 X X VSS VSS qnpn m=1
Q2 Z Z VSS VSS qnpn m=1
R1 Vout X 1k
R2 Vout Y 1k
R3 Y Z 1k
X1 VDD VSS Y X VB1 VB2 VB5 Vout opamp
.ends dut
