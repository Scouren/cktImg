* official Analog Canvas netlist; PDK X cards rewritten by convert.py
.model nch nmos
.model pch pmos

.subckt dut VDD VSS Vtune Dtune0 Dtune1 Ckvco0 CkvcoV Ckvco1 Dunit
.model ideal_switch SW(RON=1 ROFF=1e12 VT=0.5 VH=0)
I1 VDD net4 DC 1m
L1 net3 net5 1n
M1 net1 net5 net1 VSS nch l=0.15 w=1 nf=1 m=1
M2 net1 net3 net1 VSS nch l=0.15 w=1 nf=1 m=1
M3 net0 net5 net0 VSS nch l=0.15 w=1 nf=1 m=1
M4 net0 net3 net0 VSS nch l=0.15 w=1 nf=1 m=1
M5 net6 net3 net4 VDD pch l=0.15 w=1 nf=1 m=1
M6 net2 net5 net4 VDD pch l=0.15 w=1 nf=1 m=1
M7 net6 net3 VSS VSS nch l=0.15 w=1 nf=1 m=1
M8 net2 net5 VSS VSS nch l=0.15 w=1 nf=1 m=1
S1 VSS net1 Dtune0 VSS ideal_switch
S2 VDD net1 Dtune1 VSS ideal_switch
S3 VSS net0 Ckvco0 VSS ideal_switch
S4 Vtune net0 CkvcoV VSS ideal_switch
S5 VDD net0 Ckvco1 VSS ideal_switch
S6 net6 net5 Dunit VSS ideal_switch
S7 net3 net2 Dunit VSS ideal_switch
.ends dut
