* official Analog Canvas netlist; PDK X cards rewritten by convert.py
.model nch nmos
.model pch pmos
.model qpnp pnp

.global VDD

.subckt opamp VSS INN INP OUT
M1 net4 INP net7 VSS nch l=0.15 w=1 nf=1 m=1
M10 OUT net3 VSS VSS nch l=0.15 w=1 nf=1 m=1
M11 VB2 VB2 VDD VDD pch l=0.15 w=1 nf=1 m=1
M12 VB2 net1 VSS VSS nch l=0.15 w=1 nf=1 m=1
M13 net0 VB2 VDD VDD pch l=0.15 w=1 nf=1 m=1
M14 net0 net0 net1 VSS nch l=0.15 w=1 nf=1 m=1
M15 net1 net0 net5 VSS nch l=0.15 w=1 nf=1 m=1
M16 net5 net2 VB1 VSS nch l=0.15 w=1 nf=1 m=1
M17 VB1 VB1 VSS VSS nch l=0.15 w=1 nf=1 m=1
M18 net2 VB2 VDD VDD pch l=0.15 w=1 nf=1 m=1
M19 net2 net2 net5 VSS nch l=0.15 w=1 nf=1 m=1
M2 net6 INN net7 VSS nch l=0.15 w=1 nf=1 m=1
M20 VB1 VB2 VDD VDD pch l=0.15 w=1 nf=1 m=1
M21 VB3 VB2 VDD VDD pch l=0.15 w=1 nf=1 m=1
M22 VB3 VB3 VSS VSS nch l=0.15 w=1 nf=1 m=1
M3 net7 VB3 VSS VSS nch l=0.15 w=1 nf=1 m=1
M5 net6 net6 VDD VDD pch l=0.15 w=1 nf=1 m=1
M6 net4 net4 VDD VDD pch l=0.15 w=1 nf=1 m=1
M7 net3 net6 VDD VDD pch l=0.15 w=1 nf=1 m=1
M8 OUT net4 VDD VDD pch l=0.15 w=1 nf=1 m=1
M9 net3 net3 VSS VSS nch l=0.15 w=1 nf=1 m=1
.ends opamp

.subckt dut VSS Vout
Q1 VSS VSS X qpnp m=1
Q2 VSS VSS net0 qpnp m=1
R1 Vout X 1k
R2 Vout Y 1k
R3 Y net0 1k
X1 VSS Y X Vout opamp
.ends dut
