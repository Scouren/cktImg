* official Analog Canvas netlist; PDK X cards rewritten by convert.py
.model pch pmos

.subckt icm_opamp_vdd_vss VDD VSS VIP VIN VOUT params: gain=1e6
Blin nlin 0 V={gain*(V(VIP)-V(VIN))}
Bcore VOUT 0 V={0.5*(V(VDD)+(0.5*(V(VSS)+V(nlin)+sqrt((V(nlin)-V(VSS))*(V(nlin)-V(VSS))+(1e-4*(V(VDD)-V(VSS)))*(1e-4*(V(VDD)-V(VSS)))+1e-12)))-sqrt((V(VDD)-(0.5*(V(VSS)+V(nlin)+sqrt((V(nlin)-V(VSS))*(V(nlin)-V(VSS))+(1e-4*(V(VDD)-V(VSS)))*(1e-4*(V(VDD)-V(VSS)))+1e-12))))*(V(VDD)-(0.5*(V(VSS)+V(nlin)+sqrt((V(nlin)-V(VSS))*(V(nlin)-V(VSS))+(1e-4*(V(VDD)-V(VSS)))*(1e-4*(V(VDD)-V(VSS)))+1e-12))))+(1e-4*(V(VDD)-V(VSS)))*(1e-4*(V(VDD)-V(VSS)))+1e-12))}
.ends icm_opamp_vdd_vss

.subckt dut VDD VSS Vref Vbias d1 d2 Vout
M1 VSS d1 net2 VDD pch l=0.15 w=1 nf=1 m=1
M2 Vout Vbias net2 VDD pch l=0.15 w=1 nf=1 m=1
M3 net2 net3 VDD VDD pch l=0.15 w=1 nf=1 m=1
M4 net1 net3 VDD VDD pch l=0.15 w=1 nf=1 m=1
M5 net4 Vbias net1 VDD pch l=0.15 w=1 nf=1 m=1
M6 net0 net3 VDD VDD pch l=0.15 w=1 nf=1 m=1
M7 VSS d2 net0 VDD pch l=0.15 w=1 nf=1 m=1
M8 Vout Vbias net0 VDD pch l=0.15 w=1 nf=1 m=1
R1 Vout VSS 50Ω
Rref net4 VSS 1k
X1 VDD VSS net4 Vref net3 icm_opamp_vdd_vss gain=1e6
.ends dut
