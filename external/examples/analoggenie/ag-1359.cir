* official Analog Canvas netlist; PDK X cards rewritten by convert.py
.model nch nmos
.model pch pmos

.subckt dut VDD VSS VSTO VCONT1 VCONT2 VCONT3 VOUT
CL VOUT VSS 1p
CSTO VSTO VSS 1p
LRX VX1 VX2 1n
M1 net10 net2 VDD VDD pch l=0.15 w=1 nf=1 m=1
M10 net2 VX2 net9 VSS nch l=0.15 w=1 nf=1 m=1
M11 net8 VG net9 VSS nch l=0.15 w=1 nf=1 m=1
M12 VG VB4 net1 VSS nch l=0.15 w=1 nf=1 m=1
M13 net3 VX1 VSS VSS nch l=0.15 w=1 nf=1 m=1
M14 net9 VB2 VSS VSS nch l=0.15 w=1 nf=1 m=1
M15 net1 VX1 VSS VSS nch l=0.15 w=1 nf=1 m=1
M16 VB3 net0 VDD VDD pch l=0.15 w=1 nf=1 m=1
M17 net0 net0 VDD VDD pch l=0.15 w=1 nf=1 m=1
M18 VB4 net0 VDD VDD pch l=0.15 w=1 nf=1 m=1
M19 VB3 VB3 VSS VSS nch l=0.15 w=1 nf=1 m=1
M2 net11 net2 VDD VDD pch l=0.15 w=1 nf=1 m=1
M20 net0 VB3 net5 VSS nch l=0.15 w=1 nf=1 m=1
M21 VB4 VB4 net6 VSS nch l=0.15 w=1 nf=1 m=1
M22 net6 VB4 VSS VSS nch l=0.15 w=1 nf=1 m=1
M3 net7 net8 VDD VDD pch l=0.15 w=1 nf=1 m=1
M4 net4 net8 VDD VDD pch l=0.15 w=1 nf=1 m=1
M5 VX1 VB1 net10 VDD pch l=0.15 w=1 nf=1 m=1
M6 net2 VB1 net11 VDD pch l=0.15 w=1 nf=1 m=1
M7 net8 VB1 net7 VDD pch l=0.15 w=1 nf=1 m=1
M8 VG VB1 net4 VDD pch l=0.15 w=1 nf=1 m=1
M9 VX1 VB4 net3 VSS nch l=0.15 w=1 nf=1 m=1
MN1 VX1 VCONT2 VSS VSS nch l=0.15 w=1 nf=1 m=1
MN2 VX2 VCONT3 VSS VSS nch l=0.15 w=1 nf=1 m=1
MP2 VX2 VG VOUT VDD pch l=0.15 w=1 nf=1 m=1
MP3 VX1 VCONT1 VSTO VDD pch l=0.15 w=1 nf=1 m=1
R1 net5 VSS 1k
.ends dut
