* official Analog Canvas netlist; PDK X cards rewritten by convert.py
.model nch nmos
.model pch pmos
.model qnpn npn

.subckt dut VDD VSS Vout VB1 VB2
M1 net2 net2 VDD VDD pch l=0.15 w=1 nf=1 m=1
M10 net0 net0 VDD VDD pch l=0.15 w=1 nf=1 m=1
M11 VB3 net0 VDD VDD pch l=0.15 w=1 nf=1 m=1
M12 VB1 VB1 VDD VDD pch l=0.15 w=1 nf=1 m=1
M13 net0 VX VSS VSS nch l=0.15 w=1 nf=1 m=1
M14 VB3 VB3 VSS VSS nch l=0.15 w=1 nf=1 m=1
M15 VB1 VB3 VSS VSS nch l=0.15 w=1 nf=1 m=1
M16 net4 VB2 VDD VDD pch l=0.15 w=1 nf=1 m=1
M17 VB2 VB2 VDD VDD pch l=0.15 w=1 nf=1 m=1
M18 net4 VX VSS VSS nch l=0.15 w=1 nf=1 m=1
M19 VB2 net4 VX VSS nch l=0.15 w=1 nf=1 m=1
M2 net1 net1 VDD VDD pch l=0.15 w=1 nf=1 m=1
M3 net1 Y net3 VSS nch l=0.15 w=1 nf=1 m=1
M4 net2 X net3 VSS nch l=0.15 w=1 nf=1 m=1
M5 Vout net2 VDD VDD pch l=0.15 w=1 nf=1 m=1
M6 Z net1 VDD VDD pch l=0.15 w=1 nf=1 m=1
M7 net3 VB3 VSS VSS nch l=0.15 w=1 nf=1 m=1
M8 Z Z VSS VSS nch l=0.15 w=1 nf=1 m=1
M9 Vout Z VSS VSS nch l=0.15 w=1 nf=1 m=1
Q1 X X VSS VSS qnpn m=1
Q2 Z Z VSS VSS qnpn m=1
R1 Vout X 1k
R2 Vout Y 1k
R3 Y Z 1k
R4 VX VSS 1k
.ends dut
