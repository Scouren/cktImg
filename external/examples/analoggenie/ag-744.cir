* official Analog Canvas netlist; PDK X cards rewritten by convert.py
.model nch nmos
.model pch pmos
.model qnpn npn

* Ideal inverter: switches at V(VDD,VSS)/2; vt sets the step width, td the delay
.subckt inverter VDD VSS A Y params: vt=10m td=10p
BhA hA 0 V={0.5*(1+tanh((V(A,VSS)-0.5*V(VDD,VSS))/vt))}
Bf nfn VSS V={V(VDD,VSS)*(1-V(hA))}
Rd nfn ndl 1k
Cd ndl VSS {td/1000}
BY Y VSS V={V(ndl,VSS)}
.ends inverter

.subckt dut VEE VSS phi1 phi2 Vin+ Vin- Vout+ Vout-
C1 Vin+ net8 1p
C2 net6 Vin- 1p
C3 net7 VEE 1p
M1 net8 phi1 VSS VSS pch l=0.15 w=1 nf=1 m=1
M10 net0 phi2 VEE VEE nch l=0.15 w=1 nf=1 m=1
M11 net7 phi2 VEE VEE nch l=0.15 w=1 nf=1 m=1
M12 net7 phi2 net3 VSS pch l=0.15 w=1 nf=1 m=1
M2 VSS phi1 net6 VSS pch l=0.15 w=1 nf=1 m=1
M3 net1 net2 net8 VSS pch l=0.15 w=1 nf=1 m=1
M4 net5 net2 net6 VSS pch l=0.15 w=1 nf=1 m=1
M5 net4 net0 net1 VSS pch l=0.15 w=1 nf=1 m=1
M6 net0 net4 net5 VSS pch l=0.15 w=1 nf=1 m=1
M7 net4 net0 VEE VEE nch l=0.15 w=1 nf=1 m=1
M8 net0 net4 VEE VEE nch l=0.15 w=1 nf=1 m=1
M9 net4 phi2 VEE VEE nch l=0.15 w=1 nf=1 m=1
Q5 net8 net6 net3 VEE qnpn m=1
Q6 net6 net8 net3 VEE qnpn m=1
X1 VSS VEE net7 net2 inverter td=10p vt=10m
X2 VSS VEE net4 Vout+ inverter td=10p vt=10m
X3 VSS VEE net0 Vout- inverter td=10p vt=10m
.ends dut
