* official Analog Canvas netlist; PDK X cards rewritten by convert.py
.model nch nmos
.model pch pmos

.subckt dut VDD VSS Vo
M1 net3 net1 VSS VSS nch l=0.15 w=1 nf=1 m=1
M2 net0 net0 VDD VDD pch l=0.15 w=1 nf=1 m=1
M3 net3 net0 VDD VDD pch l=0.15 w=1 nf=1 m=1
M4 Vo net2 net3 VSS nch l=0.15 w=1 nf=1 m=1
M5 Vo net0 VDD VDD pch l=0.15 w=1 nf=1 m=1
M6 Vo net3 VSS VSS nch l=0.15 w=1 nf=1 m=1
R1 net0 VSS 10kΩ
Vc net2 VSS DC 1
Vi net1 VSS DC 1
.ends dut
