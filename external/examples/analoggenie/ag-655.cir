* official Analog Canvas netlist; PDK X cards rewritten by convert.py
.model qnpn npn

.subckt dut VSS IOUT1 IOUT2
I1 net4 VSS DC 1mA
I2 net5 VSS DC 50uA
I3 net3 VSS DC 50uA
Q1 VSS VSS net5 VSS qnpn m=1
Q2 IOUT1 net5 net4 VSS qnpn m=1
Q3 IOUT2 net3 net4 VSS qnpn m=1
Q4 VSS VSS net3 VSS qnpn m=1
.ends dut
