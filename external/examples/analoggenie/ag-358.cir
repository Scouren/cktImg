* official Analog Canvas netlist; PDK X cards rewritten by convert.py
.model nch nmos

.subckt dut VDD VSS Vin1 Vin2
I1 VDD net0 DC 25uA
M1 NC0001 Vin1 net2 VSS nch l=0.15 w=1 nf=1 m=1
M11 net2 net0 VSS VSS nch l=0.15 w=1 nf=1 m=1
M12 net1 net0 VSS VSS nch l=0.15 w=1 nf=1 m=1
M2 NC0002 Vin2 net2 VSS nch l=0.15 w=1 nf=1 m=1
R1 net0 net1 8kΩ
.ends dut
