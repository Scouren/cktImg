* official Analog Canvas netlist; PDK X cards rewritten by convert.py
.model nch nmos
.model pch pmos

.subckt opamp VDD VSS INN INP OUT
M10 VX INN VDD VDD pch l=0.15 w=1 nf=1 m=1
M11 VX VX VSS VSS nch l=0.15 w=1 nf=1 m=1
M12 VX VX VDD VDD pch l=0.15 w=1 nf=1 m=1
M13 VX VB3 VSS VSS nch l=0.15 w=1 nf=1 m=1
M14 VB3 VB3 VSS VSS nch l=0.15 w=1 nf=1 m=1
M15 VB3 VX VDD VDD pch l=0.15 w=1 nf=1 m=1
M16 net1 VB3 VSS VSS nch l=0.15 w=1 nf=1 m=1
M17 net1 net1 VDD VDD pch l=0.15 w=1 nf=1 m=1
M18 VB2 net1 VDD VDD pch l=0.15 w=1 nf=1 m=1
M19 VB2 VB2 VSS VSS nch l=0.15 w=1 nf=1 m=1
M20 VB1 VB1 VDD VDD pch l=0.15 w=1 nf=1 m=1
M21 VB1 VB2 VSS VSS nch l=0.15 w=1 nf=1 m=1
M3 INN INN net3 VSS nch l=0.15 w=1 nf=1 m=1
M4 net0 INP net3 VSS nch l=0.15 w=1 nf=1 m=1
M5 INN net2 VDD VDD pch l=0.15 w=1 nf=1 m=1
M6 net0 net2 VDD VDD pch l=0.15 w=1 nf=1 m=1
M7 net3 VB2 VSS VSS nch l=0.15 w=1 nf=1 m=1
M8 OUT net0 VDD VDD pch l=0.15 w=1 nf=1 m=1
M9 OUT VX VSS VSS nch l=0.15 w=1 nf=1 m=1
R1 VDD VB3 1k
.ends opamp

.subckt dut VDD VSS vci phi1 phi2 vco
C1 vcx VSS 1p
C2 net0 vco 1p
M1 vci phi1 vcx VSS nch l=0.15 w=1 nf=1 m=1
M2 vcx phi2 net0 VSS nch l=0.15 w=1 nf=1 m=1
X1 VDD VSS net0 VSS vco opamp
.ends dut
