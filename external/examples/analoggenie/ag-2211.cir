* official Analog Canvas netlist; PDK X cards rewritten by convert.py
.model nch nmos
.model pch pmos

.subckt opamp VDD VSS INP INN OUT VB1 VB3 VB2
M1 net1 VB1 VDD VDD pch l=0.15 w=1 nf=1 m=1
M10 net7 net5 VSS VSS nch l=0.15 w=1 nf=1 m=1
M11 OUT VB2 VSS VSS nch l=0.15 w=1 nf=1 m=1
M12 net0 net0 net4 VDD pch l=0.15 w=1 nf=1 m=1
M13 VB4 net0 VDD VDD pch l=0.15 w=1 nf=1 m=1
M14 VB4 VB4 net2 VSS nch l=0.15 w=1 nf=1 m=1
M15 net2 VB4 VSS VSS nch l=0.15 w=1 nf=1 m=1
M2 net3 VB1 VDD VDD pch l=0.15 w=1 nf=1 m=1
M3 net1 INP OUT VSS nch l=0.15 w=1 nf=1 m=1
M4 net3 INN OUT VSS nch l=0.15 w=1 nf=1 m=1
M5 OUT VB3 net1 VDD pch l=0.15 w=1 nf=1 m=1
M6 net5 VB3 net3 VDD pch l=0.15 w=1 nf=1 m=1
M7 OUT VB4 net6 VSS nch l=0.15 w=1 nf=1 m=1
M8 net5 VB4 net7 VSS nch l=0.15 w=1 nf=1 m=1
M9 net6 net5 VSS VSS nch l=0.15 w=1 nf=1 m=1
R1 VDD net4 1k
R2 net0 VSS 1k
.ends opamp

.subckt dut VDD VSS VIN Vref VOUT VB1 VB2 VB3
CL VOUT net0 1p
MNP VIN net1 VOUT VSS nch l=0.15 w=1 nf=1 m=1
R1 VOUT FB 1k
R2 FB VSS 1k
R3 net0 VSS 1k
X1 VDD VSS Vref FB net1 VB1 VB3 VB2 opamp
.ends dut
