* official Analog Canvas netlist; PDK X cards rewritten by convert.py
.model nch nmos

.subckt dut VDD VSS VLO VLO_bar Vin Vout1 Vout2
M1 Vout1 net0 VSS VSS nch l=0.15 w=1 nf=1 m=1
M2 Vout2 net1 VSS VSS nch l=0.15 w=1 nf=1 m=1
M3 net0 VLO Vin VSS nch l=0.15 w=1 nf=1 m=1
M4 net1 VLO_bar Vin VSS nch l=0.15 w=1 nf=1 m=1
RD1 VDD Vout1 1k
RD2 VDD Vout2 1k
.ends dut
