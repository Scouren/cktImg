* official Analog Canvas netlist; PDK X cards rewritten by convert.py
.model nch nmos

.subckt dut VDD VSS Vb Vin
I1 net0 VSS DC 1m
Ib VDD Vin DC 1m
M1 VDD Vin net0 VSS nch l=0.15 w=1 nf=1 m=1
M2 Vin Vb net0 VSS nch l=0.15 w=1 nf=1 m=1
.ends dut
