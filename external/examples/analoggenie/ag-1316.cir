* official Analog Canvas netlist; PDK X cards rewritten by convert.py
.model nch nmos
.model pch pmos

.subckt EA1 VDD VSS VFP1 VREF VX2 VB1 VISR VX1
MN1 VX2 VX2 VSS VSS nch l=0.15 w=1 nf=1 m=1
MN10 net5 VB1 VSS VSS nch l=0.15 w=1 nf=1 m=1
MN2 VX VX VSS VSS nch l=0.15 w=1 nf=1 m=1
MN3 net4 VX2 VSS VSS nch l=0.15 w=1 nf=1 m=1
MN4 net3 VX VSS VSS nch l=0.15 w=1 nf=1 m=1
MN5 VB2 net0 VSS VSS nch l=0.15 w=1 nf=1 m=1
MN6 net0 net0 VSS VSS nch l=0.15 w=1 nf=1 m=1
MN7 VX net0 VSS VSS nch l=0.15 w=1 nf=1 m=1
MN8 net5 net5 VSS VSS nch l=0.15 w=1 nf=1 m=1
MN9 net1 net5 VSS VSS nch l=0.15 w=1 nf=1 m=1
MP1 VX2 VREF net2 VDD pch l=0.15 w=1 nf=1 m=1
MP10 net1 net1 VISR VDD pch l=0.15 w=1 nf=1 m=1
MP11 VX1 net1 VISR VDD pch l=0.15 w=1 nf=1 m=1
MP2 VX VFP1 net2 VDD pch l=0.15 w=1 nf=1 m=1
MP3 net2 VB2 VDD VDD pch l=0.15 w=1 nf=1 m=1
MP4 net4 net4 VDD VDD pch l=0.15 w=1 nf=1 m=1
MP5 net3 net4 VDD VDD pch l=0.15 w=1 nf=1 m=1
MP6 VB2 VB2 VDD VDD pch l=0.15 w=1 nf=1 m=1
MP7 VX VX VDD VDD pch l=0.15 w=1 nf=1 m=1
MP8 net0 VX VDD VDD pch l=0.15 w=1 nf=1 m=1
MP9 net5 net3 VISR VDD pch l=0.15 w=1 nf=1 m=1
RBIAS VDD net0 1k
.ends EA1

.subckt dut VDD VSS VIN VS5 VS1 VS2 VS4 VS3 VP VREF VB1
.model DIODE D(IS=1e-14 N=1)
CFLY VX1 VX2 1p
CO VP VN 1p
COP VP VSS 1p
D1 VN VX2 DIODE
L1 VX1 VX3 1n
M1 VX1 VS1 VIN VDD pch l=0.15 w=1 nf=1 m=1
M2 VX2 VS2 VIN VDD pch l=0.15 w=1 nf=1 m=1
M3 VP VS3 VX3 VDD pch l=0.15 w=1 nf=1 m=1
M4 VX3 VS4 VSS VSS nch l=0.15 w=1 nf=1 m=1
M5 net0 VS5 VIN VDD pch l=0.15 w=1 nf=1 m=1
R1 VP VFP1 1k
R2 VFP1 VSS 1k
X1 VDD VSS VFP1 VREF VX2 VB1 net0 VX1 EA1
.ends dut
