* official Analog Canvas netlist; PDK X cards rewritten by convert.py
.model nch nmos

.subckt dut VDD VSS VRF VIF1 VIF2 VLO2 VLO1
I1 net1 VSS DC 1m
L1 VDD A 1n
L2 VDD B 1n
M1 net0 VRF VSS VSS nch l=0.15 w=1 nf=1 m=1
M2 VIF1 B net0 VSS nch l=0.15 w=1 nf=1 m=1
M3 VIF2 A net0 VSS nch l=0.15 w=1 nf=1 m=1
M5 A VLO2 net1 VSS nch l=0.15 w=1 nf=1 m=1
M6 B VLO1 net1 VSS nch l=0.15 w=1 nf=1 m=1
R1 VDD VIF1 1k
R2 VDD VIF2 1k
.ends dut
