* official Analog Canvas netlist; PDK X cards rewritten by convert.py
.model nch nmos

.subckt dut VDD VSS A A_bar B B_bar Vout1 Vout2
I1 net0 VSS DC 1m
M1 net1 B net0 VSS nch l=0.15 w=1 nf=1 m=1
M2 Vout2 A net1 VSS nch l=0.15 w=1 nf=1 m=1
M3 Vout1 A_bar net1 VSS nch l=0.15 w=1 nf=1 m=1
M4 net2 B_bar net0 VSS nch l=0.15 w=1 nf=1 m=1
M5 Vout1 A net2 VSS nch l=0.15 w=1 nf=1 m=1
M6 Vout2 A_bar net2 VSS nch l=0.15 w=1 nf=1 m=1
RD1 VDD Vout1 1k
RD2 VDD Vout2 1k
.ends dut
