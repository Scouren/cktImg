* official Analog Canvas netlist; PDK X cards rewritten by convert.py
.model nch nmos
.model pch pmos

.subckt dut VDD VSS Vbp Vout Vg9 Vin
CC net0 Vout 1p
M6 Vout Vbp VDD VDD pch l=0.15 w=1 nf=1 m=1
M7 Vout Vin VSS VSS nch l=0.15 w=1 nf=1 m=1
M9 net0 Vg9 Vin VSS nch l=0.15 w=1 nf=1 m=1
.ends dut
