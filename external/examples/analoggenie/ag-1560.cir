* official Analog Canvas netlist; PDK X cards rewritten by convert.py
.model nch nmos
.model pch pmos
.model qpnp pnp

.subckt opamp VDD VSS INN INP VB2 VB1 OUT
M10 net8 net5 VDD VDD pch l=0.15 w=1 nf=1 m=1
M11 net1 net5 VDD VDD pch l=0.15 w=1 nf=1 m=1
M12 net5 VB1 net8 VDD pch l=0.15 w=1 nf=1 m=1
M13 OUT VB1 net1 VDD pch l=0.15 w=1 nf=1 m=1
M14 net5 VB4 net0 VSS nch l=0.15 w=1 nf=1 m=1
M15 OUT VB4 net3 VSS nch l=0.15 w=1 nf=1 m=1
M16 net0 net6 VSS VSS nch l=0.15 w=1 nf=1 m=1
M17 net3 VX VSS VSS nch l=0.15 w=1 nf=1 m=1
M18 VB4 net4 VDD VDD pch l=0.15 w=1 nf=1 m=1
M19 VB4 VB4 net2 VSS nch l=0.15 w=1 nf=1 m=1
M20 net2 VB4 VSS VSS nch l=0.15 w=1 nf=1 m=1
M21 net4 net4 VDD VDD pch l=0.15 w=1 nf=1 m=1
M22 net4 VB3 VSS VSS nch l=0.15 w=1 nf=1 m=1
M23 VB3 net4 VDD VDD pch l=0.15 w=1 nf=1 m=1
M24 VB3 VB3 VSS VSS nch l=0.15 w=1 nf=1 m=1
M3 VX INN net10 VDD pch l=0.15 w=1 nf=1 m=1
M4 net6 INP net10 VDD pch l=0.15 w=1 nf=1 m=1
M5 net10 VB2 VDD VDD pch l=0.15 w=1 nf=1 m=1
M6 VX VB4 net9 VSS nch l=0.15 w=1 nf=1 m=1
M7 net6 VB4 net7 VSS nch l=0.15 w=1 nf=1 m=1
M8 net9 VX VSS VSS nch l=0.15 w=1 nf=1 m=1
M9 net7 net6 VSS VSS nch l=0.15 w=1 nf=1 m=1
.ends opamp

.subckt dut VDD VSS Vout VB1 VB2
Q1 VSS VSS X qpnp m=1
Q2 VSS VSS net0 qpnp m=1
R1 Vout X 1k
R2 Vout Y 1k
R3 Y net0 1k
X1 VDD VSS Y X VB2 VB1 Vout opamp
.ends dut
