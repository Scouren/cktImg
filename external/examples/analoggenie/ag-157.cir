* official Analog Canvas netlist; PDK X cards rewritten by convert.py
.model nch nmos
.model pch pmos

.subckt dut VDD VSS Vin DELTAV Vb Vout
M1 N Vin P VSS nch l=0.15 w=1 nf=1 m=1
M2 Vout DELTAV P VSS nch l=0.15 w=1 nf=1 m=1
M3 N N VDD VDD pch l=0.15 w=1 nf=1 m=1
M4 Vout N VDD VDD pch l=0.15 w=1 nf=1 m=1
M5 P Vb VSS VSS nch l=0.15 w=1 nf=1 m=1
.ends dut
