* official Analog Canvas netlist; PDK X cards rewritten by convert.py
.model qnpn npn

.subckt ct_inductor n1 n2 n3 params: l1=1n l2=1n k=0
L1 n1 n3 {l1}
L2 n3 n2 {l2}
K12 L1 L2 {k}
.ends ct_inductor

.subckt dut Vcc VSS VB1 VTune VB2
C1 net6 net10 1p
C2 net8 net7 1p
C3 net0 net4 1p
C4 net11 net0 1p
C5 net1 net9 1p
C6 net2 net1 1p
C7 VTune net11 1p
C8 VTune net9 1p
LB1A VB1 net7 1n
LB1B net6 VB1 1n
LB2A net11 VB2 1n
LB2B net9 VB2 1n
LS1 net4 net5 1n
LS2 net3 net2 1n
LT1 net5 VSS 1n
LT2 net3 VSS 1n
Q1 net10 net7 net5 VSS qnpn m=1
Q2 net8 net6 net3 VSS qnpn m=1
Q3 net8 net8 net10 VSS qnpn m=1
Q4 net10 net10 net8 VSS qnpn m=1
XLp net10 net8 Vcc ct_inductor l1=1n l2=1n k=0
.ends dut
