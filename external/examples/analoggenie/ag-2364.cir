* official Analog Canvas netlist; PDK X cards rewritten by convert.py
.model nch nmos
.model pch pmos

.subckt dut VDD VSS VIN pb nb VOUT VERR VB1 VB2 VREF
M1 net1 VEAOUT VIN VDD pch l=0.15 w=1 nf=1 m=1
M10 VCTRL VEAOUT net3 VSS nch l=0.15 w=1 nf=1 m=1
M11 net11 net10 VDD VDD pch l=0.15 w=1 nf=1 m=1
M12 net10 VB1 net11 VDD pch l=0.15 w=1 nf=1 m=1
M13 net10 VREF net3 VSS nch l=0.15 w=1 nf=1 m=1
M14 net3 VB2 VSS VSS nch l=0.15 w=1 nf=1 m=1
M15 net9 net10 VDD VDD pch l=0.15 w=1 nf=1 m=1
M16 VEAOUT VB1 net9 VDD pch l=0.15 w=1 nf=1 m=1
M17 VEAOUT VB5 net7 VSS nch l=0.15 w=1 nf=1 m=1
M18 net7 VX VSS VSS nch l=0.15 w=1 nf=1 m=1
M19 VB5 net0 VDD VDD pch l=0.15 w=1 nf=1 m=1
M2 VCTRL VCTRL net1 VDD pch l=0.15 w=1 nf=1 m=1
M20 VB5 VB5 VEAOUT VSS nch l=0.15 w=1 nf=1 m=1
M21 VEAOUT VB5 VSS VSS nch l=0.15 w=1 nf=1 m=1
M22 net0 net0 net2 VDD pch l=0.15 w=1 nf=1 m=1
M3 VCTRL nb VSS VSS nch l=0.15 w=1 nf=1 m=1
M4 net8 VCTRL VDD VDD pch l=0.15 w=1 nf=1 m=1
M5 VX VB1 net8 VDD pch l=0.15 w=1 nf=1 m=1
M6 VX VB5 net4 VSS nch l=0.15 w=1 nf=1 m=1
M7 net4 VX VSS VSS nch l=0.15 w=1 nf=1 m=1
M8 net12 VCTRL VDD VDD pch l=0.15 w=1 nf=1 m=1
M9 VCTRL VB1 net12 VDD pch l=0.15 w=1 nf=1 m=1
MBIAS VERR nb VSS VSS nch l=0.15 w=1 nf=1 m=1
MCHG net5 pb VIN VDD pch l=0.15 w=1 nf=1 m=1
MCTRL VERR VCTRL VOUT VDD pch l=0.15 w=1 nf=1 m=1
MGEN net6 net6 VSS VSS nch l=0.15 w=1 nf=1 m=1
MINJ VERR net6 VSS VSS nch l=0.15 w=1 nf=1 m=1
MRES VOUT VERR VIN VDD pch l=0.15 w=1 nf=1 m=1
MSEN net6 VEAOUT net5 VDD pch l=0.15 w=1 nf=1 m=1
R1 VDD net2 1k
R2 net0 VSS 1k
.ends dut
