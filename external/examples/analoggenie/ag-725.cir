* official Analog Canvas netlist; PDK X cards rewritten by convert.py
.model nch nmos
.model pch pmos

.subckt dut VDD VSS VB2 VB3 Iin1 Iin2 Voutp Voutn
CL1 Voutp VSS 1p
CL2 Voutn VSS 1p
I1 VDD Iin2 DC 1m
I2 VDD Iin1 DC 1m
M10 Voutn VB3 net1 VSS nch l=0.15 w=1 nf=1 m=1
M5 Voutp VB2 Iin2 VDD pch l=0.15 w=1 nf=1 m=1
M6 Voutn VB2 Iin1 VDD pch l=0.15 w=1 nf=1 m=1
M7 net0 Vcntrl VSS VSS nch l=0.15 w=1 nf=1 m=1
M8 Voutp VB3 net0 VSS nch l=0.15 w=1 nf=1 m=1
M9 net1 Vcntrl VSS VSS nch l=0.15 w=1 nf=1 m=1
RL1 Voutp Vcntrl 1k
RL2 Vcntrl Voutn 1k
.ends dut
