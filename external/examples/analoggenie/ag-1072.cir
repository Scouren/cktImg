* official Analog Canvas netlist; PDK X cards rewritten by convert.py
.model nch nmos
.model pch pmos

.subckt dut VSS RF+ DCout RF- OUT_PM OUT_NM
CC1 net0 X 1p
CC2 X net0 1p
CC3 net1 OUT_PM 1p
CC4 OUT_PM net1 1p
MN1 net0 net0 VSS VSS nch l=0.15 w=1 nf=1 m=1
MN2 OUT_PM net0 RF- VSS nch l=0.15 w=1 nf=1 m=1
MN3 OUT_NM OUT_PM VSS VSS nch l=0.15 w=1 nf=1 m=1
MN4 X net1 VSS VSS nch l=0.15 w=1 nf=1 m=1
MN5 net1 net1 RF- VSS nch l=0.15 w=1 nf=1 m=1
MP1 net0 net0 RF+ DCout pch l=0.15 w=1 nf=1 m=1
MP2 OUT_PM net0 DCout DCout pch l=0.15 w=1 nf=1 m=1
MP3 OUT_PM net0 DCout DCout pch l=0.15 w=1 nf=1 m=1
MP4 OUT_NM OUT_PM DCout DCout pch l=0.15 w=1 nf=1 m=1
MP5 X net1 RF+ DCout pch l=0.15 w=1 nf=1 m=1
MP6 net1 net1 DCout DCout pch l=0.15 w=1 nf=1 m=1
MP7 X net1 RF+ DCout pch l=0.15 w=1 nf=1 m=1
.ends dut
