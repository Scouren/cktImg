* official Analog Canvas netlist; PDK X cards rewritten by convert.py
.model nch nmos
.model pch pmos

.subckt AMP1 VDD VSS INP INN OUT n3
M10 VX VB3 net3 VSS nch l=0.15 w=1 nf=1 m=1
M11 net3 VB4 VSS VSS nch l=0.15 w=1 nf=1 m=1
M12 net2 VX VDD VDD pch l=0.15 w=1 nf=1 m=1
M13 OUT VB2 net2 VDD pch l=0.15 w=1 nf=1 m=1
M14 OUT VB3 net5 VSS nch l=0.15 w=1 nf=1 m=1
M15 net5 VB4 VSS VSS nch l=0.15 w=1 nf=1 m=1
M16 n3 VB1 VDD VDD pch l=0.15 w=1 nf=1 m=1
M17 VB3 net1 VDD VDD pch l=0.15 w=1 nf=1 m=1
M18 VB3 VB3 VB4 VSS nch l=0.15 w=1 nf=1 m=1
M19 VB4 VB4 VSS VSS nch l=0.15 w=1 nf=1 m=1
M20 net1 net1 VDD VDD pch l=0.15 w=1 nf=1 m=1
M21 net1 n3 net0 VSS nch l=0.15 w=1 nf=1 m=1
M22 n3 net1 VDD VDD pch l=0.15 w=1 nf=1 m=1
M23 n3 net0 VSS VSS nch l=0.15 w=1 nf=1 m=1
M6 net3 INP n3 VDD pch l=0.15 w=1 nf=1 m=1
M7 net5 INN n3 VDD pch l=0.15 w=1 nf=1 m=1
M8 net4 VX VDD VDD pch l=0.15 w=1 nf=1 m=1
M9 VX VB2 net4 VDD pch l=0.15 w=1 nf=1 m=1
R3 net0 VSS 1k
.ends AMP1

.subckt dut VDD VSS biasp biascas biasn Vref Vout
C1 Vset VSS 1p
C2 n3 Vout 1p
M1 Vout n3 VDD VDD pch l=0.15 w=1 nf=1 m=1
M2 n1 Vset Vout VDD pch l=0.15 w=1 nf=1 m=1
M3 n1 biasn VSS VSS nch l=0.15 w=1 nf=1 m=1
M4 n3 biasp VDD VDD pch l=0.15 w=1 nf=1 m=1
M5 n3 biascas n1 VSS nch l=0.15 w=1 nf=1 m=1
R1 fb VSS 1k
R2 Vout fb 1k
X1 VDD VSS Vref fb Vset n3 AMP1
.ends dut
