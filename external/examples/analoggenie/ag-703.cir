* official Analog Canvas netlist; PDK X cards rewritten by convert.py
.model nch nmos

.subckt dut VDD VSS Vout
I1 VDD net1 DC 1m
Is VSS net0 DC 1m
M1 Vout net1 net0 VSS nch l=0.15 w=1 nf=1 m=1
M2 net1 net0 VSS VSS nch l=0.15 w=1 nf=1 m=1
RL VDD Vout 1k
Rs net0 VSS 1k
.ends dut
