* official Analog Canvas netlist; PDK X cards rewritten by convert.py
.model nch nmos
.model pch pmos
.model qpnp pnp

.subckt opamp VDD VSS INP INN VB1 VB2 OUT
M1 INP INP net3 VSS nch l=0.15 w=1 nf=1 m=1
M10 OUT VB4 net1 VSS nch l=0.15 w=1 nf=1 m=1
M11 net0 VX VSS VSS nch l=0.15 w=1 nf=1 m=1
M12 net1 VX VSS VSS nch l=0.15 w=1 nf=1 m=1
M13 VBP VBP VDD VDD pch l=0.15 w=1 nf=1 m=1
M14 VBP VY VSS VSS nch l=0.15 w=1 nf=1 m=1
M15 net6 VBP VDD VDD pch l=0.15 w=1 nf=1 m=1
M16 net6 net6 net4 VSS nch l=0.15 w=1 nf=1 m=1
M17 net4 net6 VB3 VSS nch l=0.15 w=1 nf=1 m=1
M18 net5 VBP VDD VDD pch l=0.15 w=1 nf=1 m=1
M19 net5 net5 VY VSS nch l=0.15 w=1 nf=1 m=1
M2 net2 INN net3 VSS nch l=0.15 w=1 nf=1 m=1
M20 VY net5 net4 VSS nch l=0.15 w=1 nf=1 m=1
M21 VB3 VBP VDD VDD pch l=0.15 w=1 nf=1 m=1
M22 VB3 VB3 VSS VSS nch l=0.15 w=1 nf=1 m=1
M23 VB4 VB4 VB5 VSS nch l=0.15 w=1 nf=1 m=1
M24 VB5 VB5 VSS VSS nch l=0.15 w=1 nf=1 m=1
M3 net3 VB5 VSS VSS nch l=0.15 w=1 nf=1 m=1
M4 VB4 VBP VDD VDD pch l=0.15 w=1 nf=1 m=1
M5 INP VB1 VDD VDD pch l=0.15 w=1 nf=1 m=1
M6 net2 VB1 VDD VDD pch l=0.15 w=1 nf=1 m=1
M7 VX VB2 INP VDD pch l=0.15 w=1 nf=1 m=1
M8 OUT VB2 net2 VDD pch l=0.15 w=1 nf=1 m=1
M9 VX VB4 net0 VSS nch l=0.15 w=1 nf=1 m=1
.ends opamp

.subckt dut VDD VSS Vout VB1 VB2
Q1 VSS VSS net2 qpnp m=1
Q2 net2 net2 net3 qpnp m=1
Q3 VSS VSS net0 qpnp m=1
Q4 net0 net0 net4 qpnp m=1
R1 Vout net1 1k
R2 Vout net4 1k
R3 net1 net3 1k
X1 VDD VSS net1 net4 VB1 VB2 Vout opamp
.ends dut
