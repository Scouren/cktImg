* official Analog Canvas netlist; PDK X cards rewritten by convert.py
.model nch nmos
.model pch pmos

.subckt EA1 VDD VSS VREF VN VFP1 VX1 VEA VX2
M10 net0 net3 VDD VDD pch l=0.15 w=1 nf=1 m=1
M11 VFP1 net3 VDD VDD pch l=0.15 w=1 nf=1 m=1
M12 net1 VA VDD VDD pch l=0.15 w=1 nf=1 m=1
M13 VA VB1 VN VDD pch l=0.15 w=1 nf=1 m=1
M14 net3 VB1 net0 VDD pch l=0.15 w=1 nf=1 m=1
M15 net6 VB1 VFP1 VDD pch l=0.15 w=1 nf=1 m=1
M16 VEA VB1 net1 VDD pch l=0.15 w=1 nf=1 m=1
M17 net6 VB5 VX1 VSS nch l=0.15 w=1 nf=1 m=1
M18 VEA VB5 net7 VSS nch l=0.15 w=1 nf=1 m=1
M19 VX1 net6 VSS VSS nch l=0.15 w=1 nf=1 m=1
M20 net7 net6 VSS VSS nch l=0.15 w=1 nf=1 m=1
M27 VB5 net2 VDD VDD pch l=0.15 w=1 nf=1 m=1
M28 net2 net2 VDD VDD pch l=0.15 w=1 nf=1 m=1
M29 net5 net2 VDD VDD pch l=0.15 w=1 nf=1 m=1
M30 VB5 VB5 net4 VSS nch l=0.15 w=1 nf=1 m=1
M31 net2 net5 VX2 VSS nch l=0.15 w=1 nf=1 m=1
M32 net5 net5 VSS VSS nch l=0.15 w=1 nf=1 m=1
M33 net4 VB5 VSS VSS nch l=0.15 w=1 nf=1 m=1
M6 VA VREF net8 VSS nch l=0.15 w=1 nf=1 m=1
M7 net3 VFP1 net8 VSS nch l=0.15 w=1 nf=1 m=1
M8 net8 VB2 VSS VSS nch l=0.15 w=1 nf=1 m=1
M9 VN VA VDD VDD pch l=0.15 w=1 nf=1 m=1
RBIAS VX2 VSS 1k
.ends EA1

.subckt ISR VDD VSS VS VEA VX1
M21 net0 VEA VS VDD pch l=0.15 w=1 nf=1 m=1
M22 net1 net1 VS VDD pch l=0.15 w=1 nf=1 m=1
M23 VX1 net1 VS VDD pch l=0.15 w=1 nf=1 m=1
M24 net0 VB4 VSS VSS nch l=0.15 w=1 nf=1 m=1
M25 net0 net0 VSS VSS nch l=0.15 w=1 nf=1 m=1
M26 net1 net0 VSS VSS nch l=0.15 w=1 nf=1 m=1
.ends ISR

.subckt dut VSS VIN VCONT1 VCONT2 VCONT3 VCONT4 VCONT5 VREF
.model DIODE D(IS=1e-14 N=1)
CFLY VX1 VX2 1p
CO VP VN 1p
COP VP VSS 1p
D1 VN VX2 DIODE
L1 VX1 VX3 1n
M1 VX1 VCONT2 VIN VDD pch l=0.15 w=1 nf=1 m=1
M2 VX2 VCONT3 VIN VDD pch l=0.15 w=1 nf=1 m=1
M3 VP VCONT5 VX3 VDD pch l=0.15 w=1 nf=1 m=1
M4 VX3 VCONT4 VSS VSS nch l=0.15 w=1 nf=1 m=1
M5 net0 VCONT1 VIN VDD pch l=0.15 w=1 nf=1 m=1
R1 VP VFP1 1k
R2 VFP1 VSS 1k
X1 VDD VSS VREF VN VFP1 VX1 net1 VX2 EA1
X2 VDD VSS net0 net1 VX1 ISR
.ends dut
