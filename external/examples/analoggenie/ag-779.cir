* official Analog Canvas netlist; PDK X cards rewritten by convert.py
.model qnpn npn

.subckt dut VCC VSS Vin Vout
I3 Vout VSS DC 1m
Q1 VCC Vin net0 VSS qnpn m=1
Q2 net0 net0 Vout VSS qnpn m=1
.ends dut
