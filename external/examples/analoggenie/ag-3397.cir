* official Analog Canvas netlist; PDK X cards rewritten by convert.py
.model nch nmos
.model pch pmos

.subckt opamp VDD VSS INN INP OUT
M10 net2 VB3 net1 VDD pch l=0.15 w=1 nf=1 m=1
M11 OUT VB3 net3 VDD pch l=0.15 w=1 nf=1 m=1
M12 net5 VX VDD VDD pch l=0.15 w=1 nf=1 m=1
M13 net5 net5 VSS VSS nch l=0.15 w=1 nf=1 m=1
M14 VX VX VDD VDD pch l=0.15 w=1 nf=1 m=1
M15 VX net5 VSS VSS nch l=0.15 w=1 nf=1 m=1
M16 net7 VX VDD VDD pch l=0.15 w=1 nf=1 m=1
M17 net7 net7 VSS VSS nch l=0.15 w=1 nf=1 m=1
M18 net4 net4 VDD VDD pch l=0.15 w=1 nf=1 m=1
M19 net4 net7 VSS VSS nch l=0.15 w=1 nf=1 m=1
M20 net0 net4 VDD VDD pch l=0.15 w=1 nf=1 m=1
M21 net0 net0 VSS VSS nch l=0.15 w=1 nf=1 m=1
M5 net2 INN net6 VSS nch l=0.15 w=1 nf=1 m=1
M6 OUT INP net6 VSS nch l=0.15 w=1 nf=1 m=1
M7 net6 net0 VSS VSS nch l=0.15 w=1 nf=1 m=1
M8 net1 net2 VDD VDD pch l=0.15 w=1 nf=1 m=1
M9 net3 net2 VDD VDD pch l=0.15 w=1 nf=1 m=1
.ends opamp

.subckt dut VDD VSS vci phi1 phi2 vco
C1 net2 net1 1p
C2 net0 vco 1p
M1 vci phi1 net1 VSS nch l=0.15 w=1 nf=1 m=1
M2 net1 phi2 VSS VSS nch l=0.15 w=1 nf=1 m=1
M3 net2 phi1 VSS VSS nch l=0.15 w=1 nf=1 m=1
M4 net2 phi2 net0 VSS nch l=0.15 w=1 nf=1 m=1
X1 VDD VSS net0 VSS vco opamp
.ends dut
