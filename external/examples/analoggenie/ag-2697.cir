* official Analog Canvas netlist; PDK X cards rewritten by convert.py
.model nch nmos
.model pch pmos

.subckt dut VDD VSS vci phi1 phi2 vco VB1 VB2
C1 vcx VSS 1p
C2 VX vco 1p
M1 vci phi1 vcx VSS nch l=0.15 w=1 nf=1 m=1
M10 vco VY VDD VDD pch l=0.15 w=1 nf=1 m=1
M11 vco net0 VSS VSS nch l=0.15 w=1 nf=1 m=1
M12 VB3 VB1 VDD VDD pch l=0.15 w=1 nf=1 m=1
M13 VB3 VB3 VSS VSS nch l=0.15 w=1 nf=1 m=1
M14 VB1 VB1 VDD VDD pch l=0.15 w=1 nf=1 m=1
M15 VB1 net2 VSS VSS nch l=0.15 w=1 nf=1 m=1
M16 VB2 VB2 VDD VDD pch l=0.15 w=1 nf=1 m=1
M17 VB2 VX net2 VSS nch l=0.15 w=1 nf=1 m=1
M18 VX VB2 VDD VDD pch l=0.15 w=1 nf=1 m=1
M19 VX net2 VSS VSS nch l=0.15 w=1 nf=1 m=1
M2 vcx phi2 VX VSS nch l=0.15 w=1 nf=1 m=1
M3 vcx VX net1 VSS nch l=0.15 w=1 nf=1 m=1
M4 VY VSS net1 VSS nch l=0.15 w=1 nf=1 m=1
M5 net1 VB3 VSS VSS nch l=0.15 w=1 nf=1 m=1
M6 vcx vcx VDD VDD pch l=0.15 w=1 nf=1 m=1
M7 VY VY VDD VDD pch l=0.15 w=1 nf=1 m=1
M8 net0 vcx VDD VDD pch l=0.15 w=1 nf=1 m=1
M9 net0 net0 VSS VSS nch l=0.15 w=1 nf=1 m=1
R1 net2 VSS 1k
.ends dut
