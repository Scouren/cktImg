* official Analog Canvas netlist; PDK X cards rewritten by convert.py
.model nch nmos
.model pch pmos

.subckt dut VDD VSS VIN VCONT1 VCONT2 VCONT3 VCONT4 VCONT5 VP VB3 VREF VB1 VB2
.model DIODE D(IS=1e-14 N=1)
CFLY VX1 VX2 1p
CO VP VN 1p
COP VP VSS 1p
D1 VN VX2 DIODE
L1 VX1 VX3 1n
M1 VS VCONT1 VIN VDD pch l=0.15 w=1 nf=1 m=1
M2 VX1 VCONT2 VIN VDD pch l=0.15 w=1 nf=1 m=1
M3 VX2 VCONT3 VIN VDD pch l=0.15 w=1 nf=1 m=1
M4 VX3 VCONT4 VSS VSS nch l=0.15 w=1 nf=1 m=1
M5 VP VCONT5 VX3 VDD pch l=0.15 w=1 nf=1 m=1
MN1 VX3 VREF net3 VSS nch l=0.15 w=1 nf=1 m=1
MN10 VBP VB2 VB1 VSS nch l=0.15 w=1 nf=1 m=1
MN11 VB2 VB1 VSS VSS nch l=0.15 w=1 nf=1 m=1
MN12 VB1 VX2 VSS VSS nch l=0.15 w=1 nf=1 m=1
MN13 VX2 VX2 VSS VSS nch l=0.15 w=1 nf=1 m=1
MN2 net2 VFP1 net3 VSS nch l=0.15 w=1 nf=1 m=1
MN3 net1 net1 VSS VSS nch l=0.15 w=1 nf=1 m=1
MN4 VCTRL net1 VSS VSS nch l=0.15 w=1 nf=1 m=1
MN5 net3 VB4 VSS VSS nch l=0.15 w=1 nf=1 m=1
MN6 net0 net4 VSS VSS nch l=0.15 w=1 nf=1 m=1
MN7 net4 net4 VSS VSS nch l=0.15 w=1 nf=1 m=1
MN8 net4 VB3 VSS VSS nch l=0.15 w=1 nf=1 m=1
MN9 VB4 VB4 VSS VSS nch l=0.15 w=1 nf=1 m=1
MP1 VX3 VX3 VDD VDD pch l=0.15 w=1 nf=1 m=1
MP10 VB2 VBP VDD VDD pch l=0.15 w=1 nf=1 m=1
MP11 VX2 VBP VDD VDD pch l=0.15 w=1 nf=1 m=1
MP2 net2 net2 VDD VDD pch l=0.15 w=1 nf=1 m=1
MP3 VCTRL VX3 VDD VDD pch l=0.15 w=1 nf=1 m=1
MP4 net0 net0 VS VDD pch l=0.15 w=1 nf=1 m=1
MP5 VX1 net0 VS VDD pch l=0.15 w=1 nf=1 m=1
MP6 net4 VCTRL VS VDD pch l=0.15 w=1 nf=1 m=1
MP7 net1 net2 VDD VDD pch l=0.15 w=1 nf=1 m=1
MP8 VB4 VBP VDD VDD pch l=0.15 w=1 nf=1 m=1
MP9 VBP VBP VDD VDD pch l=0.15 w=1 nf=1 m=1
R1 VP VFP1 1k
R2 VFP1 VSS 1k
.ends dut
