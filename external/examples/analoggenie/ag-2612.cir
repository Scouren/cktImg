* official Analog Canvas netlist; PDK X cards rewritten by convert.py
.model nch nmos
.model pch pmos

.subckt dut VDD VSS biasp biascas biasn Vout
C1 Vset VSS 1p
C2 n3 Vout 1p
M1 Vout n3 VDD VDD pch l=0.15 w=1 nf=1 m=1
M10 net2 fb net7 VSS nch l=0.15 w=1 nf=1 m=1
M11 fb Vref net7 VSS nch l=0.15 w=1 nf=1 m=1
M12 net7 VX VSS VSS nch l=0.15 w=1 nf=1 m=1
M13 net1 net1 VSS VSS nch l=0.15 w=1 nf=1 m=1
M14 Vset net1 VSS VSS nch l=0.15 w=1 nf=1 m=1
M15 VX net0 VDD VDD pch l=0.15 w=1 nf=1 m=1
M16 VX VX VSS VSS nch l=0.15 w=1 nf=1 m=1
M17 net0 net0 VDD VDD pch l=0.15 w=1 nf=1 m=1
M18 net0 net3 VSS VSS nch l=0.15 w=1 nf=1 m=1
M19 net3 net4 VDD VDD pch l=0.15 w=1 nf=1 m=1
M2 n1 Vset Vout VDD pch l=0.15 w=1 nf=1 m=1
M20 net3 net3 VSS VSS nch l=0.15 w=1 nf=1 m=1
M21 net4 net4 VDD VDD pch l=0.15 w=1 nf=1 m=1
M22 net4 net3 net6 VSS nch l=0.15 w=1 nf=1 m=1
M23 net6 net5 VSS VSS nch l=0.15 w=1 nf=1 m=1
M24 net5 net4 VDD VDD pch l=0.15 w=1 nf=1 m=1
M25 net5 net5 VSS VSS nch l=0.15 w=1 nf=1 m=1
M3 n1 biasn VSS VSS nch l=0.15 w=1 nf=1 m=1
M4 n3 biasp VDD VDD pch l=0.15 w=1 nf=1 m=1
M5 n3 biascas n1 VSS nch l=0.15 w=1 nf=1 m=1
M6 net1 net2 VDD VDD pch l=0.15 w=1 nf=1 m=1
M7 net2 net2 VDD VDD pch l=0.15 w=1 nf=1 m=1
M8 fb fb VDD VDD pch l=0.15 w=1 nf=1 m=1
M9 Vset fb VDD VDD pch l=0.15 w=1 nf=1 m=1
R1 fb VSS 1k
R2 Vout fb 1k
.ends dut
