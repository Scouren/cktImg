* official Analog Canvas netlist; PDK X cards rewritten by convert.py
.model nch nmos

.subckt dut VDD VSS Vin Vout
C1 Vin X 1p
C2 X Vout 1p
I1 VDD Vout DC 1m
M1 Vout X VSS VSS nch l=0.15 w=1 nf=1 m=1
.ends dut
