* official Analog Canvas netlist; PDK X cards rewritten by convert.py
.model nch nmos
.model pch pmos

.subckt AEA VDD VSS VREF VBN OUT
M10 net0 OUT net1 VSS nch l=0.15 w=1 nf=1 m=1
M11 OUT OUT VSS VSS nch l=0.15 w=1 nf=1 m=1
M12 net1 VBN VSS VSS nch l=0.15 w=1 nf=1 m=1
M4 OUT net2 VDD VDD pch l=0.15 w=1 nf=1 m=1
M5 net2 net2 VDD VDD pch l=0.15 w=1 nf=1 m=1
M6 net0 net0 VDD VDD pch l=0.15 w=1 nf=1 m=1
M7 OUT net0 VDD VDD pch l=0.15 w=1 nf=1 m=1
M8 OUT OUT VSS VSS nch l=0.15 w=1 nf=1 m=1
M9 net2 VREF net1 VSS nch l=0.15 w=1 nf=1 m=1
.ends AEA

.subckt Bias VDD VSS VB1 VBN VB2
M13 VB1 VB1 VDD VDD pch l=0.15 w=1 nf=1 m=1
M14 VB1 VBN VSS VSS nch l=0.15 w=1 nf=1 m=1
M15 VBN net1 VDD VDD pch l=0.15 w=1 nf=1 m=1
M16 VBN VBN VSS VSS nch l=0.15 w=1 nf=1 m=1
M17 net1 net1 VDD VDD pch l=0.15 w=1 nf=1 m=1
M18 net1 VB2 VSS VSS nch l=0.15 w=1 nf=1 m=1
M19 VB2 net1 VDD VDD pch l=0.15 w=1 nf=1 m=1
M20 net0 VB2 VSS VSS nch l=0.15 w=1 nf=1 m=1
R1 VB2 net0 1k
.ends Bias

.subckt dut VDD VSS VIN VOUT VERR VREF VB1 VB2 pb nb
M1 net2 net5 VIN VDD pch l=0.15 w=1 nf=1 m=1
M2 net0 net0 net2 VDD pch l=0.15 w=1 nf=1 m=1
M3 net0 nb VSS VSS nch l=0.15 w=1 nf=1 m=1
MBIAS VERR nb VSS VSS nch l=0.15 w=1 nf=1 m=1
MCHG net4 pb VIN VDD pch l=0.15 w=1 nf=1 m=1
MCTRL VERR net0 VOUT VDD pch l=0.15 w=1 nf=1 m=1
MGEN net1 net1 VSS VSS nch l=0.15 w=1 nf=1 m=1
MINJ VERR net1 VSS VSS nch l=0.15 w=1 nf=1 m=1
MRES VOUT VERR VIN VDD pch l=0.15 w=1 nf=1 m=1
MSEN net1 net5 net4 VDD pch l=0.15 w=1 nf=1 m=1
X1 VDD VSS VREF net3 net5 AEA
X2 VDD VSS VB1 net3 VB2 Bias
.ends dut
