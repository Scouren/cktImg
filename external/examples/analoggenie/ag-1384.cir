* official Analog Canvas netlist; PDK X cards rewritten by convert.py
.model nch nmos
.model pch pmos

.subckt comparator VDD VSS VB1 VB3 VB2 TAIL IN OUT
M1 net0 VB1 VDD VDD pch l=0.15 w=1 nf=1 m=1
M10 net3 VY VSS VSS nch l=0.15 w=1 nf=1 m=1
M11 net6 VY VSS VSS nch l=0.15 w=1 nf=1 m=1
M12 net1 net1 net5 VDD pch l=0.15 w=1 nf=1 m=1
M13 VB4 net1 VDD VDD pch l=0.15 w=1 nf=1 m=1
M14 VB4 VB4 net4 VSS nch l=0.15 w=1 nf=1 m=1
M15 net4 VB4 VSS VSS nch l=0.15 w=1 nf=1 m=1
M2 net2 VB1 VDD VDD pch l=0.15 w=1 nf=1 m=1
M3 net0 IN TAIL VSS nch l=0.15 w=1 nf=1 m=1
M4 net2 OUT TAIL VSS nch l=0.15 w=1 nf=1 m=1
M5 VY VB3 net0 VDD pch l=0.15 w=1 nf=1 m=1
M6 OUT VB3 net2 VDD pch l=0.15 w=1 nf=1 m=1
M7 TAIL VB2 VSS VSS nch l=0.15 w=1 nf=1 m=1
M8 VY VB4 net3 VSS nch l=0.15 w=1 nf=1 m=1
M9 OUT VB4 net6 VSS nch l=0.15 w=1 nf=1 m=1
R1 VDD net5 1k
R2 net1 VSS 1k
.ends comparator

.subckt dut VDD VSS VSTO VCONT1 VCONT2 VCONT3 VOUT VB1 VB2 VB3
CL VOUT VSS 1p
CSTO VSTO VSS 1p
LRX VX net0 1n
MN1 VX VCONT2 VSS VSS nch l=0.15 w=1 nf=1 m=1
MN2 net0 VCONT3 VSS VSS nch l=0.15 w=1 nf=1 m=1
MP2 net0 net1 VOUT VOUT pch l=0.15 w=1 nf=1 m=1
MP3 VX VCONT1 VSTO VSTO pch l=0.15 w=1 nf=1 m=1
X1 VDD VSS VB1 VB3 VB2 VX net0 net1 comparator
.ends dut
