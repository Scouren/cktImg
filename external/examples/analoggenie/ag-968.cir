* official Analog Canvas netlist; PDK X cards rewritten by convert.py
.model nch nmos
.model pch pmos

.subckt dut VDD VSS vout vin
I1 VDD net1 DC 100uA
I2 net3 VSS DC 100uA
M1 net4 vin VSS VSS nch l=0.15 w=1 nf=1 m=1
M2 vout net1 net4 VSS nch l=0.15 w=1 nf=1 m=1
M3 vout net3 net5 VDD pch l=0.15 w=1 nf=1 m=1
M4 net5 net0 VDD VDD pch l=0.15 w=1 nf=1 m=1
M5 net2 net2 VSS VSS nch l=0.15 w=1 nf=1 m=1
M6 net1 net1 net2 VSS nch l=0.15 w=1 nf=1 m=1
M7 net3 net3 net0 VDD pch l=0.15 w=1 nf=1 m=1
M8 net0 net0 VDD VDD pch l=0.15 w=1 nf=1 m=1
.ends dut
