* official Analog Canvas netlist; PDK X cards rewritten by convert.py
.model nch nmos
.model pch pmos

.subckt dut VDD VSS ViP ViN Io
I1 net1 VSS DC 50uA
I2 net6 VSS DC 50uA
M1 Io ViP net3 VSS nch l=0.15 w=1 nf=1 m=1
M10 Io net2 VDD VDD pch l=0.15 w=1 nf=1 m=1
M2 net2 ViP net4 VSS nch l=0.15 w=1 nf=1 m=1
M3 net2 ViN net0 VSS nch l=0.15 w=1 nf=1 m=1
M4 Io ViN net5 VSS nch l=0.15 w=1 nf=1 m=1
M5 net1 net1 net3 VDD pch l=0.15 w=1 nf=1 m=1
M6 VSS net1 net0 VDD pch l=0.15 w=1 nf=1 m=1
M7 VSS net6 net4 VDD pch l=0.15 w=1 nf=1 m=1
M8 net6 net6 net5 VDD pch l=0.15 w=1 nf=1 m=1
M9 net2 net2 VDD VDD pch l=0.15 w=1 nf=1 m=1
.ends dut
