* official Analog Canvas netlist; PDK X cards rewritten by convert.py
.model nch nmos
.model pch pmos
.model qpnp pnp

.subckt A1 VDD VSS INN INP OUT VB2 VB1
M1 net3 INN net4 VSS nch l=0.15 w=1 nf=1 m=1
M10 VB2 VB2 VDD VDD pch l=0.15 w=1 nf=1 m=1
M11 VB2 net8 VSS VSS nch l=0.15 w=1 nf=1 m=1
M12 net2 VB2 VDD VDD pch l=0.15 w=1 nf=1 m=1
M13 net2 net2 net8 VSS nch l=0.15 w=1 nf=1 m=1
M14 net8 net2 net1 VSS nch l=0.15 w=1 nf=1 m=1
M15 net7 VB2 VDD VDD pch l=0.15 w=1 nf=1 m=1
M16 net7 net7 net1 VSS nch l=0.15 w=1 nf=1 m=1
M17 net1 net7 net5 VSS nch l=0.15 w=1 nf=1 m=1
M18 net5 net5 VSS VSS nch l=0.15 w=1 nf=1 m=1
M19 VB1 VB1 VDD VDD pch l=0.15 w=1 nf=1 m=1
M2 net0 INP net4 VSS nch l=0.15 w=1 nf=1 m=1
M20 VB1 VB3 VSS VSS nch l=0.15 w=1 nf=1 m=1
M21 VB3 net9 VDD VDD pch l=0.15 w=1 nf=1 m=1
M22 VB3 VB3 VSS VSS nch l=0.15 w=1 nf=1 m=1
M23 net9 net9 VDD VDD pch l=0.15 w=1 nf=1 m=1
M24 net9 net5 VSS VSS nch l=0.15 w=1 nf=1 m=1
M25 net5 VB2 VDD VDD pch l=0.15 w=1 nf=1 m=1
M3 net3 net3 VDD VDD pch l=0.15 w=1 nf=1 m=1
M4 net0 net0 VDD VDD pch l=0.15 w=1 nf=1 m=1
M5 net6 net3 VDD VDD pch l=0.15 w=1 nf=1 m=1
M6 OUT net0 VDD VDD pch l=0.15 w=1 nf=1 m=1
M7 net6 net6 VSS VSS nch l=0.15 w=1 nf=1 m=1
M8 OUT net6 VSS VSS nch l=0.15 w=1 nf=1 m=1
M9 net4 VB3 VSS VSS nch l=0.15 w=1 nf=1 m=1
.ends A1

.subckt dut VDD VSS Vout VB1 VB2
Q1 VSS VSS net0 qpnp m=1
Q2 net0 net0 X qpnp m=1
Q3 VSS VSS net2 qpnp m=1
Q4 net2 net2 net1 qpnp m=1
R1 Vout X 1k
R2 Vout Y 1k
R3 Y net1 1k
X1 VDD VSS Y X Vout VB2 VB1 A1
.ends dut
