* official Analog Canvas netlist; PDK X cards rewritten by convert.py
.model nch nmos
.model pch pmos

.subckt dut VDD VSS VIN VOUT pb VREF
M1 net3 VEA VIN VDD pch l=0.15 w=1 nf=1 m=1
M10 VEA VEA VSS VSS nch l=0.15 w=1 nf=1 m=1
M11 VEA VEA VSS VSS nch l=0.15 w=1 nf=1 m=1
M12 net1 VBN VSS VSS nch l=0.15 w=1 nf=1 m=1
M13 VC net4 VDD VDD pch l=0.15 w=1 nf=1 m=1
M14 net4 net4 VDD VDD pch l=0.15 w=1 nf=1 m=1
M15 VBN net4 VDD VDD pch l=0.15 w=1 nf=1 m=1
M16 net4 VC VB1 VSS nch l=0.15 w=1 nf=1 m=1
M17 VC VB1 VSS VSS nch l=0.15 w=1 nf=1 m=1
M18 VBN VBN VSS VSS nch l=0.15 w=1 nf=1 m=1
M2 VC VC net3 VDD pch l=0.15 w=1 nf=1 m=1
M3 VC nb VSS VSS nch l=0.15 w=1 nf=1 m=1
M4 net5 net5 VDD VDD pch l=0.15 w=1 nf=1 m=1
M5 VEA net5 VDD VDD pch l=0.15 w=1 nf=1 m=1
M6 VEA net0 VDD VDD pch l=0.15 w=1 nf=1 m=1
M7 net0 net0 VDD VDD pch l=0.15 w=1 nf=1 m=1
M8 net5 VREF net1 VSS nch l=0.15 w=1 nf=1 m=1
M9 net0 VEA net1 VSS nch l=0.15 w=1 nf=1 m=1
MBIAS VERR nb VSS VSS nch l=0.15 w=1 nf=1 m=1
MCHG net2 pb VIN VDD pch l=0.15 w=1 nf=1 m=1
MCTRL VERR VC VOUT VDD pch l=0.15 w=1 nf=1 m=1
MGEN net6 net6 VSS VSS nch l=0.15 w=1 nf=1 m=1
MINJ VERR net6 VSS VSS nch l=0.15 w=1 nf=1 m=1
MRES VOUT VERR VIN VDD pch l=0.15 w=1 nf=1 m=1
MSEN net6 VEA net2 VDD pch l=0.15 w=1 nf=1 m=1
R1 VB1 VSS 1k
.ends dut
