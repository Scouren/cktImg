* official Analog Canvas netlist; PDK X cards rewritten by convert.py
.model nch nmos
.model pch pmos
.model qpnp pnp

.global VDD

.subckt opamp VSS INN INP OUT
M1 net0 INN net5 VSS nch l=0.15 w=1 nf=1 m=1
M10 VB2 VB3 VDD VDD pch l=0.15 w=1 nf=1 m=1
M11 VB1 VB3 VDD VDD pch l=0.15 w=1 nf=1 m=1
M12 VB3 VB3 VDD VDD pch l=0.15 w=1 nf=1 m=1
M13 net2 VB3 VDD VDD pch l=0.15 w=1 nf=1 m=1
M14 VB2 VB2 VSS VSS nch l=0.15 w=1 nf=1 m=1
M15 VB1 VB1 VSS VSS nch l=0.15 w=1 nf=1 m=1
M16 VB3 VB1 net3 VSS nch l=0.15 w=1 nf=1 m=1
M17 net3 net2 VSS VSS nch l=0.15 w=1 nf=1 m=1
M18 net2 net2 VSS VSS nch l=0.15 w=1 nf=1 m=1
M2 net1 INP net5 VSS nch l=0.15 w=1 nf=1 m=1
M3 net0 net0 VDD VDD pch l=0.15 w=1 nf=1 m=1
M4 net1 net1 VDD VDD pch l=0.15 w=1 nf=1 m=1
M5 net5 VB2 VSS VSS nch l=0.15 w=1 nf=1 m=1
M6 net4 net0 VDD VDD pch l=0.15 w=1 nf=1 m=1
M7 OUT net1 VDD VDD pch l=0.15 w=1 nf=1 m=1
M8 net4 net4 VSS VSS nch l=0.15 w=1 nf=1 m=1
M9 OUT net4 VSS VSS nch l=0.15 w=1 nf=1 m=1
.ends opamp

.subckt dut VSS Vout
Q1 VSS VSS X qpnp m=1
Q2 VSS VSS net0 qpnp m=1
R1 Vout X 1k
R2 Vout Y 1k
R3 Y net0 1k
X1 VSS Y X Vout opamp
.ends dut
