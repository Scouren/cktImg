* official Analog Canvas netlist; PDK X cards rewritten by convert.py
.model nch nmos
.model pch pmos

.subckt dut VDD VSS vci phi1 phi2 vco
C1 net2 net0 1p
C2 net5 vco 1p
M1 vci phi1 net2 VSS nch l=0.15 w=1 nf=1 m=1
M10 net6 net5 net7 VSS nch l=0.15 w=1 nf=1 m=1
M11 net4 VSS net7 VSS nch l=0.15 w=1 nf=1 m=1
M12 net7 VBN VSS VSS nch l=0.15 w=1 nf=1 m=1
M13 vco VX VSS VSS nch l=0.15 w=1 nf=1 m=1
M14 VB1 VB1 VDD VDD pch l=0.15 w=1 nf=1 m=1
M15 VBN VP VDD VDD pch l=0.15 w=1 nf=1 m=1
M16 VP VP VDD VDD pch l=0.15 w=1 nf=1 m=1
M17 VB2 VP VDD VDD pch l=0.15 w=1 nf=1 m=1
M18 net1 VP VDD VDD pch l=0.15 w=1 nf=1 m=1
M19 VB1 VBN VSS VSS nch l=0.15 w=1 nf=1 m=1
M2 net2 phi2 VSS VSS nch l=0.15 w=1 nf=1 m=1
M20 VBN VBN VSS VSS nch l=0.15 w=1 nf=1 m=1
M21 VP VB2 net3 VSS nch l=0.15 w=1 nf=1 m=1
M22 net3 net1 VSS VSS nch l=0.15 w=1 nf=1 m=1
M23 VB2 VB2 VSS VSS nch l=0.15 w=1 nf=1 m=1
M24 net1 net1 VSS VSS nch l=0.15 w=1 nf=1 m=1
M3 net0 phi1 VSS VSS nch l=0.15 w=1 nf=1 m=1
M4 net0 phi2 net5 VSS nch l=0.15 w=1 nf=1 m=1
M5 VX net6 VDD VDD pch l=0.15 w=1 nf=1 m=1
M6 net6 net6 VDD VDD pch l=0.15 w=1 nf=1 m=1
M7 net4 net4 VDD VDD pch l=0.15 w=1 nf=1 m=1
M8 vco net4 VDD VDD pch l=0.15 w=1 nf=1 m=1
M9 VX VX VSS VSS nch l=0.15 w=1 nf=1 m=1
.ends dut
