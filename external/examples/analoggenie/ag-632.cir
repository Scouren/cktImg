* official Analog Canvas netlist; PDK X cards rewritten by convert.py
.model nch nmos
.model pch pmos

.subckt dut Vcc VSS In Ref Out
Ibias Vcc net2 DC 20uA
M1 net1 In net4 VSS nch l=0.15 w=1 nf=1 m=1
M10 Out net3 VSS VSS nch l=0.15 w=1 nf=1 m=1
M2 net0 Ref net4 VSS nch l=0.15 w=1 nf=1 m=1
M3 net1 net1 Vcc Vcc pch l=0.15 w=1 nf=1 m=1
M4 net0 net1 Vcc Vcc pch l=0.15 w=1 nf=1 m=1
M5 net3 net0 Vcc Vcc pch l=0.15 w=1 nf=1 m=1
M6 net2 net2 VSS VSS nch l=0.15 w=1 nf=1 m=1
M7 net4 net2 VSS VSS nch l=0.15 w=1 nf=1 m=1
M8 net3 net2 VSS VSS nch l=0.15 w=1 nf=1 m=1
M9 Out net3 Vcc Vcc pch l=0.15 w=1 nf=1 m=1
.ends dut
