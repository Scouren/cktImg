* official Analog Canvas netlist; PDK X cards rewritten by convert.py
.model nch nmos
.model pch pmos

.subckt dut VDD VSS Vin1 Vin2 Iout1 Iout2
ISS VDD net2 DC 1m
M1 net0 Vin1 net2 VDD pch l=0.15 w=1 nf=1 m=1
M2 net1 Vin2 net2 VDD pch l=0.15 w=1 nf=1 m=1
M3 net0 net0 VSS VSS nch l=0.15 w=1 nf=1 m=1
M4 net1 net1 VSS VSS nch l=0.15 w=1 nf=1 m=1
M5 Iout1 net0 VSS VSS nch l=0.15 w=1 nf=1 m=1
M6 Iout2 net1 VSS VSS nch l=0.15 w=1 nf=1 m=1
.ends dut
