* official Analog Canvas netlist; PDK X cards rewritten by convert.py
.model nch nmos

.subckt dut VDD VSS IN OUT
M1 net0 IN VSS VSS nch l=0.15 w=1 nf=1 m=1
M2 OUT IN VSS VSS nch l=0.15 w=1 nf=1 m=1
M3 VDD net0 OUT VSS nch l=0.15 w=1 nf=1 m=1
RF IN net0 1k
.ends dut
