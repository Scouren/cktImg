* official Analog Canvas netlist; PDK X cards rewritten by convert.py
.model qnpn npn
.model qpnp pnp

.subckt dut VCC VEE VSS BIAS V1 Vo
Q13A net1 BIAS VCC qpnp m=1
Q14 VCC net1 Vo VSS qnpn m=1
Q18 net1 net2 net0 VSS qnpn m=1
Q19 net1 net1 net2 VSS qnpn m=1
Q20 VEE net0 Vo qpnp m=1
Q23 VEE V1 net0 qpnp m=1
R10 net2 net0 40kΩ
RL Vo VSS 1k
.ends dut
