* official Analog Canvas netlist; PDK X cards rewritten by convert.py
.model nch nmos

.subckt dut VDD VSS Vin Vout Vb
I1 VDD net1 DC 1m
I2 VDD Vout DC 1m
M1 net1 Vb net0 VSS nch l=0.15 w=1 nf=1 m=1
M2 Vout net1 VSS VSS nch l=0.15 w=1 nf=1 m=1
RS Vin net0 1k
.ends dut
