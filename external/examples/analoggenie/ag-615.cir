* official Analog Canvas netlist; PDK X cards rewritten by convert.py
.model nch nmos

.subckt dut VSS
I1 net2 VSS DC 20uA
M1 net0 net3 net2 VSS nch l=0.35 w=50 nf=1 m=1
M2 net0 net1 net2 VSS nch l=0.35 w=50 nf=1 m=1
V1 net3 VSS DC 1
V2 net1 VSS DC 2V
Vdd net0 VSS DC 1
.ends dut
