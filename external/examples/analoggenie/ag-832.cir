* official Analog Canvas netlist; PDK X cards rewritten by convert.py
.model nch nmos
.model qnpn npn

.subckt dut VDD VSS vi vo
M1 net0 vi VSS VSS nch l=0.15 w=1 nf=1 m=1
M2 net1 net1 VSS VSS nch l=0.15 w=1 nf=1 m=1
Q1 net2 net3 net0 VSS qnpn m=1
Q2 net3 net3 net1 VSS qnpn m=1
Q3 VDD net2 vo VSS qnpn m=1
R1 VDD net3 10kΩ
R2 vi vo 30kΩ
RL1 VDD net0 1kΩ
RL2 VDD net2 10kΩ
RL3 vo VSS 1kΩ
.ends dut
