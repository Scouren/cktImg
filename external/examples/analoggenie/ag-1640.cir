* official Analog Canvas netlist; PDK X cards rewritten by convert.py
.model nch nmos
.model pch pmos
.model qpnp pnp

.subckt opamp VDD VSS INN INP OUT
M1 net3 INN net5 VSS nch l=0.15 w=1 nf=1 m=1
M10 VB1 VB1 VDD VDD pch l=0.15 w=1 nf=1 m=1
M11 VB1 VB3 VSS VSS nch l=0.15 w=1 nf=1 m=1
M12 VB3 net0 VDD VDD pch l=0.15 w=1 nf=1 m=1
M13 VB3 VB3 VSS VSS nch l=0.15 w=1 nf=1 m=1
M14 net0 net0 VDD VDD pch l=0.15 w=1 nf=1 m=1
M15 net0 net4 VB2 VSS nch l=0.15 w=1 nf=1 m=1
M16 net4 net0 VDD VDD pch l=0.15 w=1 nf=1 m=1
M17 net4 VB2 VSS VSS nch l=0.15 w=1 nf=1 m=1
M2 net1 INP net5 VSS nch l=0.15 w=1 nf=1 m=1
M3 net3 net3 VDD VDD pch l=0.15 w=1 nf=1 m=1
M4 net1 net1 VDD VDD pch l=0.15 w=1 nf=1 m=1
M5 net2 net3 VDD VDD pch l=0.15 w=1 nf=1 m=1
M6 OUT net1 VDD VDD pch l=0.15 w=1 nf=1 m=1
M7 net5 VB3 VSS VSS nch l=0.15 w=1 nf=1 m=1
M8 net2 net2 VSS VSS nch l=0.15 w=1 nf=1 m=1
M9 OUT net2 VSS VSS nch l=0.15 w=1 nf=1 m=1
R1 VB2 VSS 1k
.ends opamp

.subckt dut VDD VSS Vout
Q1 VSS VSS X qpnp m=1
Q2 VSS VSS net0 qpnp m=1
R1 Vout X 1k
R2 Vout Y 1k
R3 Y net0 1k
X1 VDD VSS Y X Vout opamp
.ends dut
