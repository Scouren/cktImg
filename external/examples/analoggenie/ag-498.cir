* official Analog Canvas netlist; PDK X cards rewritten by convert.py
.model nch nmos

.subckt dut VDD VSS LO LO_bar VRF X Y
M1 net0 VRF VSS VSS nch l=0.15 w=1 nf=1 m=1
M2 X LO net0 VSS nch l=0.15 w=1 nf=1 m=1
M3 Y LO_bar net0 VSS nch l=0.15 w=1 nf=1 m=1
R1 VDD X 1k
R2 VDD Y 1k
.ends dut
