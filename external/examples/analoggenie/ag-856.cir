* official Analog Canvas netlist; PDK X cards rewritten by convert.py
.model nch nmos
.model pch pmos

.subckt dut VDD VSS IBIAS2 IBIAS1
M1 net2 net0 VSS VSS nch l=0.15 w=1 nf=1 m=1
M2 net1 net2 net0 VSS nch l=0.15 w=1 nf=1 m=1
M3 IBIAS1 net0 VSS VSS nch l=0.15 w=1 nf=1 m=1
M4 net2 net1 VDD VDD pch l=0.15 w=1 nf=1 m=1
M5 net1 net1 VDD VDD pch l=0.15 w=1 nf=1 m=1
M6 IBIAS2 net1 VDD VDD pch l=0.15 w=1 nf=1 m=1
M7 net3 net0 VSS VSS nch l=0.15 w=1 nf=1 m=1
M8 net3 net0 VDD VDD pch l=0.15 w=1 nf=1 m=1
M9 net1 net3 VSS VSS nch l=0.15 w=1 nf=1 m=1
R net0 VSS 1k
.ends dut
