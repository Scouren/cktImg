* official Analog Canvas netlist; PDK X cards rewritten by convert.py
.model nch nmos
.model pch pmos

.subckt dut VDD VSS GND vIN vOUT
CL vOUT GND 1p
M1 vOUT net0 VSS GND nch l=0.15 w=1 nf=1 m=1
M2 vOUT net0 VDD VDD pch l=0.15 w=1 nf=1 m=1
R1 vIN net0 1k
R2 net0 vOUT 1k
RL vOUT GND 1k
.ends dut
