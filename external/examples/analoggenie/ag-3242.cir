* official Analog Canvas netlist; PDK X cards rewritten by convert.py
.model nch nmos
.model pch pmos

.subckt dut VDD VSS vci phi1 phi2 vco VB1 VB2
C1 net1 net4 1p
C2 net2 vco 1p
M1 vci phi1 net1 VSS nch l=0.15 w=1 nf=1 m=1
M10 VX net3 VDD VDD pch l=0.15 w=1 nf=1 m=1
M11 vco net6 VDD VDD pch l=0.15 w=1 nf=1 m=1
M12 VX VX VSS VSS nch l=0.15 w=1 nf=1 m=1
M13 vco VX VSS VSS nch l=0.15 w=1 nf=1 m=1
M14 VB1 VB1 VDD VDD pch l=0.15 w=1 nf=1 m=1
M15 VB1 VB3 VSS VSS nch l=0.15 w=1 nf=1 m=1
M16 VB3 net0 VDD VDD pch l=0.15 w=1 nf=1 m=1
M17 VB3 VB3 VSS VSS nch l=0.15 w=1 nf=1 m=1
M18 net0 net0 VDD VDD pch l=0.15 w=1 nf=1 m=1
M19 net0 VB2 VSS VSS nch l=0.15 w=1 nf=1 m=1
M2 net1 phi2 VSS VSS nch l=0.15 w=1 nf=1 m=1
M20 VB2 net0 VDD VDD pch l=0.15 w=1 nf=1 m=1
M21 VB2 VB2 VSS VSS nch l=0.15 w=1 nf=1 m=1
M3 net4 phi1 VSS VSS nch l=0.15 w=1 nf=1 m=1
M4 net4 phi2 net2 VSS nch l=0.15 w=1 nf=1 m=1
M5 net3 net2 net5 VSS nch l=0.15 w=1 nf=1 m=1
M6 net6 VSS net5 VSS nch l=0.15 w=1 nf=1 m=1
M7 net5 VB3 VSS VSS nch l=0.15 w=1 nf=1 m=1
M8 net3 net3 VDD VDD pch l=0.15 w=1 nf=1 m=1
M9 net6 net6 VDD VDD pch l=0.15 w=1 nf=1 m=1
.ends dut
