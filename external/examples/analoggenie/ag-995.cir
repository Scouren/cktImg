* official Analog Canvas netlist; PDK X cards rewritten by convert.py
.model nch nmos
.model pch pmos

.subckt dut VDD VSS vin VBIAS vout
Cc1 net0 vout 1p
M1 net1 vin net3 VSS nch l=0.15 w=1 nf=1 m=1
M2 net2 vout net3 VSS nch l=0.15 w=1 nf=1 m=1
M3 net1 net2 VDD VDD pch l=0.15 w=1 nf=1 m=1
M4 net2 net2 VDD VDD pch l=0.15 w=1 nf=1 m=1
M5 net3 VBIAS VSS VSS nch l=0.15 w=1 nf=1 m=1
M6 vout net1 VDD VDD pch l=0.15 w=1 nf=1 m=1
MR1 net0 VSS net1 VDD pch l=0.15 w=1 nf=1 m=1
.ends dut
