* official Analog Canvas netlist; PDK X cards rewritten by convert.py
.model nch nmos
.model pch pmos

.subckt dut VDD VSS Vin1 Vin2 Vb S1
.model ideal_switch SW(RON=1 ROFF=1e12 VT=0.5 VH=0)
C1 net1 X 1p
C2 X net3 1p
ID net0 VSS DC 1m
M1 net1 Vin1 net2 VSS nch l=0.15 w=1 nf=1 m=1
M2 net3 Vin2 net2 VSS nch l=0.15 w=1 nf=1 m=1
M3 net1 Vb VDD VDD pch l=0.15 w=1 nf=1 m=1
M4 net3 Vb VDD VDD pch l=0.15 w=1 nf=1 m=1
M5 net2 X VSS VSS nch l=0.15 w=1 nf=1 m=1
M6 VDD net3 net0 VSS nch l=0.15 w=1 nf=1 m=1
M7 VDD net1 net0 VSS nch l=0.15 w=1 nf=1 m=1
S1 X net0 S1 VSS ideal_switch
.ends dut
