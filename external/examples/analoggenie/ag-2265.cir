* official Analog Canvas netlist; PDK X cards rewritten by convert.py
.model nch nmos
.model pch pmos

.subckt dut VDD VSS Vref VIN VOUT VB1
CL VOUT VX 1p
M1 net2 net2 VDD VDD pch l=0.15 w=1 nf=1 m=1
M10 net0 net0 net3 VSS nch l=0.15 w=1 nf=1 m=1
M11 net1 net1 VDD VDD pch l=0.15 w=1 nf=1 m=1
M12 net1 net0 VSS VSS nch l=0.15 w=1 nf=1 m=1
M13 VB2 net1 VDD VDD pch l=0.15 w=1 nf=1 m=1
M14 VB2 VB2 VSS VSS nch l=0.15 w=1 nf=1 m=1
M15 VB1 VB1 VDD VDD pch l=0.15 w=1 nf=1 m=1
M16 VB1 VB2 VSS VSS nch l=0.15 w=1 nf=1 m=1
M2 VX VX VDD VDD pch l=0.15 w=1 nf=1 m=1
M3 VX FB net4 VSS nch l=0.15 w=1 nf=1 m=1
M4 net2 Vref net4 VSS nch l=0.15 w=1 nf=1 m=1
M5 net5 net2 VDD VDD pch l=0.15 w=1 nf=1 m=1
M6 VY VX VDD VDD pch l=0.15 w=1 nf=1 m=1
M7 net4 VB2 VSS VSS nch l=0.15 w=1 nf=1 m=1
M8 VY VY VSS VSS nch l=0.15 w=1 nf=1 m=1
M9 net5 VY VSS VSS nch l=0.15 w=1 nf=1 m=1
MNP VIN net5 VOUT VSS nch l=0.15 w=1 nf=1 m=1
R1 VOUT FB 1k
R2 FB VSS 1k
R3 VX VSS 1k
R4 VDD net0 1k
R5 net3 VSS 1k
.ends dut
