* official Analog Canvas netlist; PDK X cards rewritten by convert.py
.model nch nmos

.subckt dut VDD VSS Vin Vout
M1 net2 net0 VSS VSS nch l=0.15 w=1 nf=1 m=1
M2 net1 net2 VSS VSS nch l=0.15 w=1 nf=1 m=1
M3 Vout net1 VSS VSS nch l=0.15 w=1 nf=1 m=1
R1 Vin net0 1k
R2 VDD net2 1k
R3 VDD net1 1k
R4 VDD Vout 1k
R5 net0 Vout 1k
.ends dut
