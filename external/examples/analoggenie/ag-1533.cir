* official Analog Canvas netlist; PDK X cards rewritten by convert.py
.model nch nmos
.model pch pmos
.model qnpn npn

.subckt opamp VDD VSS INN INP OUT VZ VB1
M1 net3 INP net4 VSS nch l=0.15 w=1 nf=1 m=1
M10 net0 net2 VSS VSS nch l=0.15 w=1 nf=1 m=1
M11 net2 net2 VSS VSS nch l=0.15 w=1 nf=1 m=1
M12 VB1 net2 VSS VSS nch l=0.15 w=1 nf=1 m=1
M13 VB1 VB1 VDD VDD pch l=0.15 w=1 nf=1 m=1
M14 VB2 VB1 VDD VDD pch l=0.15 w=1 nf=1 m=1
M15 VB2 VB2 VSS VSS nch l=0.15 w=1 nf=1 m=1
M2 net1 INN net4 VSS nch l=0.15 w=1 nf=1 m=1
M3 net3 net3 VDD VDD pch l=0.15 w=1 nf=1 m=1
M4 net1 net1 VDD VDD pch l=0.15 w=1 nf=1 m=1
M5 net4 VB2 VSS VSS nch l=0.15 w=1 nf=1 m=1
M6 OUT VZ VSS VSS nch l=0.15 w=1 nf=1 m=1
M7 OUT net3 VDD VDD pch l=0.15 w=1 nf=1 m=1
M8 VZ net1 VDD VDD pch l=0.15 w=1 nf=1 m=1
M9 VZ VZ VSS VSS nch l=0.15 w=1 nf=1 m=1
R4 VDD net0 1k
R5 net0 net2 1k
R6 VDD net2 1k
.ends opamp

.subckt dut VDD VSS Vout VB1
Q1 X X VSS VSS qnpn m=1
Q2 net0 net0 VSS VSS qnpn m=1
R1 Vout X 1k
R2 Vout Y 1k
R3 Y net0 1k
X1 VDD VSS Y X Vout net0 VB1 opamp
.ends dut
