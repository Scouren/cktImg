* official Analog Canvas netlist; PDK X cards rewritten by convert.py
.model nch nmos
.model pch pmos

.subckt dut VDD VSS VIN VOUT VERR VREF
M1 VX VEAOUT VIN VDD pch l=0.15 w=1 nf=1 m=1
M10 VX V1 VSS VSS nch l=0.15 w=1 nf=1 m=1
M11 net4 V2 VSS VSS nch l=0.15 w=1 nf=1 m=1
M12 net2 VB2 VDD VDD pch l=0.15 w=1 nf=1 m=1
M13 V1 VEAOUT net2 VDD pch l=0.15 w=1 nf=1 m=1
M14 V2 VREF net2 VDD pch l=0.15 w=1 nf=1 m=1
M15 V1 VC net6 VSS nch l=0.15 w=1 nf=1 m=1
M16 V2 VC net8 VSS nch l=0.15 w=1 nf=1 m=1
M17 net6 V1 VSS VSS nch l=0.15 w=1 nf=1 m=1
M18 net8 V2 VSS VSS nch l=0.15 w=1 nf=1 m=1
M19 VBP VBP VDD VDD pch l=0.15 w=1 nf=1 m=1
M2 net1 net1 VX VDD pch l=0.15 w=1 nf=1 m=1
M20 VBP VM1 VSS VSS nch l=0.15 w=1 nf=1 m=1
M21 VB3 VBP VDD VDD pch l=0.15 w=1 nf=1 m=1
M22 VB3 VB3 VSS VSS nch l=0.15 w=1 nf=1 m=1
M23 net7 VBP VDD VDD pch l=0.15 w=1 nf=1 m=1
M24 VM2 VBP VDD VDD pch l=0.15 w=1 nf=1 m=1
M25 net7 net7 VM1 VSS nch l=0.15 w=1 nf=1 m=1
M26 VM1 net7 net3 VSS nch l=0.15 w=1 nf=1 m=1
M27 net3 VM2 VB3 VSS nch l=0.15 w=1 nf=1 m=1
M28 VM2 VM2 net3 VSS nch l=0.15 w=1 nf=1 m=1
M29 VC VBP VDD VDD pch l=0.15 w=1 nf=1 m=1
M3 net1 nb VSS VSS nch l=0.15 w=1 nf=1 m=1
M30 VC VC VEAOUT VSS nch l=0.15 w=1 nf=1 m=1
M31 VEAOUT VC VSS VSS nch l=0.15 w=1 nf=1 m=1
M4 VM1 net0 VDD VDD pch l=0.15 w=1 nf=1 m=1
M5 VM2 net0 VDD VDD pch l=0.15 w=1 nf=1 m=1
M6 VEAOUT VB1 VM1 VDD pch l=0.15 w=1 nf=1 m=1
M7 net0 VB1 VM2 VDD pch l=0.15 w=1 nf=1 m=1
M8 VEAOUT VC VX VSS nch l=0.15 w=1 nf=1 m=1
M9 net0 VC net4 VSS nch l=0.15 w=1 nf=1 m=1
MBIAS VERR nb VSS VSS nch l=0.15 w=1 nf=1 m=1
MCHG net9 pb VIN VDD pch l=0.15 w=1 nf=1 m=1
MCTRL VERR net1 VOUT VDD pch l=0.15 w=1 nf=1 m=1
MGEN net5 net5 VSS VSS nch l=0.15 w=1 nf=1 m=1
MINJ VERR net5 VSS VSS nch l=0.15 w=1 nf=1 m=1
MRES VOUT VERR VIN VDD pch l=0.15 w=1 nf=1 m=1
MSEN net5 VEAOUT net9 VDD pch l=0.15 w=1 nf=1 m=1
.ends dut
