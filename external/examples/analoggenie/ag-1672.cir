* official Analog Canvas netlist; PDK X cards rewritten by convert.py
.model nch nmos
.model pch pmos
.model qpnp pnp

.global VDD

.subckt opamp VSS INN INP OUT
M1 net3 VB1 VDD VDD pch l=0.15 w=1 nf=1 m=1
M10 net2 VX VSS VSS nch l=0.15 w=1 nf=1 m=1
M11 net0 VX VSS VSS nch l=0.15 w=1 nf=1 m=1
M12 VB5 net1 VDD VDD pch l=0.15 w=1 nf=1 m=1
M13 net1 net1 VDD VDD pch l=0.15 w=1 nf=1 m=1
M14 VX net1 VDD VDD pch l=0.15 w=1 nf=1 m=1
M15 VB5 VB5 net5 VSS nch l=0.15 w=1 nf=1 m=1
M16 net5 VB5 VSS VSS nch l=0.15 w=1 nf=1 m=1
M17 net1 VX VB4 VSS nch l=0.15 w=1 nf=1 m=1
M18 VX VB4 VSS VSS nch l=0.15 w=1 nf=1 m=1
M2 INN VB1 VDD VDD pch l=0.15 w=1 nf=1 m=1
M3 INN INN net4 VSS nch l=0.15 w=1 nf=1 m=1
M4 net3 INP net4 VSS nch l=0.15 w=1 nf=1 m=1
M5 net4 VB2 VSS VSS nch l=0.15 w=1 nf=1 m=1
M6 VX VB3 INN VDD pch l=0.15 w=1 nf=1 m=1
M7 OUT VB3 net3 VDD pch l=0.15 w=1 nf=1 m=1
M8 VX VB5 net2 VSS nch l=0.15 w=1 nf=1 m=1
M9 OUT VB5 net0 VSS nch l=0.15 w=1 nf=1 m=1
R4 VB4 VSS 1k
.ends opamp

.subckt dut VSS Vout
Q1 VSS VSS net0 qpnp m=1
Q2 net0 net0 X qpnp m=1
Q3 VSS VSS net2 qpnp m=1
Q4 net2 net2 net1 qpnp m=1
R1 Vout X 1k
R2 Vout Y 1k
R3 Y net1 1k
X1 VSS Y X Vout opamp
.ends dut
