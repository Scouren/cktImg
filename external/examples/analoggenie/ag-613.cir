* official Analog Canvas netlist; PDK X cards rewritten by convert.py
.model nch nmos

.subckt dut VDD VSS
I3 VDD net2 DC 50uA
M1 net0 net2 net1 VSS nch l=0.15 w=1 nf=1 m=1
M2 net1 net0 VSS VSS nch l=0.15 w=1 nf=1 m=1
M3 VDD net2 net3 VSS nch l=0.15 w=1 nf=1 m=1
M4 net3 net0 VSS VSS nch l=0.15 w=1 nf=1 m=1
R1 net2 net0 5kΩ
.ends dut
