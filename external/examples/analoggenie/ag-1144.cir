* official Analog Canvas netlist; PDK X cards rewritten by convert.py
.model nch nmos

.subckt dut VDD VSS Y+ Y- Vbias X+ X-
C1 Y+ Y- 1p
Icmin net0 VSS DC 1m
Icore net3 VSS DC 1m
Ictune net0 VSS DC 1m
L1 VDD Y+ 1n
L2 VDD Y- 1n
M1 Y+ Y- net3 VSS nch l=0.15 w=1 nf=1 m=1
M2 Y- Y+ net3 VSS nch l=0.15 w=1 nf=1 m=1
M3 net2 X+ net0 VSS nch l=0.15 w=1 nf=1 m=1
M4 net1 X- net0 VSS nch l=0.15 w=1 nf=1 m=1
Mb1 Y+ Vbias net2 VSS nch l=0.15 w=1 nf=1 m=1
Mb2 Y- Vbias net1 VSS nch l=0.15 w=1 nf=1 m=1
.ends dut
