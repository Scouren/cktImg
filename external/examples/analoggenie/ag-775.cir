* official Analog Canvas netlist; PDK X cards rewritten by convert.py
.model nch nmos
.model pch pmos

.subckt dut VDD VSS v1 v2 Iout1a Iout2a Iout1b Iout2b
I1 net1 VSS DC 1m
I2 net0 VSS DC 1m
M1a Iout1a v1 net4 VSS nch l=0.15 w=1 nf=1 m=1
M1b Iout1b net1 net4 VDD pch l=0.15 w=1 nf=1 m=1
M2a Iout2a v2 net2 VSS nch l=0.15 w=1 nf=1 m=1
M2b Iout2b net0 net2 VDD pch l=0.15 w=1 nf=1 m=1
M3a VDD v1 net3 VSS nch l=0.15 w=1 nf=1 m=1
M3b net0 net0 net3 VDD pch l=0.15 w=1 nf=1 m=1
M4a VDD v2 net5 VSS nch l=0.15 w=1 nf=1 m=1
M4b net1 net1 net5 VDD pch l=0.15 w=1 nf=1 m=1
.ends dut
