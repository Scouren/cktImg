* official Analog Canvas netlist; PDK X cards rewritten by convert.py
.model nch nmos
.model pch pmos

.subckt comparator VDD VSS INN VB OUT
M1 OUT OUT VDD VDD pch l=0.15 w=1 nf=1 m=1
M2 OUT OUT VDD VDD pch l=0.15 w=1 nf=1 m=1
M3 net0 net0 VDD VDD pch l=0.15 w=1 nf=1 m=1
M4 net2 net0 VDD VDD pch l=0.15 w=1 nf=1 m=1
M5 OUT OUT net1 VSS nch l=0.15 w=1 nf=1 m=1
M6 net0 INN net1 VSS nch l=0.15 w=1 nf=1 m=1
M7 net1 VB VSS VSS nch l=0.15 w=1 nf=1 m=1
M8 net2 net2 VSS VSS nch l=0.15 w=1 nf=1 m=1
M9 OUT net2 VSS VSS nch l=0.15 w=1 nf=1 m=1
.ends comparator

.subckt dut VDD VSS VSTO VCONT1 VCONT2 VCONT3 VOUT VB2 VB1
CL VOUT VSS 1p
CSTO VSTO VSS 1p
LRX net3 net5 1n
M10 net6 VB2 VDD VDD pch l=0.15 w=1 nf=1 m=1
M11 net6 net6 VSS VSS nch l=0.15 w=1 nf=1 m=1
M12 VB2 VB2 VDD VDD pch l=0.15 w=1 nf=1 m=1
M13 VB2 net0 net4 VSS nch l=0.15 w=1 nf=1 m=1
M14 net4 net6 VSS VSS nch l=0.15 w=1 nf=1 m=1
M15 net0 VB2 VDD VDD pch l=0.15 w=1 nf=1 m=1
M16 net0 net0 VSS VSS nch l=0.15 w=1 nf=1 m=1
M17 net2 net2 VDD VDD pch l=0.15 w=1 nf=1 m=1
M18 net2 net0 VSS VSS nch l=0.15 w=1 nf=1 m=1
M19 VB3 net2 VDD VDD pch l=0.15 w=1 nf=1 m=1
M20 VB3 VB3 VSS VSS nch l=0.15 w=1 nf=1 m=1
M21 VB1 VB1 VDD VDD pch l=0.15 w=1 nf=1 m=1
M22 VB1 VB3 VSS VSS nch l=0.15 w=1 nf=1 m=1
MN1 net3 VCONT2 VSS VSS nch l=0.15 w=1 nf=1 m=1
MN2 net5 VCONT3 VSS VSS nch l=0.15 w=1 nf=1 m=1
MP2 net5 net1 VOUT VDD pch l=0.15 w=1 nf=1 m=1
MP3 net3 VCONT1 VSTO VDD pch l=0.15 w=1 nf=1 m=1
X1 VDD VSS net5 VB3 net1 comparator
.ends dut
