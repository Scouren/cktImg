* official Analog Canvas netlist; PDK X cards rewritten by convert.py
.model nch nmos
.model pch pmos

.subckt comparator VDD VSS INN OUT
M1 VX VB1 VDD VDD pch l=0.15 w=1 nf=1 m=1
M10 net2 VB2 VSS VSS nch l=0.15 w=1 nf=1 m=1
M11 VA VB2 VSS VSS nch l=0.15 w=1 nf=1 m=1
M12 VB5 net5 VDD VDD pch l=0.15 w=1 nf=1 m=1
M13 VB5 VB5 net3 VSS nch l=0.15 w=1 nf=1 m=1
M14 net3 VB5 VSS VSS nch l=0.15 w=1 nf=1 m=1
M15 net5 net5 VDD VDD pch l=0.15 w=1 nf=1 m=1
M16 net5 VX VB4 VSS nch l=0.15 w=1 nf=1 m=1
M17 VX net5 VDD VDD pch l=0.15 w=1 nf=1 m=1
M18 VX VB4 VSS VSS nch l=0.15 w=1 nf=1 m=1
M2 VA INN VX net6 pch l=0.15 w=1 nf=1 m=1
M3 net2 OUT VX net6 pch l=0.15 w=1 nf=1 m=1
M4 net4 net0 VDD VDD pch l=0.15 w=1 nf=1 m=1
M5 net1 net0 VDD VDD pch l=0.15 w=1 nf=1 m=1
M6 net0 VB3 net4 VDD pch l=0.15 w=1 nf=1 m=1
M7 OUT VB3 net1 VDD pch l=0.15 w=1 nf=1 m=1
M8 net0 VB5 net2 VSS nch l=0.15 w=1 nf=1 m=1
M9 OUT VB5 VA VSS nch l=0.15 w=1 nf=1 m=1
R1 VB4 VSS 1k
.ends comparator

.subckt dut VDD VSS VSTO VCONT1 VCONT2 VCONT3 VOUT
CL VOUT VSS 1p
CSTO VSTO VSS 1p
LRX net2 net1 1n
MN1 net2 VCONT2 VSS VSS nch l=0.15 w=1 nf=1 m=1
MN2 net1 VCONT3 VSS VSS nch l=0.15 w=1 nf=1 m=1
MP2 net1 net0 VOUT VOUT pch l=0.15 w=1 nf=1 m=1
MP3 net2 VCONT1 VSTO VSTO pch l=0.15 w=1 nf=1 m=1
X1 VDD VSS net1 net0 comparator
.ends dut
