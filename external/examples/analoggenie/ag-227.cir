* official Analog Canvas netlist; PDK X cards rewritten by convert.py
.model nch nmos

.subckt dut VDD VSS Vout
C1 Vout net0 1p
C2 net0 VSS 1p
I1 VDD Vout DC 1m
I2 net1 VSS DC 1m
M1 Vout net0 net1 VSS nch l=0.15 w=1 nf=1 m=1
Vin net1 VSS DC 1
.ends dut
