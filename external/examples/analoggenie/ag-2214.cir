* official Analog Canvas netlist; PDK X cards rewritten by convert.py
.model nch nmos
.model pch pmos

.subckt Opamp VDD VSS INP INN OUT
M1 net10 INP OUT VSS nch l=0.15 w=1 nf=1 m=1
M10 net5 net3 VSS VSS nch l=0.15 w=1 nf=1 m=1
M11 net9 net3 VSS VSS nch l=0.15 w=1 nf=1 m=1
M12 VC VP VDD VDD pch l=0.15 w=1 nf=1 m=1
M13 VC VC net2 VSS nch l=0.15 w=1 nf=1 m=1
M14 net2 VC VSS VSS nch l=0.15 w=1 nf=1 m=1
M15 VP VP VDD VDD pch l=0.15 w=1 nf=1 m=1
M16 VP net8 VSS VSS nch l=0.15 w=1 nf=1 m=1
M17 net1 VP VDD VDD pch l=0.15 w=1 nf=1 m=1
M18 net1 net1 net8 VSS nch l=0.15 w=1 nf=1 m=1
M19 net8 net1 net4 VSS nch l=0.15 w=1 nf=1 m=1
M2 net7 INN OUT VSS nch l=0.15 w=1 nf=1 m=1
M20 net6 VP VDD VDD pch l=0.15 w=1 nf=1 m=1
M21 net6 net6 net4 VSS nch l=0.15 w=1 nf=1 m=1
M22 net4 net6 net0 VSS nch l=0.15 w=1 nf=1 m=1
M23 net0 VP VDD VDD pch l=0.15 w=1 nf=1 m=1
M24 net0 net0 VSS VSS nch l=0.15 w=1 nf=1 m=1
M3 OUT VB2 VSS VSS nch l=0.15 w=1 nf=1 m=1
M4 net10 VB1 VDD VDD pch l=0.15 w=1 nf=1 m=1
M5 net7 VB1 VDD VDD pch l=0.15 w=1 nf=1 m=1
M6 OUT VB3 net10 VDD pch l=0.15 w=1 nf=1 m=1
M7 net3 VB3 net7 VDD pch l=0.15 w=1 nf=1 m=1
M8 OUT VC net5 VSS nch l=0.15 w=1 nf=1 m=1
M9 net3 VC net9 VSS nch l=0.15 w=1 nf=1 m=1
.ends Opamp

.subckt dut VDD VSS Vref VIN VOUT
CL VOUT net1 1p
MNP VIN net0 VOUT VSS nch l=0.15 w=1 nf=1 m=1
R1 VOUT FB 1k
R2 FB VSS 1k
RESR net1 VSS 1k
X1 VDD VSS Vref FB net0 Opamp
.ends dut
