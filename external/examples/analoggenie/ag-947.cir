* official Analog Canvas netlist; PDK X cards rewritten by convert.py
.model nch nmos
.model pch pmos

.subckt dut VDD VSS VREF
.model DIODE D(IS=1e-14 N=1)
VB1 VDD Vb1 DC 1
D1 net3 VSS DIODE
D2 net4 VSS DIODE
D3 net2 VSS DIODE
M1 net6 net6 net3 VSS nch l=0.15 w=1 nf=1 m=1
M2 net5 net6 net0 VSS nch l=0.15 w=1 nf=1 m=1
M3 net6 Vb1 net1 VDD pch l=0.15 w=1 nf=1 m=1
M4 net5 Vb1 net7 VDD pch l=0.15 w=1 nf=1 m=1
M5 VREF Vb1 net8 VDD pch l=0.15 w=1 nf=1 m=1
M6 net1 net5 VDD VDD pch l=0.15 w=1 nf=1 m=1
M7 net7 net5 VDD VDD pch l=0.15 w=1 nf=1 m=1
M8 net8 net5 VDD VDD pch l=0.15 w=1 nf=1 m=1
R1 net0 net4 1k
R2 VREF net2 1k
.ends dut
