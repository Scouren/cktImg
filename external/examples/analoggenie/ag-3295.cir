* official Analog Canvas netlist; PDK X cards rewritten by convert.py
.model nch nmos
.model pch pmos

.subckt opamp VDD VSS INP INN OUT
M10 VX net1 VSS VSS nch l=0.15 w=1 nf=1 m=1
M11 VX VX VDD VDD pch l=0.15 w=1 nf=1 m=1
M12 OUT VX VDD VDD pch l=0.15 w=1 nf=1 m=1
M13 OUT net4 VSS VSS nch l=0.15 w=1 nf=1 m=1
M14 net3 net3 VDD VDD pch l=0.15 w=1 nf=1 m=1
M15 net5 net3 VDD VDD pch l=0.15 w=1 nf=1 m=1
M16 net3 net5 net6 VSS nch l=0.15 w=1 nf=1 m=1
M17 net5 net6 VSS VSS nch l=0.15 w=1 nf=1 m=1
M18 net0 net3 VDD VDD pch l=0.15 w=1 nf=1 m=1
M19 net0 net0 VSS VSS nch l=0.15 w=1 nf=1 m=1
M20 VB1 VB1 VDD VDD pch l=0.15 w=1 nf=1 m=1
M21 VB1 net0 VSS VSS nch l=0.15 w=1 nf=1 m=1
M5 net2 VB1 VDD VDD pch l=0.15 w=1 nf=1 m=1
M6 net4 INN net2 VDD pch l=0.15 w=1 nf=1 m=1
M7 net1 INP net2 VDD pch l=0.15 w=1 nf=1 m=1
M8 net4 net4 VSS VSS nch l=0.15 w=1 nf=1 m=1
M9 net1 net1 VSS VSS nch l=0.15 w=1 nf=1 m=1
R1 net6 VSS 1k
.ends opamp

.subckt dut VDD VSS vci phi1 phi2 vco
C1 net0 net2 1p
C2 net1 vco 1p
M1 vci phi1 net0 VSS nch l=0.15 w=1 nf=1 m=1
M2 net0 phi2 VSS VSS nch l=0.15 w=1 nf=1 m=1
M3 net2 phi1 VSS VSS nch l=0.15 w=1 nf=1 m=1
M4 net2 phi2 net1 VSS nch l=0.15 w=1 nf=1 m=1
X1 VDD VSS VSS net1 vco opamp
.ends dut
