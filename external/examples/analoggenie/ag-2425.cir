* official Analog Canvas netlist; PDK X cards rewritten by convert.py
.model nch nmos
.model pch pmos

.subckt AEA VDD VSS VREF OUT
M10 OUT OUT VSS VSS nch l=0.15 w=1 nf=1 m=1
M11 OUT OUT VSS VSS nch l=0.15 w=1 nf=1 m=1
M12 net6 net1 VSS VSS nch l=0.15 w=1 nf=1 m=1
M13 net1 net3 VDD VDD pch l=0.15 w=1 nf=1 m=1
M14 net1 net1 VSS VSS nch l=0.15 w=1 nf=1 m=1
M15 net3 net3 VDD VDD pch l=0.15 w=1 nf=1 m=1
M16 net3 net4 VSS VSS nch l=0.15 w=1 nf=1 m=1
M17 net4 net5 VDD VDD pch l=0.15 w=1 nf=1 m=1
M18 net4 net4 VSS VSS nch l=0.15 w=1 nf=1 m=1
M19 net5 net4 VSS VSS nch l=0.15 w=1 nf=1 m=1
M4 net2 net2 VDD VDD pch l=0.15 w=1 nf=1 m=1
M5 OUT net2 VDD VDD pch l=0.15 w=1 nf=1 m=1
M6 OUT net0 VDD VDD pch l=0.15 w=1 nf=1 m=1
M7 net0 net0 VDD VDD pch l=0.15 w=1 nf=1 m=1
M8 net2 VREF net6 VSS nch l=0.15 w=1 nf=1 m=1
M9 net0 OUT net6 VSS nch l=0.15 w=1 nf=1 m=1
R1 VDD net4 1k
R2 VDD net5 1k
.ends AEA

.subckt dut VDD VSS VREF nb pb VOUT VIN
M1 net3 VEAOUT VIN VDD pch l=0.15 w=1 nf=1 m=1
M2 net0 net0 net3 VDD pch l=0.15 w=1 nf=1 m=1
M3 net0 nb VSS VSS nch l=0.15 w=1 nf=1 m=1
MBIAS VERR nb VSS VSS nch l=0.15 w=1 nf=1 m=1
MCHG net2 pb VIN VDD pch l=0.15 w=1 nf=1 m=1
MCTRL VERR net0 VOUT VDD pch l=0.15 w=1 nf=1 m=1
MGEN net1 net1 VSS VSS nch l=0.15 w=1 nf=1 m=1
MINJ VERR net1 VSS VSS nch l=0.15 w=1 nf=1 m=1
MRES VOUT VERR VIN VDD pch l=0.15 w=1 nf=1 m=1
MSEN net1 VEAOUT net2 VDD pch l=0.15 w=1 nf=1 m=1
X1 VDD VSS VREF VEAOUT AEA
.ends dut
