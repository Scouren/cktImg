* official Analog Canvas netlist; PDK X cards rewritten by convert.py
.model nch nmos
.model pch pmos

.subckt opamp VDD VSS INN INP OUT VX
M1 net3 VX VDD VDD pch l=0.15 w=1 nf=1 m=1
M10 VB3 VB1 VDD VDD pch l=0.15 w=1 nf=1 m=1
M11 VB3 VB3 VSS VSS nch l=0.15 w=1 nf=1 m=1
M12 VB1 VB1 VDD VDD pch l=0.15 w=1 nf=1 m=1
M13 VB1 net2 VSS VSS nch l=0.15 w=1 nf=1 m=1
M14 VB2 VB2 VDD VDD pch l=0.15 w=1 nf=1 m=1
M15 VB2 net4 net2 VSS nch l=0.15 w=1 nf=1 m=1
M16 net4 VB2 VDD VDD pch l=0.15 w=1 nf=1 m=1
M17 net4 net2 VSS VSS nch l=0.15 w=1 nf=1 m=1
M2 VX VX VDD VDD pch l=0.15 w=1 nf=1 m=1
M3 net0 net0 VDD VDD pch l=0.15 w=1 nf=1 m=1
M4 OUT net0 VDD VDD pch l=0.15 w=1 nf=1 m=1
M5 net3 net3 VSS VSS nch l=0.15 w=1 nf=1 m=1
M6 VX INN net1 VSS nch l=0.15 w=1 nf=1 m=1
M7 net0 INP net1 VSS nch l=0.15 w=1 nf=1 m=1
M8 OUT net3 VSS VSS nch l=0.15 w=1 nf=1 m=1
M9 net1 VB3 VSS VSS nch l=0.15 w=1 nf=1 m=1
R1 net2 VSS 1k
.ends opamp

.subckt dut VDD VSS VIN Vref VOUT
CL VOUT VX 1p
MNP VIN net0 VOUT VSS nch l=0.15 w=1 nf=1 m=1
R1 VOUT FB 1k
R2 FB VSS 1k
R3 VX VSS 1k
X1 VDD VSS FB Vref net0 VX opamp
.ends dut
