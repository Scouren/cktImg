* official Analog Canvas netlist; PDK X cards rewritten by convert.py
.model nch nmos
.model pch pmos

.subckt dut VDD VSS VB2 VREF VB1 VB4 IBUF VIN VOUT
CL VOUT net8 1p
M10 EAO VB1 net13 VDD pch l=0.15 w=1 nf=1 m=1
M11 net0 net10 VDD VDD pch l=0.15 w=1 nf=1 m=1
M12 net13 net10 VDD VDD pch l=0.15 w=1 nf=1 m=1
M13 net3 VB4 VDD VDD pch l=0.15 w=1 nf=1 m=1
M14 VX EAO net3 VDD pch l=0.15 w=1 nf=1 m=1
M15 VX VX VSS VSS nch l=0.15 w=1 nf=1 m=1
M16 GATE VX VSS VSS nch l=0.15 w=1 nf=1 m=1
M17 VDD net3 GATE VSS nch l=0.15 w=1 nf=1 m=1
M18 net9 EAO IBUF IBUF nch l=0.15 w=1 nf=1 m=1
M19 net9 net9 VDD VDD pch l=0.15 w=1 nf=1 m=1
M2 EAO VB2 VDD VDD pch l=0.15 w=1 nf=1 m=1
M20 GATE net9 VDD VDD pch l=0.15 w=1 nf=1 m=1
M21 VSS IBUF GATE VSS pch l=0.15 w=1 nf=1 m=1
M22 VY VBN net5 VSS nch l=0.15 w=1 nf=1 m=1
M23 net5 VY VSS VSS nch l=0.15 w=1 nf=1 m=1
M24 VX VBN net6 VSS nch l=0.15 w=1 nf=1 m=1
M25 net6 VX VSS VSS nch l=0.15 w=1 nf=1 m=1
M26 VBN net1 VDD VDD pch l=0.15 w=1 nf=1 m=1
M27 net1 net1 VDD VDD pch l=0.15 w=1 nf=1 m=1
M28 VB3 net1 VDD VDD pch l=0.15 w=1 nf=1 m=1
M29 net1 VB3 net2 VSS nch l=0.15 w=1 nf=1 m=1
M3 VX VREF EAO net11 pch l=0.15 w=1 nf=1 m=1
M30 VB3 VB3 VSS VSS nch l=0.15 w=1 nf=1 m=1
M31 VBN VBN net7 VSS nch l=0.15 w=1 nf=1 m=1
M32 net7 VBN VSS VSS nch l=0.15 w=1 nf=1 m=1
M4 VY FB EAO net11 pch l=0.15 w=1 nf=1 m=1
M5 net4 VX VSS VSS nch l=0.15 w=1 nf=1 m=1
M6 net12 VY VSS VSS nch l=0.15 w=1 nf=1 m=1
M7 net10 VBN net4 VSS nch l=0.15 w=1 nf=1 m=1
M8 EAO VBN net12 VSS nch l=0.15 w=1 nf=1 m=1
M9 net10 VB1 net0 VDD pch l=0.15 w=1 nf=1 m=1
MNP VIN GATE VOUT VOUT nch l=0.15 w=1 nf=1 m=1
R1 FB VSS 1k
R2 VOUT FB 1k
R3 net2 VSS 1k
R4 net8 VSS 1k
RL VOUT VSS 1k
.ends dut
