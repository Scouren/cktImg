* official Analog Canvas netlist; PDK X cards rewritten by convert.py
.model nch nmos

.subckt dut VDD VSS IB
Cshort1 VDD net1 1p
Cshort2 net2 VSS 1p
Ct net0 net3 1p
Ctail net4 net2 1p
L1 VDD net3 150pH
L2 VDD net0 150pH
Lgnd net1 VSS 200pH
Ltail net4 net2 120pH
M1 net3 net0 net4 VSS nch l=0.15 w=1 nf=1 m=1
M2 net0 net3 net4 VSS nch l=0.15 w=1 nf=1 m=1
M3 net2 IB VSS VSS nch l=0.15 w=1 nf=1 m=1
M4 IB IB VSS VSS nch l=0.15 w=1 nf=1 m=1
.ends dut
