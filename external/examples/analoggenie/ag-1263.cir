* official Analog Canvas netlist; PDK X cards rewritten by convert.py
.model nch nmos
.model pch pmos

.subckt EA1 VDD VSS VCTRL VREF VFP1 VX3
MN1 net0 VFP1 net4 VSS nch l=0.15 w=1 nf=1 m=1
MN2 VX3 VREF net4 VSS nch l=0.15 w=1 nf=1 m=1
MN3 net3 net3 VSS VSS nch l=0.15 w=1 nf=1 m=1
MN4 VCTRL net3 VSS VSS nch l=0.15 w=1 nf=1 m=1
MN5 net4 VBN VSS VSS nch l=0.15 w=1 nf=1 m=1
MN6 VBN VBN VSS VSS nch l=0.15 w=1 nf=1 m=1
MN7 VB1 net1 VSS VSS nch l=0.15 w=1 nf=1 m=1
MN8 net1 net1 VSS VSS nch l=0.15 w=1 nf=1 m=1
MN9 net2 net1 VSS VSS nch l=0.15 w=1 nf=1 m=1
MP1 net3 net0 VDD VDD pch l=0.15 w=1 nf=1 m=1
MP2 net0 net0 VDD VDD pch l=0.15 w=1 nf=1 m=1
MP3 VX3 VX3 VDD VDD pch l=0.15 w=1 nf=1 m=1
MP4 VCTRL VX3 VDD VDD pch l=0.15 w=1 nf=1 m=1
MP5 VBN VB1 VDD VDD pch l=0.15 w=1 nf=1 m=1
MP6 VB1 VB1 VDD VDD pch l=0.15 w=1 nf=1 m=1
R1 VDD net2 1k
R2 net1 net2 1k
RBIAS VDD net1 1k
.ends EA1

.subckt dut VDD VSS VIN VP VS5 VS1 VS2 VS3 VS4 VB2 VREF
.model DIODE D(IS=1e-14 N=1)
CFLY VX1 VX2 1p
CO VP VN 1p
COP VP VSS 1p
D1 VN VX2 DIODE
L1 VX1 VX3 1n
M1 VX1 VS1 VIN VDD pch l=0.15 w=1 nf=1 m=1
M2 VX2 VS2 VIN VDD pch l=0.15 w=1 nf=1 m=1
M3 VP VS3 VX3 VDD pch l=0.15 w=1 nf=1 m=1
M4 VX3 VS4 VSS VSS nch l=0.15 w=1 nf=1 m=1
M5 net1 VS5 VIN VDD pch l=0.15 w=1 nf=1 m=1
MN10 net2 net2 VSS VSS nch l=0.15 w=1 nf=1 m=1
MN11 net0 net2 VSS VSS nch l=0.15 w=1 nf=1 m=1
MN12 net2 VB2 VSS VSS nch l=0.15 w=1 nf=1 m=1
MP7 net0 net0 net1 VDD pch l=0.15 w=1 nf=1 m=1
MP8 VX1 net0 net1 VDD pch l=0.15 w=1 nf=1 m=1
MP9 net2 net3 net1 VDD pch l=0.15 w=1 nf=1 m=1
R1 VP VFP1 1k
R2 VFP1 VSS 1k
X1 VDD VSS net3 VREF VFP1 VX3 EA1
.ends dut
