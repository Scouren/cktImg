* official Analog Canvas netlist; PDK X cards rewritten by convert.py
.model nch nmos
.model pch pmos

.subckt dut VSS Ibias +Vo -Vo Vctrl
L1 +Vo net1 1n
L2 Ibias +Vo 1n
L3 -Vo net0 1n
L4 Ibias -Vo 1n
M1 +Vo -Vo VSS VSS nch l=0.15 w=1 nf=1 m=1
M2 -Vo +Vo VSS VSS nch l=0.15 w=1 nf=1 m=1
M3 Vctrl net1 Vctrl Vctrl pch l=0.15 w=1 nf=1 m=1
M4 Vctrl net0 Vctrl Vctrl pch l=0.15 w=1 nf=1 m=1
.ends dut
