* official Analog Canvas netlist; PDK X cards rewritten by convert.py
.model nch nmos
.model pch pmos

.subckt dut VDD VSS vin- vin+ vo+ vo-
I1 net0 VSS DC 1m
I2 net1 VSS DC 1m
M1 vo+ vin- net1 VSS nch l=0.15 w=1 nf=1 m=1
M2 vo- vin+ net1 VSS nch l=0.15 w=1 nf=1 m=1
M3 vo+ net0 VDD VDD pch l=0.15 w=1 nf=1 m=1
M4 vo- net0 VDD VDD pch l=0.15 w=1 nf=1 m=1
M5 vo+ vo+ VDD VDD pch l=0.15 w=1 nf=1 m=1
M6 vo- vo- VDD VDD pch l=0.15 w=1 nf=1 m=1
M7 net0 net0 VDD VDD pch l=0.15 w=1 nf=1 m=1
.ends dut
