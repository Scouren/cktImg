* official Analog Canvas netlist; PDK X cards rewritten by convert.py
.model nch nmos

.subckt dut VDD VSS Vout
C2 Vout X 1p
CP VDD Vout 1p
Ib X VSS DC 1m
LP VDD Vout 1n
M1 Vout net0 X VSS nch l=0.15 w=1 nf=1 m=1
RP VDD Vout 1k
Vin net0 VSS DC 1
.ends dut
