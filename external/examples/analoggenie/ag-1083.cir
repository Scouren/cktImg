* official Analog Canvas netlist; PDK X cards rewritten by convert.py
.model nch nmos

.subckt dut VDD VSS Vb Vout
I1 X VSS DC 1m
M1 Y Vb X VSS nch l=0.15 w=1 nf=1 m=1
M2 Vout X VSS VSS nch l=0.15 w=1 nf=1 m=1
M7 Vout Y VSS VSS nch l=0.15 w=1 nf=1 m=1
R1 VDD Y 1k
R2 VDD Vout 1k
RS net0 X 1k
VS net0 VSS DC 1 SIN(0 1 1k 0 0 0)
.ends dut
