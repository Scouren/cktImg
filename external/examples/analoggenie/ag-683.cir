* official Analog Canvas netlist; PDK X cards rewritten by convert.py
.model nch nmos
.model pch pmos

.subckt dut VDD VSS vi Vo
I1 VDD net4 DC 1m
I2 net0 VSS DC 1m
M1 net1 vi VSS VSS nch l=0.15 w=1 nf=1 m=1
M2 Vo net4 net1 VSS nch l=0.15 w=1 nf=1 m=1
M3 net3 net2 VDD VDD pch l=0.15 w=1 nf=1 m=1
M4 net2 net2 VDD VDD pch l=0.15 w=1 nf=1 m=1
M5 net5 net5 VSS VSS nch l=0.15 w=1 nf=1 m=1
M6 net4 net4 net5 VSS nch l=0.15 w=1 nf=1 m=1
M7 Vo net0 net3 VDD pch l=0.15 w=1 nf=1 m=1
M8 net0 net0 net2 VDD pch l=0.15 w=1 nf=1 m=1
.ends dut
