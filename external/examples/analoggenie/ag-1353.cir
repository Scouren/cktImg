* official Analog Canvas netlist; PDK X cards rewritten by convert.py
.model nch nmos
.model pch pmos

.subckt EA1 VDD VSS VFP1 VREF OUT VX2
MN1 VB1 VFP1 net1 VSS nch l=0.15 w=1 nf=1 m=1
MN10 VB2 VX2 VSS VSS nch l=0.15 w=1 nf=1 m=1
MN11 VX2 VX2 VSS VSS nch l=0.15 w=1 nf=1 m=1
MN2 OUT VREF net1 VSS nch l=0.15 w=1 nf=1 m=1
MN3 net0 net0 VSS VSS nch l=0.15 w=1 nf=1 m=1
MN4 net1 net0 VSS VSS nch l=0.15 w=1 nf=1 m=1
MN8 VBP VB3 VB2 VSS nch l=0.15 w=1 nf=1 m=1
MN9 VB3 VB2 VSS VSS nch l=0.15 w=1 nf=1 m=1
MP1 VB1 VB1 VDD VDD pch l=0.15 w=1 nf=1 m=1
MP2 OUT VB1 VDD VDD pch l=0.15 w=1 nf=1 m=1
MP6 net0 VBP VDD VDD pch l=0.15 w=1 nf=1 m=1
MP7 VBP VBP VDD VDD pch l=0.15 w=1 nf=1 m=1
MP8 VB3 VBP VDD VDD pch l=0.15 w=1 nf=1 m=1
MP9 VX2 VBP VDD VDD pch l=0.15 w=1 nf=1 m=1
.ends EA1

.subckt ISR VDD VSS CTRL VB4 VS OUT
MN5 net1 VB4 VSS VSS nch l=0.15 w=1 nf=1 m=1
MN6 net0 net1 VSS VSS nch l=0.15 w=1 nf=1 m=1
MN7 net1 net1 VSS VSS nch l=0.15 w=1 nf=1 m=1
MP3 net1 CTRL VS VDD pch l=0.15 w=1 nf=1 m=1
MP4 net0 net0 VS VDD pch l=0.15 w=1 nf=1 m=1
MP5 OUT net0 VS VDD pch l=0.15 w=1 nf=1 m=1
.ends ISR

.subckt dut VDD VSS VIN VP VREF VB4 VCONT1 VCONT2 VCONT3 VCONT4 VCONT5
.model DIODE D(IS=1e-14 N=1)
CFLY VX1 VX2 1p
CO VP VN 1p
COP VP VSS 1p
D1 VN VX2 DIODE
L1 VX1 VX3 1n
M1 VX1 VCONT2 VIN VDD pch l=0.15 w=1 nf=1 m=1
M2 VX2 VCONT3 VIN VDD pch l=0.15 w=1 nf=1 m=1
M3 VP VCONT5 VX3 VDD pch l=0.15 w=1 nf=1 m=1
M4 VX3 VCONT4 VSS VSS nch l=0.15 w=1 nf=1 m=1
M5 net0 VCONT1 VIN VDD pch l=0.15 w=1 nf=1 m=1
R1 VP VFP1 1k
R2 VFP1 VSS 1k
X1 VDD VSS net1 VB4 net0 VX1 ISR
X2 VDD VSS VFP1 VREF net1 VX2 EA1
.ends dut
