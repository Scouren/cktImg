* official Analog Canvas netlist; PDK X cards rewritten by convert.py
.model nch nmos
.model pch pmos
.model qpnp pnp

.subckt OPAMP VDD VSS IN- IN+ OUT
M1 net3 IN- net6 VSS nch l=0.15 w=1 nf=1 m=1
M10 net5 VB2 VDD VDD pch l=0.15 w=1 nf=1 m=1
M11 net5 net5 VSS VSS nch l=0.15 w=1 nf=1 m=1
M12 VB2 VB2 VDD VDD pch l=0.15 w=1 nf=1 m=1
M13 VB2 net2 net0 VSS nch l=0.15 w=1 nf=1 m=1
M14 net0 net5 VSS VSS nch l=0.15 w=1 nf=1 m=1
M15 net2 VB2 VDD VDD pch l=0.15 w=1 nf=1 m=1
M16 net2 net2 VSS VSS nch l=0.15 w=1 nf=1 m=1
M17 net7 net7 VDD VDD pch l=0.15 w=1 nf=1 m=1
M18 net7 net2 VSS VSS nch l=0.15 w=1 nf=1 m=1
M19 VB3 net7 VDD VDD pch l=0.15 w=1 nf=1 m=1
M2 net1 IN+ net6 VSS nch l=0.15 w=1 nf=1 m=1
M20 VB3 VB3 VSS VSS nch l=0.15 w=1 nf=1 m=1
M21 VB1 VB1 VDD VDD pch l=0.15 w=1 nf=1 m=1
M22 VB1 VB3 VSS VSS nch l=0.15 w=1 nf=1 m=1
M3 net6 VB3 VSS VSS nch l=0.15 w=1 nf=1 m=1
M4 OUT net4 VSS VSS nch l=0.15 w=1 nf=1 m=1
M5 net3 net3 VDD VDD pch l=0.15 w=1 nf=1 m=1
M6 net1 net1 VDD VDD pch l=0.15 w=1 nf=1 m=1
M7 net4 net3 VDD VDD pch l=0.15 w=1 nf=1 m=1
M8 OUT net1 VDD VDD pch l=0.15 w=1 nf=1 m=1
M9 net4 net4 VSS VSS nch l=0.15 w=1 nf=1 m=1
.ends OPAMP

.subckt dut VDD VSS Vout
Q1 VSS VSS X qpnp m=1
Q2 VSS VSS net0 qpnp m=1
R1 Vout X 1k
R2 Vout Y 1k
R3 Y net0 1k
X1 VDD VSS Y X Vout OPAMP
.ends dut
