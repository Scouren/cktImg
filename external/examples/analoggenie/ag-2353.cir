* official Analog Canvas netlist; PDK X cards rewritten by convert.py
.model nch nmos
.model pch pmos

.subckt bias VDD VSS VBN
M22 net3 VB2 VDD VDD pch l=0.15 w=1 nf=1 m=1
M23 net3 net3 VSS VSS nch l=0.15 w=1 nf=1 m=1
M24 VB2 VB2 VDD VDD pch l=0.15 w=1 nf=1 m=1
M25 VB2 net2 net1 VSS nch l=0.15 w=1 nf=1 m=1
M26 net1 net3 VSS VSS nch l=0.15 w=1 nf=1 m=1
M27 net2 VB2 VDD VDD pch l=0.15 w=1 nf=1 m=1
M28 net2 net2 VSS VSS nch l=0.15 w=1 nf=1 m=1
M29 net0 net0 VDD VDD pch l=0.15 w=1 nf=1 m=1
M30 net0 net2 VSS VSS nch l=0.15 w=1 nf=1 m=1
M31 VBN net0 VDD VDD pch l=0.15 w=1 nf=1 m=1
M32 VBN VBN VSS VSS nch l=0.15 w=1 nf=1 m=1
M33 VB1 VB1 VDD VDD pch l=0.15 w=1 nf=1 m=1
M34 VB1 VBN VSS VSS nch l=0.15 w=1 nf=1 m=1
.ends bias

.subckt dut VDD VSS VREF VB4 IBUF VIN VOUT
CL VOUT net4 1p
M1 net1 net1 VDD VDD pch l=0.15 w=1 nf=1 m=1
M13 net2 VB4 VDD VDD pch l=0.15 w=1 nf=1 m=1
M14 VX EAO net2 VDD pch l=0.15 w=1 nf=1 m=1
M15 VX VX VSS VSS nch l=0.15 w=1 nf=1 m=1
M16 GATE VX VSS VSS nch l=0.15 w=1 nf=1 m=1
M17 VDD net2 GATE VSS nch l=0.15 w=1 nf=1 m=1
M18 net3 EAO IBUF VSS nch l=0.15 w=1 nf=1 m=1
M19 net3 net3 VDD VDD pch l=0.15 w=1 nf=1 m=1
M2 net0 net0 VDD VDD pch l=0.15 w=1 nf=1 m=1
M20 GATE net3 VDD VDD pch l=0.15 w=1 nf=1 m=1
M21 VSS IBUF GATE VDD pch l=0.15 w=1 nf=1 m=1
M3 net1 VREF VX VSS nch l=0.15 w=1 nf=1 m=1
M4 net0 FB VX VSS nch l=0.15 w=1 nf=1 m=1
M5 VN net0 VDD VDD pch l=0.15 w=1 nf=1 m=1
M6 EAO net1 VDD VDD pch l=0.15 w=1 nf=1 m=1
M7 VN VN VSS VSS nch l=0.15 w=1 nf=1 m=1
M8 EAO VN VSS VSS nch l=0.15 w=1 nf=1 m=1
M9 VX VBN VSS VSS nch l=0.15 w=1 nf=1 m=1
MNP VIN GATE VOUT VSS nch l=0.15 w=1 nf=1 m=1
R1 FB VSS 1k
R2 VOUT FB 1k
R3 net4 VSS 1k
RL VOUT VSS 1k
X1 VDD VSS VBN bias
.ends dut
