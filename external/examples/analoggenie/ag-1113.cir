* official Analog Canvas netlist; PDK X cards rewritten by convert.py
.model nch nmos
.model pch pmos

.subckt dut VDD Vbuffer VSS Vbias Vtune
C1 Vtune net2 1p
C2 Vtune net6 1p
C3 net7 net3 1p
C4 net4 net0 1p
L1 Vbuffer net5 1n
L2 Vbuffer net1 1n
L3 Vbuffer net7 1n
L4 Vbuffer net4 1n
L5 Vdrain net2 1n
L6 Vdrain net6 1n
M1 net2 net6 VSS VSS nch l=0.15 w=1 nf=1 m=1
M2 net6 net2 VSS VSS nch l=0.15 w=1 nf=1 m=1
M3 net5 net2 VSS VSS nch l=0.15 w=1 nf=1 m=1
M4 net1 net6 VSS VSS nch l=0.15 w=1 nf=1 m=1
M5 net7 net5 VSS VSS nch l=0.15 w=1 nf=1 m=1
M6 net4 net1 VSS VSS nch l=0.15 w=1 nf=1 m=1
M7 Vdrain Vbias VDD VDD pch l=0.15 w=1 nf=1 m=1
R1 net3 VSS 50Ω
R2 net0 VSS 50Ω
.ends dut
