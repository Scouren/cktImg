* official Analog Canvas netlist; PDK X cards rewritten by convert.py
.model nch nmos
.model pch pmos

.subckt dut VDD VSS Vout
C1 VSS net1 2pF
C2 net4 Vout 1pF
C3 net3 net2 1p
I1 VDD net1 DC 2mA
I2 VDD Vout DC 2mA
M1 net0 net2 VSS VSS nch l=0.15 w=30 nf=1 m=1
M2 net0 net2 net1 net1 pch l=0.1 w=80 nf=1 m=1
M3 VSS net0 Vout Vout pch l=0.15 w=80 nf=1 m=1
R1 net2 net0 5kΩ
RM net2 net4 450Ω
RS net5 net3 1k
Vin net5 VSS DC 1
.ends dut
