* official Analog Canvas netlist; PDK X cards rewritten by convert.py
.model nch nmos
.model pch pmos
.model qpnp pnp

.subckt opamp VDD VSS INN INP OUT VB1 VB2 VB3
M1 INN INN net4 VSS nch l=0.15 w=1 nf=1 m=1
M10 net2 net3 VSS VSS nch l=0.15 w=1 nf=1 m=1
M11 net4 VB5 VSS VSS nch l=0.15 w=1 nf=1 m=1
M12 VB4 net0 VDD VDD pch l=0.15 w=1 nf=1 m=1
M13 VB4 VB4 VB5 VSS nch l=0.15 w=1 nf=1 m=1
M14 VB5 VB5 VSS VSS nch l=0.15 w=1 nf=1 m=1
M15 net0 net0 VDD VDD pch l=0.15 w=1 nf=1 m=1
M16 net0 VB3 net6 VSS nch l=0.15 w=1 nf=1 m=1
M17 VB3 net0 VDD VDD pch l=0.15 w=1 nf=1 m=1
M18 VB3 VB3 VSS VSS nch l=0.15 w=1 nf=1 m=1
M2 net1 INP net4 VSS nch l=0.15 w=1 nf=1 m=1
M3 INN VB1 VDD VDD pch l=0.15 w=1 nf=1 m=1
M4 net1 VB1 VDD VDD pch l=0.15 w=1 nf=1 m=1
M5 net3 VB2 INN VDD pch l=0.15 w=1 nf=1 m=1
M6 OUT VB2 net1 VDD pch l=0.15 w=1 nf=1 m=1
M7 net3 VB4 net5 VSS nch l=0.15 w=1 nf=1 m=1
M8 OUT VB4 net2 VSS nch l=0.15 w=1 nf=1 m=1
M9 net5 net3 VSS VSS nch l=0.15 w=1 nf=1 m=1
R4 net6 VSS 1k
.ends opamp

.subckt dut VDD VSS Vout VB1 VB2 VB3
Q1 VSS VSS net0 qpnp m=1
Q2 net0 net0 X qpnp m=1
Q3 VSS VSS net2 qpnp m=1
Q4 net2 net2 net1 qpnp m=1
R1 Vout X 1k
R2 Vout Y 1k
R3 Y net1 1k
X1 VDD VSS Y X Vout VB1 VB2 VB3 opamp
.ends dut
