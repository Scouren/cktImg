* official Analog Canvas netlist; PDK X cards rewritten by convert.py
.model nch nmos
.model pch pmos
.model qnpn npn

.subckt A1 VDD VSS INN INP OUT VZ VB3
M1 net2 INN net1 VSS nch l=0.15 w=1 nf=1 m=1
M2 net0 INP net1 VSS nch l=0.15 w=1 nf=1 m=1
M3 net1 VB3 VSS VSS nch l=0.15 w=1 nf=1 m=1
M4 net2 net2 VDD VDD pch l=0.15 w=1 nf=1 m=1
M5 net0 net0 VDD VDD pch l=0.15 w=1 nf=1 m=1
M6 VZ net2 VDD VDD pch l=0.15 w=1 nf=1 m=1
M7 OUT net0 VDD VDD pch l=0.15 w=1 nf=1 m=1
M8 VZ VZ VSS VSS nch l=0.15 w=1 nf=1 m=1
M9 OUT VZ VSS VSS nch l=0.15 w=1 nf=1 m=1
.ends A1

.subckt dut VDD VSS Vout
M10 VB3 VB1 VDD VDD pch l=0.15 w=1 nf=1 m=1
M11 VB3 VB3 VSS VSS nch l=0.15 w=1 nf=1 m=1
M12 VB1 VB1 VDD VDD pch l=0.15 w=1 nf=1 m=1
M13 VB1 net1 VSS VSS nch l=0.15 w=1 nf=1 m=1
M14 net1 VB2 VDD VDD pch l=0.15 w=1 nf=1 m=1
M15 net1 net1 VSS VSS nch l=0.15 w=1 nf=1 m=1
M16 VB2 VB2 VDD VDD pch l=0.15 w=1 nf=1 m=1
M17 VB2 net1 VSS VSS nch l=0.15 w=1 nf=1 m=1
Q1 X X VSS VSS qnpn m=1
Q2 net0 net0 VSS VSS qnpn m=1
R1 Vout X 1k
R2 Vout Y 1k
R3 Y net0 1k
X1 VDD VSS Y X Vout net0 VB3 A1
.ends dut
