* official Analog Canvas netlist; PDK X cards rewritten by convert.py
.model nch nmos
.model pch pmos

.subckt opamp VDD VSS Vn Vp Vo VX
M1 VX Vn net2 VSS nch l=0.15 w=1 nf=1 m=1
M10 VB2 VB2 VDD VDD pch l=0.15 w=1 nf=1 m=1
M11 net3 VB2 VDD VDD pch l=0.15 w=1 nf=1 m=1
M12 VB1 VB1 VDD VDD pch l=0.15 w=1 nf=1 m=1
M13 VB3 VB1 VDD VDD pch l=0.15 w=1 nf=1 m=1
M14 VB2 net3 net4 VSS nch l=0.15 w=1 nf=1 m=1
M15 net3 net3 VSS VSS nch l=0.15 w=1 nf=1 m=1
M16 VB1 net3 VSS VSS nch l=0.15 w=1 nf=1 m=1
M17 VB3 VB3 VSS VSS nch l=0.15 w=1 nf=1 m=1
M2 net1 Vp net2 VSS nch l=0.15 w=1 nf=1 m=1
M3 net0 VX VDD VDD pch l=0.15 w=1 nf=1 m=1
M4 VX VX VDD VDD pch l=0.15 w=1 nf=1 m=1
M5 net1 net1 VDD VDD pch l=0.15 w=1 nf=1 m=1
M6 Vo net1 VDD VDD pch l=0.15 w=1 nf=1 m=1
M7 net2 VB3 VSS VSS nch l=0.15 w=1 nf=1 m=1
M8 net0 net0 VSS VSS nch l=0.15 w=1 nf=1 m=1
M9 Vo net0 VSS VSS nch l=0.15 w=1 nf=1 m=1
R1 net4 VSS 1k
.ends opamp

.subckt dut VDD VSS Vref VIN VOUT
CL VOUT VX 1p
MNP VIN net0 VOUT VSS nch l=0.15 w=1 nf=1 m=1
R1 VOUT FB 1k
R2 FB VSS 1k
R3 VX VSS 1k
X1 VDD VSS FB Vref net0 VX opamp
.ends dut
