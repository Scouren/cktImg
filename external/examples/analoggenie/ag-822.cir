* official Analog Canvas netlist; PDK X cards rewritten by convert.py
.model qnpn npn

.subckt dut VCC VSS vi vo
C1 vi net0 1p
C2 net4 net7 1p
C3 net2 VSS 1p
C4 net5 net6 1p
C5 net1 VSS 1p
C6 net3 vo 1p
Q1 net4 net0 net2 VSS qnpn m=1
Q2 net5 net7 net1 VSS qnpn m=1
Q3 VCC net6 net3 VSS qnpn m=1
R1 VCC net0 1k
R10 net6 VSS 1k
R11 net3 VSS 1k
R2 net0 VSS 1k
R3 VCC net4 1k
R4 net2 VSS 1k
R5 VCC net7 1k
R6 net7 VSS 1k
R7 VCC net5 1k
R8 net1 VSS 1k
R9 VCC net6 1k
.ends dut
