* official Analog Canvas netlist; PDK X cards rewritten by convert.py
.model nch nmos
.model pch pmos

.subckt AMP1 VDD VSS INN VB2 INP OUT VB1 N3
M10 net0 N3 VDD VDD pch l=0.15 w=1 nf=1 m=1
M11 N3 VB1 net0 VDD pch l=0.15 w=1 nf=1 m=1
M12 N3 INN net4 VSS nch l=0.15 w=1 nf=1 m=1
M13 net7 net5 VDD VDD pch l=0.15 w=1 nf=1 m=1
M14 net5 VB1 net7 VDD pch l=0.15 w=1 nf=1 m=1
M15 net5 INP net4 VSS nch l=0.15 w=1 nf=1 m=1
M16 net6 net5 VDD VDD pch l=0.15 w=1 nf=1 m=1
M17 OUT VB1 net6 VDD pch l=0.15 w=1 nf=1 m=1
M18 OUT VN net2 VSS nch l=0.15 w=1 nf=1 m=1
M19 net2 VX VSS VSS nch l=0.15 w=1 nf=1 m=1
M20 net4 VB2 VSS VSS nch l=0.15 w=1 nf=1 m=1
M21 VN VP VDD VDD pch l=0.15 w=1 nf=1 m=1
M22 VN VN net1 VSS nch l=0.15 w=1 nf=1 m=1
M23 net1 VN VSS VSS nch l=0.15 w=1 nf=1 m=1
M24 VP VP VDD VDD pch l=0.15 w=1 nf=1 m=1
M25 VP VB3 net10 VSS nch l=0.15 w=1 nf=1 m=1
M26 net10 net8 VSS VSS nch l=0.15 w=1 nf=1 m=1
M27 net8 VP VDD VDD pch l=0.15 w=1 nf=1 m=1
M28 net8 net8 VSS VSS nch l=0.15 w=1 nf=1 m=1
M29 VB3 VP VDD VDD pch l=0.15 w=1 nf=1 m=1
M30 VB3 VB3 VSS VSS nch l=0.15 w=1 nf=1 m=1
M6 net9 N3 VDD VDD pch l=0.15 w=1 nf=1 m=1
M7 VX VB1 net9 VDD pch l=0.15 w=1 nf=1 m=1
M8 VX VN net3 VSS nch l=0.15 w=1 nf=1 m=1
M9 net3 VX VSS VSS nch l=0.15 w=1 nf=1 m=1
.ends AMP1

.subckt dut VDD VSS biasp biascas biasn Vref Vout VB1 VB2
C1 Vset VSS 1p
C2 n3 Vout 1p
M1 Vout n3 VDD VDD pch l=0.15 w=1 nf=1 m=1
M2 n1 Vset Vout VDD pch l=0.15 w=1 nf=1 m=1
M3 n1 biasn VSS VSS nch l=0.15 w=1 nf=1 m=1
M4 n3 biasp VDD VDD pch l=0.15 w=1 nf=1 m=1
M5 n3 biascas n1 VSS nch l=0.15 w=1 nf=1 m=1
R1 fb VSS 1k
R2 Vout fb 1k
X1 VDD VSS fb VB2 Vref Vset VB1 n3 AMP1
.ends dut
