* official Analog Canvas netlist; PDK X cards rewritten by convert.py
.model nch nmos
.model pch pmos
.model qpnp pnp

.subckt opamp VDD VSS INN INP OUT
M1 INN INN net5 VSS nch l=0.15 w=1 nf=1 m=1
M10 net3 net4 VSS VSS nch l=0.15 w=1 nf=1 m=1
M11 net1 net4 VSS VSS nch l=0.15 w=1 nf=1 m=1
M12 VB5 net2 VDD VDD pch l=0.15 w=1 nf=1 m=1
M13 VB5 VB5 VB4 VSS nch l=0.15 w=1 nf=1 m=1
M14 VB4 VB4 VSS VSS nch l=0.15 w=1 nf=1 m=1
M15 net2 net2 VDD VDD pch l=0.15 w=1 nf=1 m=1
M16 VB3 net2 VDD VDD pch l=0.15 w=1 nf=1 m=1
M17 net2 VB3 VSS VSS nch l=0.15 w=1 nf=1 m=1
M18 VB3 VB3 VSS VSS nch l=0.15 w=1 nf=1 m=1
M2 net0 INP net5 VSS nch l=0.15 w=1 nf=1 m=1
M3 INN VB1 VDD VDD pch l=0.15 w=1 nf=1 m=1
M4 net0 VB1 VDD VDD pch l=0.15 w=1 nf=1 m=1
M5 net4 VB2 INN VDD pch l=0.15 w=1 nf=1 m=1
M6 OUT VB2 net0 VDD pch l=0.15 w=1 nf=1 m=1
M7 net5 VB4 VSS VSS nch l=0.15 w=1 nf=1 m=1
M8 net4 VB5 net3 VSS nch l=0.15 w=1 nf=1 m=1
M9 OUT VB5 net1 VSS nch l=0.15 w=1 nf=1 m=1
.ends opamp

.subckt dut VDD VSS Vout
Q1 VSS VSS net4 qpnp m=1
Q2 net4 net4 net2 qpnp m=1
Q3 VSS VSS net0 qpnp m=1
Q4 net0 net0 net3 qpnp m=1
R1 Vout net2 1k
R2 Vout net1 1k
R3 net1 net3 1k
X1 VDD VSS net1 net2 Vout opamp
.ends dut
