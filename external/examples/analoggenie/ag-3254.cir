* official Analog Canvas netlist; PDK X cards rewritten by convert.py
.model nch nmos
.model pch pmos

.subckt dut VDD VSS vci phi1 phi2 vco
C1 net8 net2 1p
C2 net6 vco 1p
M1 vci phi1 net8 VSS nch l=0.15 w=1 nf=1 m=1
M10 vco net1 VDD VDD pch l=0.15 w=1 nf=1 m=1
M11 net5 net5 VSS VSS nch l=0.15 w=1 nf=1 m=1
M12 vco net5 VSS VSS nch l=0.15 w=1 nf=1 m=1
M13 net7 VB2 VSS VSS nch l=0.15 w=1 nf=1 m=1
M14 net0 net3 VDD VDD pch l=0.15 w=1 nf=1 m=1
M15 net3 net3 net0 VDD pch l=0.15 w=1 nf=1 m=1
M16 net0 net0 VSS VSS nch l=0.15 w=1 nf=1 m=1
M17 VB1 net0 VSS VSS nch l=0.15 w=1 nf=1 m=1
M18 VB1 VB1 VDD VDD pch l=0.15 w=1 nf=1 m=1
M19 VB2 VB1 VDD VDD pch l=0.15 w=1 nf=1 m=1
M2 net8 phi2 VSS VSS nch l=0.15 w=1 nf=1 m=1
M20 VB2 VB2 VSS VSS nch l=0.15 w=1 nf=1 m=1
M3 net2 phi1 VSS VSS nch l=0.15 w=1 nf=1 m=1
M4 net2 phi2 net6 VSS nch l=0.15 w=1 nf=1 m=1
M5 net4 net6 net7 VSS nch l=0.15 w=1 nf=1 m=1
M6 net1 VSS net7 VSS nch l=0.15 w=1 nf=1 m=1
M7 net4 net4 VDD VDD pch l=0.15 w=1 nf=1 m=1
M8 net1 net1 VDD VDD pch l=0.15 w=1 nf=1 m=1
M9 net5 net4 VDD VDD pch l=0.15 w=1 nf=1 m=1
R1 VDD net0 1k
R2 net3 VSS 1k
.ends dut
