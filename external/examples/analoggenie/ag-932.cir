* official Analog Canvas netlist; PDK X cards rewritten by convert.py
.model nch nmos
.model pch pmos

.subckt dut VDD VSS Vi1 Vi2 Vo1 Vo2 VCM
IDC net6 net2 DC 100uA
M1 net8 Vi1 net0 VSS nch l=0.15 w=1 nf=1 m=1
M11 net6 net6 VDD VDD pch l=0.15 w=1 nf=1 m=1
M12 net3 net6 VDD VDD pch l=0.15 w=1 nf=1 m=1
M13 net3 net3 net0 VSS nch l=0.15 w=1 nf=1 m=1
M14 net2 net2 VSS VSS nch l=0.15 w=1 nf=1 m=1
M1C Vo1 net3 net8 VSS nch l=0.15 w=1 nf=1 m=1
M2 net4 Vi2 net0 VSS nch l=0.15 w=1 nf=1 m=1
M21 VSS Vo2 net1 VDD pch l=0.15 w=1 nf=1 m=1
M22 net5 VCM net1 VDD pch l=0.15 w=1 nf=1 m=1
M23 net5 VCM net7 VDD pch l=0.15 w=1 nf=1 m=1
M24 VSS Vo1 net7 VDD pch l=0.15 w=1 nf=1 m=1
M25 net5 net5 VSS VSS nch l=0.15 w=1 nf=1 m=1
M26 net1 net6 VDD VDD pch l=0.15 w=1 nf=1 m=1
M27 net7 net6 VDD VDD pch l=0.15 w=1 nf=1 m=1
M2C Vo2 net3 net4 VSS nch l=0.15 w=1 nf=1 m=1
M3 Vo1 net6 VDD VDD pch l=0.15 w=1 nf=1 m=1
M4 Vo2 net6 VDD VDD pch l=0.15 w=1 nf=1 m=1
M51 net0 net2 VSS VSS nch l=0.15 w=1 nf=1 m=1
M52 net0 net5 VSS VSS nch l=0.15 w=1 nf=1 m=1
.ends dut
