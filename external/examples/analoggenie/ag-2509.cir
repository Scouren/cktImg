* official Analog Canvas netlist; PDK X cards rewritten by convert.py
.model nch nmos
.model pch pmos

.subckt dut VDD VSS VREF VB4 VB3 VB2 VOUT VIN VB1
CF1 VOUT VFB 1p
Cm1 VOUT V1 1p
Cm2 V1 net5 1p
M11 net1 VBN VSS VSS nch l=0.15 w=1 nf=1 m=1
M12 V3 VFB net1 VSS nch l=0.15 w=1 nf=1 m=1
M13 V2 VREF net1 VSS nch l=0.15 w=1 nf=1 m=1
M14 V3 V3 VIN VDD pch l=0.15 w=1 nf=1 m=1
M15 V2 V2 VIN VDD pch l=0.15 w=1 nf=1 m=1
M16 V2 VB4 VIN VDD pch l=0.15 w=1 nf=1 m=1
M17 V2 V2 VSS VSS nch l=0.15 w=1 nf=1 m=1
M18 V2 V1 VSS VSS nch l=0.15 w=1 nf=1 m=1
M21 net2 V1 VSS VSS nch l=0.15 w=1 nf=1 m=1
M22 net6 V2 VSS VSS nch l=0.15 w=1 nf=1 m=1
M23 net2 net2 VIN VDD pch l=0.15 w=1 nf=1 m=1
M24 net6 net2 VIN VDD pch l=0.15 w=1 nf=1 m=1
M25 V1 V3 VIN VDD pch l=0.15 w=1 nf=1 m=1
M26 net0 V2 VIN VDD pch l=0.15 w=1 nf=1 m=1
M27 V1 net0 VSS VSS nch l=0.15 w=1 nf=1 m=1
M28 net0 net0 VSS VSS nch l=0.15 w=1 nf=1 m=1
M29 VBN net3 VIN VDD pch l=0.15 w=1 nf=1 m=1
M30 net3 net3 VIN VDD pch l=0.15 w=1 nf=1 m=1
M31 net4 net3 VIN VDD pch l=0.15 w=1 nf=1 m=1
M32 VBN VBN VSS VSS nch l=0.15 w=1 nf=1 m=1
M33 net3 net4 VB1 VSS nch l=0.15 w=1 nf=1 m=1
M34 net4 VB1 VSS VSS nch l=0.15 w=1 nf=1 m=1
MD1 net5 V1 VSS VSS nch l=0.15 w=1 nf=1 m=1
MD2 net7 VB2 VSS VSS nch l=0.15 w=1 nf=1 m=1
MD3 net8 net5 net7 VSS nch l=0.15 w=1 nf=1 m=1
MD4 V3 VB3 net7 VSS nch l=0.15 w=1 nf=1 m=1
MD5 net5 V3 VIN VDD pch l=0.15 w=1 nf=1 m=1
MD6 net8 net8 VIN VDD pch l=0.15 w=1 nf=1 m=1
MD7 V3 V3 VIN VDD pch l=0.15 w=1 nf=1 m=1
MPT VOUT net6 VIN VDD pch l=0.15 w=1 nf=1 m=1
R1 VB1 VSS 1k
RF1 VOUT VFB 1k
RF2 VFB VSS 1k
.ends dut
