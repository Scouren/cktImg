* official Analog Canvas netlist; PDK X cards rewritten by convert.py
.model qnpn npn

.subckt dut VDD VSS
I1 VDD net0 DC 50uA
Q1 net0 net0 net2 VSS qnpn m=1
Q2 VDD net0 net1 VSS qnpn m=1
R1 net2 VSS 6kΩ
R2 net1 VSS 6kΩ
.ends dut
