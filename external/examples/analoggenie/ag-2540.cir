* official Analog Canvas netlist; PDK X cards rewritten by convert.py
.model nch nmos
.model pch pmos

.subckt dut VDD VSS VREF VIN VB3 VB5 VB4 VB1 VB2 VOUT
CF1 VOUT VFB 1p
Cm1 VOUT V1 1p
Cm2 V1 net6 1p
M11 net3 VBN VSS VSS nch l=0.15 w=1 nf=1 m=1
M12 V3 VFB net3 VSS nch l=0.15 w=1 nf=1 m=1
M13 V2 VREF net3 VSS nch l=0.15 w=1 nf=1 m=1
M14 V3 V3 VIN VDD pch l=0.15 w=1 nf=1 m=1
M15 V2 V2 VIN VDD pch l=0.15 w=1 nf=1 m=1
M16 V1 V3 VIN VDD pch l=0.15 w=1 nf=1 m=1
M17 net4 V2 VIN VDD pch l=0.15 w=1 nf=1 m=1
M18 net4 net4 VSS VSS nch l=0.15 w=1 nf=1 m=1
M19 V1 net4 VSS VSS nch l=0.15 w=1 nf=1 m=1
M21 net1 V1 VSS VSS nch l=0.15 w=1 nf=1 m=1
M22 net2 V2 VSS VSS nch l=0.15 w=1 nf=1 m=1
M23 net1 net1 VIN VDD pch l=0.15 w=1 nf=1 m=1
M24 net2 net1 VIN VDD pch l=0.15 w=1 nf=1 m=1
M25 V2 VB4 VIN VDD pch l=0.15 w=1 nf=1 m=1
M26 V2 V1 VSS VSS nch l=0.15 w=1 nf=1 m=1
M27 V2 V2 VSS VSS nch l=0.15 w=1 nf=1 m=1
MB1 VB1 VB1 VIN VDD pch l=0.15 w=1 nf=1 m=1
MB2 VB1 VBN VSS VSS nch l=0.15 w=1 nf=1 m=1
MB3 VBN VBN VSS VSS nch l=0.15 w=1 nf=1 m=1
MB4 VBN net0 VIN VDD pch l=0.15 w=1 nf=1 m=1
MB5 net0 net0 VIN VDD pch l=0.15 w=1 nf=1 m=1
MB6 net8 net0 VIN VDD pch l=0.15 w=1 nf=1 m=1
MB7 net0 net8 VB2 VSS nch l=0.15 w=1 nf=1 m=1
MB8 net8 VB2 VSS VSS nch l=0.15 w=1 nf=1 m=1
MD1 net6 V1 VSS VSS nch l=0.15 w=1 nf=1 m=1
MD2 net7 VB5 VSS VSS nch l=0.15 w=1 nf=1 m=1
MD3 net5 net6 net7 VSS nch l=0.15 w=1 nf=1 m=1
MD4 V3 VB3 net7 VSS nch l=0.15 w=1 nf=1 m=1
MD5 net6 V3 VIN VDD pch l=0.15 w=1 nf=1 m=1
MD6 net5 net5 VIN VDD pch l=0.15 w=1 nf=1 m=1
MD7 V3 V3 VIN VDD pch l=0.15 w=1 nf=1 m=1
MPT VOUT net2 VIN VDD pch l=0.15 w=1 nf=1 m=1
RB VB2 VSS 1k
RF1 VOUT VFB 1k
RF2 VFB VSS 1k
.ends dut
