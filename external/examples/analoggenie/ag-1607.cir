* official Analog Canvas netlist; PDK X cards rewritten by convert.py
.model nch nmos
.model pch pmos
.model qpnp pnp

.subckt opamp VDD VSS INP INN OUT
M1 net1 net1 VDD VDD pch l=0.15 w=1 nf=1 m=1
M10 net2 INN net4 VSS nch l=0.15 w=1 nf=1 m=1
M11 net3 net3 VDD VDD pch l=0.15 w=1 nf=1 m=1
M12 net5 net3 VDD VDD pch l=0.15 w=1 nf=1 m=1
M13 net5 net5 VSS VSS nch l=0.15 w=1 nf=1 m=1
M2 net2 net2 VDD VDD pch l=0.15 w=1 nf=1 m=1
M3 net1 INP net4 VSS nch l=0.15 w=1 nf=1 m=1
M4 net4 net5 VSS VSS nch l=0.15 w=1 nf=1 m=1
M5 OUT net1 VDD VDD pch l=0.15 w=1 nf=1 m=1
M6 net0 net2 VDD VDD pch l=0.15 w=1 nf=1 m=1
M7 OUT net0 VSS VSS nch l=0.15 w=1 nf=1 m=1
M8 net0 net0 VSS VSS nch l=0.15 w=1 nf=1 m=1
R4 net3 VSS 1k
.ends opamp

.subckt dut VDD VSS Vout
Q1 VSS VSS X qpnp m=1
Q2 VSS VSS net0 qpnp m=1
R1 Vout X 1k
R2 Vout Y 1k
R3 Y net0 1k
X1 VDD VSS X Y Vout opamp
.ends dut
