* official Analog Canvas netlist; PDK X cards rewritten by convert.py
.model nch nmos
.model pch pmos

.subckt dut VDD VSS Vout1 Vout2 Vb VCMFB
I1 net1 VSS DC 1m
I2 net0 VSS DC 1m
M1 VDD Vout1 net1 VSS nch l=0.15 w=1 nf=1 m=1
M2 VCMFB Vb net1 VSS nch l=0.15 w=1 nf=1 m=1
M3 VDD Vout2 net0 VSS nch l=0.15 w=1 nf=1 m=1
M4 VCMFB Vb net0 VSS nch l=0.15 w=1 nf=1 m=1
M5 VCMFB VCMFB VDD VDD pch l=0.15 w=1 nf=1 m=1
.ends dut
