* official Analog Canvas netlist; PDK X cards rewritten by convert.py
.model nch nmos

.subckt dut VDD VSS X
I1 VDD net0 DC 1m
M0 X Vb A VSS nch l=0.15 w=1 nf=1 m=1
M1 A X VSS VSS nch l=0.15 w=1 nf=1 m=1
M5 net1 net1 VSS VSS nch l=0.15 w=1 nf=1 m=1
M6 Vb net0 net1 VSS nch l=0.15 w=1 nf=1 m=1
Rb net0 Vb 1k
.ends dut
