* official Analog Canvas netlist; PDK X cards rewritten by convert.py
.model nch nmos
.model pch pmos
.model qpnp pnp

.subckt dut VDD VSS IB1
M10 net3 net7 net9 VDD pch l=0.15 w=1 nf=1 m=1
M11 net7 net7 net2 VDD pch l=0.15 w=1 nf=1 m=1
M12 IB1 net7 net1 VDD pch l=0.15 w=1 nf=1 m=1
M3 net0 net0 net4 VSS nch l=0.15 w=1 nf=1 m=1
M4 net8 net0 net5 VSS nch l=0.15 w=1 nf=1 m=1
M5 net9 net2 VDD VDD pch l=0.15 w=1 nf=1 m=1
M6 net2 net2 VDD VDD pch l=0.15 w=1 nf=1 m=1
M7 net1 net2 VDD VDD pch l=0.15 w=1 nf=1 m=1
M8 net3 net3 net0 VSS nch l=0.15 w=1 nf=1 m=1
M9 net7 net3 net8 VSS nch l=0.15 w=1 nf=1 m=1
Q1 VSS VSS net4 qpnp m=1
Q2 VSS VSS net6 qpnp m=1
R net5 net6 1k
.ends dut
