* official Analog Canvas netlist; PDK X cards rewritten by convert.py
.model nch nmos
.model pch pmos

.subckt dut VDD VSS VB1 VREF VB3 VB2 VB6 VB7 VIN VB5 VOUT
CF1 VOUT VFB 1p
Cm1 VOUT V1 1p
Cm2 V1 net3 1p
M11 net8 VB1 VIN VDD pch l=0.15 w=1 nf=1 m=1
M12 net4 VFB net8 VDD pch l=0.15 w=1 nf=1 m=1
M13 net0 VREF net8 VDD pch l=0.15 w=1 nf=1 m=1
M14 net4 VB2 VSS VSS nch l=0.15 w=1 nf=1 m=1
M15 net0 VB2 VSS VSS nch l=0.15 w=1 nf=1 m=1
M16 VY VX VIN VDD pch l=0.15 w=1 nf=1 m=1
M17 VX VBN net4 VSS nch l=0.15 w=1 nf=1 m=1
M18 V1 VBN net0 VSS nch l=0.15 w=1 nf=1 m=1
M19 net9 VX VIN VDD pch l=0.15 w=1 nf=1 m=1
M20 VX VB3 VY VDD pch l=0.15 w=1 nf=1 m=1
M21 net2 V1 VSS VSS nch l=0.15 w=1 nf=1 m=1
M22 net5 V2 VSS VSS nch l=0.15 w=1 nf=1 m=1
M23 net2 net2 VIN VDD pch l=0.15 w=1 nf=1 m=1
M24 net5 net2 VIN VDD pch l=0.15 w=1 nf=1 m=1
M25 V1 VB3 net9 VDD pch l=0.15 w=1 nf=1 m=1
M26 VB4 net7 VIN VDD pch l=0.15 w=1 nf=1 m=1
M27 VB4 VB4 VSS VSS nch l=0.15 w=1 nf=1 m=1
M28 net7 net7 VIN VDD pch l=0.15 w=1 nf=1 m=1
M29 net7 VB4 VSS VSS nch l=0.15 w=1 nf=1 m=1
M30 VBN net7 VIN VDD pch l=0.15 w=1 nf=1 m=1
M31 VBN VBN net6 VSS nch l=0.15 w=1 nf=1 m=1
M32 net6 VBN VSS VSS nch l=0.15 w=1 nf=1 m=1
MD1 net3 V1 VSS VSS nch l=0.15 w=1 nf=1 m=1
MD10 V2 V1 VSS VSS nch l=0.15 w=1 nf=1 m=1
MD2 VY VB6 VSS VSS nch l=0.15 w=1 nf=1 m=1
MD3 net1 net3 VY VSS nch l=0.15 w=1 nf=1 m=1
MD4 net10 VB7 VY VSS nch l=0.15 w=1 nf=1 m=1
MD5 net3 net10 VIN VDD pch l=0.15 w=1 nf=1 m=1
MD6 net10 net10 VIN VDD pch l=0.15 w=1 nf=1 m=1
MD7 net1 net1 VIN VDD pch l=0.15 w=1 nf=1 m=1
MD8 V2 VB5 VIN VDD pch l=0.15 w=1 nf=1 m=1
MD9 V2 V2 VSS VSS nch l=0.15 w=1 nf=1 m=1
MPT VOUT net5 VIN VDD pch l=0.15 w=1 nf=1 m=1
RF1 VOUT VFB 1k
RF2 VFB VSS 1k
.ends dut
