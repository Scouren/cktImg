* official Analog Canvas netlist; PDK X cards rewritten by convert.py
.model nch nmos
.model pch pmos

.subckt dut VDD VSS VREF VB1 VB4 VB2 VIN VBP1 VBP2 VOUT
CF1 VOUT VFB 1p
Cm1 VOUT VO1 1p
Cm2 VO1 net9 1p
M11 net5 VBN VSS VSS nch l=0.15 w=1 nf=1 m=1
M12 VX VFB net5 VSS nch l=0.15 w=1 nf=1 m=1
M13 VY VREF net5 VSS nch l=0.15 w=1 nf=1 m=1
M14 net1 net1 VSS VSS nch l=0.15 w=1 nf=1 m=1
M15 VO1 net1 VSS VSS nch l=0.15 w=1 nf=1 m=1
M16 VY VB1 VIN VDD pch l=0.15 w=1 nf=1 m=1
M17 VY VO1 VSS VSS nch l=0.15 w=1 nf=1 m=1
M18 VY VY VSS VSS nch l=0.15 w=1 nf=1 m=1
M19 VX VX VIN VDD pch l=0.15 w=1 nf=1 m=1
M20 VY VY VIN VDD pch l=0.15 w=1 nf=1 m=1
M21 net6 VO1 VSS VSS nch l=0.15 w=1 nf=1 m=1
M22 net0 VY VSS VSS nch l=0.15 w=1 nf=1 m=1
M23 net6 net6 VIN VDD pch l=0.15 w=1 nf=1 m=1
M24 net0 net6 VIN VDD pch l=0.15 w=1 nf=1 m=1
M25 VO1 VX VIN VDD pch l=0.15 w=1 nf=1 m=1
M26 net1 VY VIN VDD pch l=0.15 w=1 nf=1 m=1
M27 VBP2 VBP2 VIN VDD pch l=0.15 w=1 nf=1 m=1
M28 net3 VBP2 VIN VDD pch l=0.15 w=1 nf=1 m=1
M29 VBP2 net3 VSS VSS nch l=0.15 w=1 nf=1 m=1
M30 net2 net3 VSS VSS nch l=0.15 w=1 nf=1 m=1
M31 net4 net4 VIN VDD pch l=0.15 w=1 nf=1 m=1
M32 VBN net4 VIN VDD pch l=0.15 w=1 nf=1 m=1
M33 net4 net3 VSS VSS nch l=0.15 w=1 nf=1 m=1
M34 VBN VBN VSS VSS nch l=0.15 w=1 nf=1 m=1
M35 VBP1 VBP1 VIN VDD pch l=0.15 w=1 nf=1 m=1
M36 VBP1 VBN VSS VSS nch l=0.15 w=1 nf=1 m=1
MD1 net9 VO1 VSS VSS nch l=0.15 w=1 nf=1 m=1
MD2 net7 VB2 VSS VSS nch l=0.15 w=1 nf=1 m=1
MD3 net8 net9 net7 VSS nch l=0.15 w=1 nf=1 m=1
MD4 VX VB4 net7 VSS nch l=0.15 w=1 nf=1 m=1
MD5 net9 VX VIN VDD pch l=0.15 w=1 nf=1 m=1
MD6 VX VX VIN VDD pch l=0.15 w=1 nf=1 m=1
MD7 net8 net8 VIN VDD pch l=0.15 w=1 nf=1 m=1
MPT VOUT net0 VIN VDD pch l=0.15 w=1 nf=1 m=1
R1 net3 net2 1k
RF1 VOUT VFB 1k
RF2 VFB VSS 1k
.ends dut
