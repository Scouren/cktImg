* official Analog Canvas netlist; PDK X cards rewritten by convert.py
.model nch nmos
.model pch pmos

.subckt EA VDD VSS INN INP VX OUT
MN1 net2 INN net4 VSS nch l=0.15 w=1 nf=1 m=1
MN2 VX INP net4 VSS nch l=0.15 w=1 nf=1 m=1
MN3 net1 net1 VSS VSS nch l=0.15 w=1 nf=1 m=1
MN4 OUT net1 VSS VSS nch l=0.15 w=1 nf=1 m=1
MN5 net4 VBN VSS VSS nch l=0.15 w=1 nf=1 m=1
MN6 VBN VBN VSS VSS nch l=0.15 w=1 nf=1 m=1
MN7 net0 net3 VB2 VSS nch l=0.15 w=1 nf=1 m=1
MN8 net3 VB2 VSS VSS nch l=0.15 w=1 nf=1 m=1
MN9 VB1 VBN VSS VSS nch l=0.15 w=1 nf=1 m=1
MP1 net2 net2 VDD VDD pch l=0.15 w=1 nf=1 m=1
MP2 VX VX VDD VDD pch l=0.15 w=1 nf=1 m=1
MP3 net1 net2 VDD VDD pch l=0.15 w=1 nf=1 m=1
MP4 OUT VX VDD VDD pch l=0.15 w=1 nf=1 m=1
MP5 VBN net0 VDD VDD pch l=0.15 w=1 nf=1 m=1
MP6 net0 net0 VDD VDD pch l=0.15 w=1 nf=1 m=1
MP7 net3 net0 VDD VDD pch l=0.15 w=1 nf=1 m=1
MP8 VB1 VB1 VDD VDD pch l=0.15 w=1 nf=1 m=1
RBIAS VB2 VSS 1k
.ends EA

.subckt dut VDD VSS VIN VCONT1 VCONT2 VCONT3 VB3 VCONT5 VCONT4 VP VREF
.model DIODE D(IS=1e-14 N=1)
CFLY VX1 VX2 1p
CO VP VN 1p
COP VP VSS 1p
D1 VN VX2 DIODE
L1 VX1 VX3 1n
M1 net2 VCONT1 VIN VDD pch l=0.15 w=1 nf=1 m=1
M2 VX1 VCONT2 VIN VDD pch l=0.15 w=1 nf=1 m=1
M3 VX2 VCONT3 VIN VDD pch l=0.15 w=1 nf=1 m=1
M4 VX3 VCONT4 VSS VSS nch l=0.15 w=1 nf=1 m=1
M5 VX3 VCONT5 VP VDD pch l=0.15 w=1 nf=1 m=1
MN10 net1 net1 VSS VSS nch l=0.15 w=1 nf=1 m=1
MN11 net0 net1 VSS VSS nch l=0.15 w=1 nf=1 m=1
MN12 net1 VB3 VSS VSS nch l=0.15 w=1 nf=1 m=1
MP10 net0 net0 net2 VDD pch l=0.15 w=1 nf=1 m=1
MP11 VX1 net0 net2 VDD pch l=0.15 w=1 nf=1 m=1
MP9 net1 VCTRL net2 VDD pch l=0.15 w=1 nf=1 m=1
R1 VP VFP1 1k
R2 VFP1 VSS 1k
X1 VDD VSS VFP1 VREF VX3 VCTRL EA
.ends dut
