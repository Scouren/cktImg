* official Analog Canvas netlist; PDK X cards rewritten by convert.py
.model nch nmos
.model pch pmos

.subckt dut VDD VSS Vout1 Vout2 Vin1 Vin2
I1 net1 VSS DC 1m
I2 net0 VSS DC 1m
ISS net2 VSS DC 1m
M1 Vout1 Vin1 net2 VSS nch l=0.15 w=1 nf=1 m=1
M2 Vout2 Vin2 net2 VSS nch l=0.15 w=1 nf=1 m=1
M3 Vout1 net1 VDD VDD pch l=0.15 w=1 nf=1 m=1
M4 Vout2 net0 VDD VDD pch l=0.15 w=1 nf=1 m=1
M5 VDD Vout1 net1 VSS nch l=0.15 w=1 nf=1 m=1
M6 VDD Vout2 net0 VSS nch l=0.15 w=1 nf=1 m=1
.ends dut
