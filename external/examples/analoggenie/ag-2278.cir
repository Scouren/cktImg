* official Analog Canvas netlist; PDK X cards rewritten by convert.py
.model nch nmos
.model pch pmos

.subckt dut VDD VSS VB1 VB2 VREF VB4 IBUF VB3 VIN FB VOUT
CL VOUT net3 1p
M1 net4 net8 VDD VDD pch l=0.15 w=1 nf=1 m=1
M10 EAO VBN net11 VSS nch l=0.15 w=1 nf=1 m=1
M11 net13 VX VSS VSS nch l=0.15 w=1 nf=1 m=1
M12 net11 VX VSS VSS nch l=0.15 w=1 nf=1 m=1
M13 VT VB4 VDD VDD pch l=0.15 w=1 nf=1 m=1
M14 net2 EAO VT VDD pch l=0.15 w=1 nf=1 m=1
M15 net2 net2 VSS VSS nch l=0.15 w=1 nf=1 m=1
M16 GATE net2 VSS VSS nch l=0.15 w=1 nf=1 m=1
M17 VDD VT GATE VSS nch l=0.15 w=1 nf=1 m=1
M18 net7 EAO IBUF VSS nch l=0.15 w=1 nf=1 m=1
M19 net7 net7 VDD VDD pch l=0.15 w=1 nf=1 m=1
M2 net0 net9 VDD VDD pch l=0.15 w=1 nf=1 m=1
M20 GATE net7 VDD VDD pch l=0.15 w=1 nf=1 m=1
M21 VSS IBUF GATE VDD pch l=0.15 w=1 nf=1 m=1
M22 net8 VB1 net4 VDD pch l=0.15 w=1 nf=1 m=1
M23 net9 VB1 net0 VDD pch l=0.15 w=1 nf=1 m=1
M24 VT VB2 VSS VSS nch l=0.15 w=1 nf=1 m=1
M25 net6 VBP VDD VDD pch l=0.15 w=1 nf=1 m=1
M26 net6 net6 VSS VSS nch l=0.15 w=1 nf=1 m=1
M27 VBP VBP VDD VDD pch l=0.15 w=1 nf=1 m=1
M28 VBP VB3 net12 VSS nch l=0.15 w=1 nf=1 m=1
M29 net12 net6 VSS VSS nch l=0.15 w=1 nf=1 m=1
M3 net9 VREF VT VSS nch l=0.15 w=1 nf=1 m=1
M30 VB3 VBP VDD VDD pch l=0.15 w=1 nf=1 m=1
M31 VB3 VB3 VSS VSS nch l=0.15 w=1 nf=1 m=1
M32 VBN VBP VDD VDD pch l=0.15 w=1 nf=1 m=1
M33 VBN VBN net10 VSS nch l=0.15 w=1 nf=1 m=1
M34 net10 VBN VSS VSS nch l=0.15 w=1 nf=1 m=1
M4 net8 FB VT VSS nch l=0.15 w=1 nf=1 m=1
M5 net5 net8 VDD VDD pch l=0.15 w=1 nf=1 m=1
M6 net1 net9 VDD VDD pch l=0.15 w=1 nf=1 m=1
M7 VX VB1 net5 VDD pch l=0.15 w=1 nf=1 m=1
M8 EAO VB1 net1 VDD pch l=0.15 w=1 nf=1 m=1
M9 VX VBN net13 VSS nch l=0.15 w=1 nf=1 m=1
MNP VIN GATE VOUT VSS nch l=0.15 w=1 nf=1 m=1
R1 FB VSS 1k
R2 VOUT FB 1k
R3 net3 VSS 1k
R4 VOUT VSS 1k
.ends dut
