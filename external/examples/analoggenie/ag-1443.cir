* official Analog Canvas netlist; PDK X cards rewritten by convert.py
.model nch nmos
.model pch pmos

.subckt dut VDD VSS VSTO VCONT1 VCONT2 VCONT3 VOUT VB1
C1 VSTO VSS 1p
C2 VOUT VSS 1p
L1 net4 VX 1n
M1 net4 VCONT1 VSTO VDD pch l=0.15 w=1 nf=1 m=1
M10 VG VG net1 VSS nch l=0.15 w=1 nf=1 m=1
M11 net1 VBN VSS VSS nch l=0.15 w=1 nf=1 m=1
M12 VG VG VDD VDD pch l=0.15 w=1 nf=1 m=1
M13 VG VY VSS VSS nch l=0.15 w=1 nf=1 m=1
M14 net3 net0 VDD VDD pch l=0.15 w=1 nf=1 m=1
M15 net3 VB2 VSS VSS nch l=0.15 w=1 nf=1 m=1
M16 net0 net0 VDD VDD pch l=0.15 w=1 nf=1 m=1
M17 net0 net3 VB2 VSS nch l=0.15 w=1 nf=1 m=1
M18 VBN net0 VDD VDD pch l=0.15 w=1 nf=1 m=1
M19 VBN VBN VSS VSS nch l=0.15 w=1 nf=1 m=1
M2 net4 VCONT2 VSS VSS nch l=0.15 w=1 nf=1 m=1
M20 VB1 VB1 VDD VDD pch l=0.15 w=1 nf=1 m=1
M21 VB1 VBN VSS VSS nch l=0.15 w=1 nf=1 m=1
M3 VX VCONT3 VSS VSS nch l=0.15 w=1 nf=1 m=1
M4 VX VG VOUT VDD pch l=0.15 w=1 nf=1 m=1
M5 VY net2 VDD VDD pch l=0.15 w=1 nf=1 m=1
M6 VY VY VSS VSS nch l=0.15 w=1 nf=1 m=1
M7 net2 net2 VDD VDD pch l=0.15 w=1 nf=1 m=1
M8 net2 VX net1 VSS nch l=0.15 w=1 nf=1 m=1
M9 VG VG VDD VDD pch l=0.15 w=1 nf=1 m=1
R1 VB2 VSS 1k
.ends dut
