* official Analog Canvas netlist; PDK X cards rewritten by convert.py
.model nch nmos
.model pch pmos

.subckt dut VDD VSS VIN VC5 VC1 VC2 VC4 VC3 VP VB2 VREF
.model DIODE D(IS=1e-14 N=1)
CFLY VX1 VX2 1p
CO VP VN 1p
COP VP VSS 1p
D1 VN VX2 DIODE
L1 VX1 VX3 1n
M1 VX1 VC1 VIN VDD pch l=0.15 w=1 nf=1 m=1
M2 VX2 VC2 VIN VDD pch l=0.15 w=1 nf=1 m=1
M3 VP VC3 VX3 VDD pch l=0.15 w=1 nf=1 m=1
M4 VX3 VC4 VSS VSS nch l=0.15 w=1 nf=1 m=1
M5 net3 VC5 VIN VDD pch l=0.15 w=1 nf=1 m=1
MN1 net6 VFP1 net7 VSS nch l=0.15 w=1 nf=1 m=1
MN10 VB3 VB3 VSS VSS nch l=0.15 w=1 nf=1 m=1
MN11 net5 VB2 VSS VSS nch l=0.15 w=1 nf=1 m=1
MN2 VX3 VREF net7 VSS nch l=0.15 w=1 nf=1 m=1
MN3 net8 net8 VSS VSS nch l=0.15 w=1 nf=1 m=1
MN4 net7 VB3 VSS VSS nch l=0.15 w=1 nf=1 m=1
MN5 VCTRL net8 VSS VSS nch l=0.15 w=1 nf=1 m=1
MN6 net5 net5 VSS VSS nch l=0.15 w=1 nf=1 m=1
MN7 net0 net5 VSS VSS nch l=0.15 w=1 nf=1 m=1
MN8 net2 net1 VSS VSS nch l=0.15 w=1 nf=1 m=1
MN9 net1 net1 net4 VSS nch l=0.15 w=1 nf=1 m=1
MP1 net8 net6 VDD VDD pch l=0.15 w=1 nf=1 m=1
MP2 net6 net6 VDD VDD pch l=0.15 w=1 nf=1 m=1
MP3 VX3 VX3 VDD VDD pch l=0.15 w=1 nf=1 m=1
MP4 net0 net0 net3 VDD pch l=0.15 w=1 nf=1 m=1
MP5 VX1 net0 net3 VDD pch l=0.15 w=1 nf=1 m=1
MP6 VCTRL VX3 VDD VDD pch l=0.15 w=1 nf=1 m=1
MP7 net2 net2 VDD VDD pch l=0.15 w=1 nf=1 m=1
MP8 VB3 net2 VDD VDD pch l=0.15 w=1 nf=1 m=1
MP9 net5 VCTRL net3 VDD pch l=0.15 w=1 nf=1 m=1
R1 VP VFP1 1k
R2 VFP1 VSS 1k
R4 net4 VSS 1k
RBIAS VDD net1 1k
.ends dut
