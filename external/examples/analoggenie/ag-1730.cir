* official Analog Canvas netlist; PDK X cards rewritten by convert.py
.model nch nmos
.model pch pmos
.model qpnp pnp

.subckt ota VDD VSS - + OUT
M1 net1 + net3 VSS nch l=0.15 w=1 nf=1 m=1
M10 net4 net2 VDD VDD pch l=0.15 w=1 nf=1 m=1
M11 net4 net4 VSS VSS nch l=0.15 w=1 nf=1 m=1
M12 OUT net4 VSS VSS nch l=0.15 w=1 nf=1 m=1
M13 VB3 VB3 VDD VDD pch l=0.15 w=1 nf=1 m=1
M14 net0 VB3 VDD VDD pch l=0.15 w=1 nf=1 m=1
M15 VB4 VB3 VDD VDD pch l=0.15 w=1 nf=1 m=1
M16 VB1 VB1 VDD VDD pch l=0.15 w=1 nf=1 m=1
M17 VB3 net0 VB2 VSS nch l=0.15 w=1 nf=1 m=1
M18 net0 VB2 VSS VSS nch l=0.15 w=1 nf=1 m=1
M19 VB4 VB4 VSS VSS nch l=0.15 w=1 nf=1 m=1
M2 net2 - net3 VSS nch l=0.15 w=1 nf=1 m=1
M20 VB1 VB4 VSS VSS nch l=0.15 w=1 nf=1 m=1
M3 net1 net1 VDD VDD pch l=0.15 w=1 nf=1 m=1
M4 net2 net2 VDD VDD pch l=0.15 w=1 nf=1 m=1
M5 net3 VB4 VSS VSS nch l=0.15 w=1 nf=1 m=1
M9 OUT net1 VDD VDD pch l=0.15 w=1 nf=1 m=1
R4 VB2 VSS 1k
.ends ota

.subckt dut VDD VSS Vout
Q1 VSS VSS net1 qpnp m=1
Q2 net1 net1 Y qpnp m=1
Q3 VSS VSS net0 qpnp m=1
Q4 net0 net0 net2 qpnp m=1
R1 Vout Y 1k
R2 Vout X 1k
R3 X net2 1k
X1 VDD VSS X Y Vout ota
.ends dut
