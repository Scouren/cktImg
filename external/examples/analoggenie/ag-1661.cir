* official Analog Canvas netlist; PDK X cards rewritten by convert.py
.model nch nmos
.model pch pmos
.model qpnp pnp

.subckt opamp VDD VSS VB1 VB2 INP INN OUT
M1 INP INP net4 VSS nch l=0.15 w=1 nf=1 m=1
M10 net1 net5 VSS VSS nch l=0.15 w=1 nf=1 m=1
M11 net2 net5 VSS VSS nch l=0.15 w=1 nf=1 m=1
M12 net0 net0 VDD VDD pch l=0.15 w=1 nf=1 m=1
M13 VB3 net0 VDD VDD pch l=0.15 w=1 nf=1 m=1
M14 VB3 VB3 VB4 VSS nch l=0.15 w=1 nf=1 m=1
M15 VB4 VB4 VSS VSS nch l=0.15 w=1 nf=1 m=1
M2 net3 INN net4 VSS nch l=0.15 w=1 nf=1 m=1
M3 net4 VB4 VSS VSS nch l=0.15 w=1 nf=1 m=1
M4 INP VB1 VDD VDD pch l=0.15 w=1 nf=1 m=1
M5 net3 VB1 VDD VDD pch l=0.15 w=1 nf=1 m=1
M6 net5 VB2 INP VDD pch l=0.15 w=1 nf=1 m=1
M7 OUT VB2 net3 VDD pch l=0.15 w=1 nf=1 m=1
M8 net5 VB3 net1 VSS nch l=0.15 w=1 nf=1 m=1
M9 OUT VB3 net2 VSS nch l=0.15 w=1 nf=1 m=1
RB net0 VSS 1k
.ends opamp

.subckt dut VDD VSS Vout VB1 VB2
Q1 VSS VSS net0 qpnp m=1
Q2 net0 net0 net3 qpnp m=1
Q3 VSS VSS net2 qpnp m=1
Q4 net2 net2 net1 qpnp m=1
R1 Vout net4 1k
R2 Vout net1 1k
R3 net4 net3 1k
X1 VDD VSS VB1 VB2 net4 net1 Vout opamp
.ends dut
