* official Analog Canvas netlist; PDK X cards rewritten by convert.py
.model nch nmos

.subckt dut VSS VG Vx
M5 Vx VG VSS VSS nch l=0.15 w=1 nf=1 m=1
M6 VG VG Vx VSS nch l=0.15 w=1 nf=1 m=1
.ends dut
