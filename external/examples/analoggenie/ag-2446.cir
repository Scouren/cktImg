* official Analog Canvas netlist; PDK X cards rewritten by convert.py
.model nch nmos
.model pch pmos

.subckt dut VDD VSS VIN VOUT VERR nb pb VREF VB1 VB2
M1 net5 net4 VIN VDD pch l=0.15 w=1 nf=1 m=1
M10 net4 net4 VSS VSS nch l=0.15 w=1 nf=1 m=1
M11 net1 net4 net7 VSS nch l=0.15 w=1 nf=1 m=1
M12 net7 VBN VSS VSS nch l=0.15 w=1 nf=1 m=1
M13 VB1 VB1 VDD VDD pch l=0.15 w=1 nf=1 m=1
M14 VB1 VBN VSS VSS nch l=0.15 w=1 nf=1 m=1
M15 VBN net0 VDD VDD pch l=0.15 w=1 nf=1 m=1
M16 VBN VBN VSS VSS nch l=0.15 w=1 nf=1 m=1
M17 net0 net0 VDD VDD pch l=0.15 w=1 nf=1 m=1
M18 net0 VB2 VSS VSS nch l=0.15 w=1 nf=1 m=1
M19 VB2 net0 VDD VDD pch l=0.15 w=1 nf=1 m=1
M2 net8 net8 net5 VDD pch l=0.15 w=1 nf=1 m=1
M20 VB2 VB2 VSS VSS nch l=0.15 w=1 nf=1 m=1
M3 net8 nb VSS VSS nch l=0.15 w=1 nf=1 m=1
M4 net3 net3 VDD VDD pch l=0.15 w=1 nf=1 m=1
M5 net4 net3 VDD VDD pch l=0.15 w=1 nf=1 m=1
M6 net4 net1 VDD VDD pch l=0.15 w=1 nf=1 m=1
M7 net1 net1 VDD VDD pch l=0.15 w=1 nf=1 m=1
M8 net3 VREF net7 VSS nch l=0.15 w=1 nf=1 m=1
M9 net4 net4 VSS VSS nch l=0.15 w=1 nf=1 m=1
MBIAS VERR nb VSS VSS nch l=0.15 w=1 nf=1 m=1
MCHG net6 pb VIN VDD pch l=0.15 w=1 nf=1 m=1
MCTRL VERR net8 VOUT VDD pch l=0.15 w=1 nf=1 m=1
MGEN net2 net2 VSS VSS nch l=0.15 w=1 nf=1 m=1
MINJ VERR net2 VSS VSS nch l=0.15 w=1 nf=1 m=1
MRES VOUT VERR VIN VDD pch l=0.15 w=1 nf=1 m=1
MSEN net2 net4 net6 VDD pch l=0.15 w=1 nf=1 m=1
.ends dut
