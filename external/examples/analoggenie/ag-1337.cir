* official Analog Canvas netlist; PDK X cards rewritten by convert.py
.model nch nmos
.model pch pmos

.subckt dut VDD VSS VIN VCONT1 VB3 VCONT2 VCONT3 VCONT5 VCONT4 VP VREF VB2 VB1
.model DIODE D(IS=1e-14 N=1)
C1 VX1 VX2 1p
C2 VP VN 1p
C3 VP VSS 1p
D1 VN VX2 DIODE
L1 VX1 VX3 1n
M1 net7 net7 VDD VDD pch l=0.15 w=1 nf=1 m=1
M10 VB2 net1 VDD VDD pch l=0.15 w=1 nf=1 m=1
M11 VB2 VB2 VSS VSS nch l=0.15 w=1 nf=1 m=1
M12 net1 net1 VDD VDD pch l=0.15 w=1 nf=1 m=1
M13 net1 VB2 VX2 VSS nch l=0.15 w=1 nf=1 m=1
M14 net0 net1 VDD VDD pch l=0.15 w=1 nf=1 m=1
M15 net0 net0 VSS VSS nch l=0.15 w=1 nf=1 m=1
M16 VB4 VB4 VDD VDD pch l=0.15 w=1 nf=1 m=1
M17 net5 VCONT1 VIN VIN pch l=0.15 w=1 nf=1 m=1
M18 VX1 net6 net5 net5 pch l=0.15 w=1 nf=1 m=1
M19 net6 net6 net5 net5 pch l=0.15 w=1 nf=1 m=1
M2 VCTRL net7 VDD VDD pch l=0.15 w=1 nf=1 m=1
M20 net4 VCTRL net5 net5 pch l=0.15 w=1 nf=1 m=1
M21 net6 net4 VSS VSS nch l=0.15 w=1 nf=1 m=1
M22 net4 net4 VSS VSS nch l=0.15 w=1 nf=1 m=1
M23 net4 VB3 VSS VSS nch l=0.15 w=1 nf=1 m=1
M24 VX1 VCONT2 VIN VIN pch l=0.15 w=1 nf=1 m=1
M25 VX2 VCONT3 VIN VIN pch l=0.15 w=1 nf=1 m=1
M26 VP VCONT5 VX3 VP pch l=0.15 w=1 nf=1 m=1
M27 VX3 VCONT4 VSS VSS nch l=0.15 w=1 nf=1 m=1
M28 VB4 net0 VSS VSS nch l=0.15 w=1 nf=1 m=1
M29 VB1 VB4 VDD VDD pch l=0.15 w=1 nf=1 m=1
M3 net8 VB4 VDD VDD pch l=0.15 w=1 nf=1 m=1
M30 VB1 VB1 VSS VSS nch l=0.15 w=1 nf=1 m=1
M4 net2 VFP1 net8 net3 pch l=0.15 w=1 nf=1 m=1
M5 VX2 VREF net8 net3 pch l=0.15 w=1 nf=1 m=1
M6 net7 VX2 VSS VSS nch l=0.15 w=1 nf=1 m=1
M7 VCTRL net2 VSS VSS nch l=0.15 w=1 nf=1 m=1
M8 net2 net2 VSS VSS nch l=0.15 w=1 nf=1 m=1
M9 VX2 VX2 VSS VSS nch l=0.15 w=1 nf=1 m=1
R1 VP VFP1 1k
R2 VFP1 VSS 1k
R3 VX2 VSS 1k
.ends dut
