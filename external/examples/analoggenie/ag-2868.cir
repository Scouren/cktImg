* official Analog Canvas netlist; PDK X cards rewritten by convert.py
.model nch nmos
.model pch pmos

.subckt dut VDD VSS VB1 VB2 vci phi1 phi2 vco
C1 vcx VSS 1p
C2 net2 vco 1p
M1 vci phi1 vcx VSS nch l=0.15 w=1 nf=1 m=1
M10 VB1 VB1 VDD VDD pch l=0.15 w=1 nf=1 m=1
M11 VB1 VB3 VSS VSS nch l=0.15 w=1 nf=1 m=1
M12 VB3 net0 VDD VDD pch l=0.15 w=1 nf=1 m=1
M13 VB3 VB3 VSS VSS nch l=0.15 w=1 nf=1 m=1
M14 net0 net0 VDD VDD pch l=0.15 w=1 nf=1 m=1
M15 net0 VB2 net6 VSS nch l=0.15 w=1 nf=1 m=1
M16 VB2 net0 VDD VDD pch l=0.15 w=1 nf=1 m=1
M17 VB2 VB2 VSS VSS nch l=0.15 w=1 nf=1 m=1
M2 vcx phi2 net2 VSS nch l=0.15 w=1 nf=1 m=1
M3 vcx net2 net5 VSS nch l=0.15 w=1 nf=1 m=1
M4 vco VSS net5 VSS nch l=0.15 w=1 nf=1 m=1
M5 net5 VB3 VSS VSS nch l=0.15 w=1 nf=1 m=1
M6 net4 vcx VDD VDD pch l=0.15 w=1 nf=1 m=1
M7 net1 vcx VDD VDD pch l=0.15 w=1 nf=1 m=1
M8 vcx net3 net4 VDD pch l=0.15 w=1 nf=1 m=1
M9 vco net3 net1 VDD pch l=0.15 w=1 nf=1 m=1
R1 net6 VSS 1k
.ends dut
