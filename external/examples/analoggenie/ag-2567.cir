* official Analog Canvas netlist; PDK X cards rewritten by convert.py
.model nch nmos
.model pch pmos

.subckt AMP1 VDD VSS VB1 VB2 INN INP OUT n3 n1
M1 net2 VB1 VDD VDD pch l=0.15 w=1 nf=1 m=1
M10 net4 INP net3 VSS nch l=0.15 w=1 nf=1 m=1
M11 net3 VT VSS VSS nch l=0.15 w=1 nf=1 m=1
M12 net1 VP VDD VDD pch l=0.15 w=1 nf=1 m=1
M13 VP VP VDD VDD pch l=0.15 w=1 nf=1 m=1
M14 VB4 VP VDD VDD pch l=0.15 w=1 nf=1 m=1
M15 VC VP VDD VDD pch l=0.15 w=1 nf=1 m=1
M16 VP VB4 VB3 VSS nch l=0.15 w=1 nf=1 m=1
M17 VC VC VT VSS nch l=0.15 w=1 nf=1 m=1
M18 net1 net1 VSS VSS nch l=0.15 w=1 nf=1 m=1
M19 VB3 net1 VSS VSS nch l=0.15 w=1 nf=1 m=1
M2 net4 VB1 VDD VDD pch l=0.15 w=1 nf=1 m=1
M20 VB4 VB3 VSS VSS nch l=0.15 w=1 nf=1 m=1
M21 VT VT VSS VSS nch l=0.15 w=1 nf=1 m=1
M3 n3 VB2 net2 VDD pch l=0.15 w=1 nf=1 m=1
M4 OUT VB2 net4 VDD pch l=0.15 w=1 nf=1 m=1
M5 n3 VC net0 VSS nch l=0.15 w=1 nf=1 m=1
M6 OUT VC n1 VSS nch l=0.15 w=1 nf=1 m=1
M7 net0 n3 VSS VSS nch l=0.15 w=1 nf=1 m=1
M8 n1 n3 VSS VSS nch l=0.15 w=1 nf=1 m=1
M9 net2 INN net3 VSS nch l=0.15 w=1 nf=1 m=1
.ends AMP1

.subckt dut VDD VSS Vref Vout VB1 VB2 biasp biascas biasn
C1 Vset VSS 1p
C2 n3 Vout 1p
M1 Vout n3 VDD VDD pch l=0.15 w=1 nf=1 m=1
M2 n1 Vset Vout VDD pch l=0.15 w=1 nf=1 m=1
M3 n1 biasn VSS VSS nch l=0.15 w=1 nf=1 m=1
M4 n3 biasp VDD VDD pch l=0.15 w=1 nf=1 m=1
M5 n3 biascas n1 VSS nch l=0.15 w=1 nf=1 m=1
R1 fb VSS 1k
R2 Vout fb 1k
X1 VDD VSS VB1 VB2 fb Vref Vset n3 n1 AMP1
.ends dut
