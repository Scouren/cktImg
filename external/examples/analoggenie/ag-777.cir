* official Analog Canvas netlist; PDK X cards rewritten by convert.py
.model nch nmos

.subckt dut VSS VB v1 i1 i2
M1 net0 v1 VSS VSS nch l=0.15 w=1 nf=1 m=1
M2 i2 net0 VSS VSS nch l=0.15 w=1 nf=1 m=1
M3 i1 VB net0 VSS nch l=0.15 w=1 nf=1 m=1
.ends dut
