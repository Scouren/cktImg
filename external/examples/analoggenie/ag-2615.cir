* official Analog Canvas netlist; PDK X cards rewritten by convert.py
.model nch nmos
.model pch pmos

.subckt dut VDD VSS Vref VB1 biasp biascas biasn Vout
C1 Vset VSS 1p
C2 n3 Vout 1p
M1 Vout n3 VDD VDD pch l=0.15 w=1 nf=1 m=1
M10 fb Vref net1 VSS nch l=0.15 w=1 nf=1 m=1
M11 net3 fb net1 VSS nch l=0.15 w=1 nf=1 m=1
M12 net1 VY VSS VSS nch l=0.15 w=1 nf=1 m=1
M13 VX VX VSS VSS nch l=0.15 w=1 nf=1 m=1
M14 Vset VX VSS VSS nch l=0.15 w=1 nf=1 m=1
M15 VB1 VB1 VDD VDD pch l=0.15 w=1 nf=1 m=1
M16 VB1 VY VSS VSS nch l=0.15 w=1 nf=1 m=1
M17 VY net0 VDD VDD pch l=0.15 w=1 nf=1 m=1
M18 VY VY VSS VSS nch l=0.15 w=1 nf=1 m=1
M19 net0 net0 VDD VDD pch l=0.15 w=1 nf=1 m=1
M2 n1 Vset Vout VDD pch l=0.15 w=1 nf=1 m=1
M20 net0 net2 VSS VSS nch l=0.15 w=1 nf=1 m=1
M21 net2 VX VDD VDD pch l=0.15 w=1 nf=1 m=1
M22 net2 net2 VSS VSS nch l=0.15 w=1 nf=1 m=1
M23 VX VX VDD VDD pch l=0.15 w=1 nf=1 m=1
M24 VX net2 VSS VSS nch l=0.15 w=1 nf=1 m=1
M3 n1 biasn VSS VSS nch l=0.15 w=1 nf=1 m=1
M4 n3 biasp VDD VDD pch l=0.15 w=1 nf=1 m=1
M5 n3 biascas n1 VSS nch l=0.15 w=1 nf=1 m=1
M6 fb fb VDD VDD pch l=0.15 w=1 nf=1 m=1
M7 net3 net3 VDD VDD pch l=0.15 w=1 nf=1 m=1
M8 VX net3 VDD VDD pch l=0.15 w=1 nf=1 m=1
M9 Vset fb VDD VDD pch l=0.15 w=1 nf=1 m=1
R1 fb VSS 1k
R2 Vout fb 1k
R3 VDD net2 1k
.ends dut
