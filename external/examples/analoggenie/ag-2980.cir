* official Analog Canvas netlist; PDK X cards rewritten by convert.py
.model nch nmos
.model pch pmos

.subckt dut VDD VSS vci phi1 phi2 vco
C1 net0 VSS 1p
C2 net6 vco 1p
C3 net3 vco 1p
M1 vci phi1 net0 VSS nch l=0.15 w=1 nf=1 m=1
M10 VB5 VB5 VDD VDD pch l=0.15 w=1 nf=1 m=1
M11 VB3 VB5 VDD VDD pch l=0.15 w=1 nf=1 m=1
M12 VB5 VB3 VB2 VSS nch l=0.15 w=1 nf=1 m=1
M13 VB3 VB2 VSS VSS nch l=0.15 w=1 nf=1 m=1
M14 net1 VB5 VDD VDD pch l=0.15 w=1 nf=1 m=1
M15 net1 net1 VSS VSS nch l=0.15 w=1 nf=1 m=1
M16 VB2 net1 VSS VSS nch l=0.15 w=1 nf=1 m=1
M17 net2 VB5 VDD VDD pch l=0.15 w=1 nf=1 m=1
M18 net2 net2 VSS VSS nch l=0.15 w=1 nf=1 m=1
M19 VB1 net2 VSS VSS nch l=0.15 w=1 nf=1 m=1
M2 net0 phi2 net6 VSS nch l=0.15 w=1 nf=1 m=1
M20 VB1 VB1 VDD VDD pch l=0.15 w=1 nf=1 m=1
M21 VB4 VB1 VDD VDD pch l=0.15 w=1 nf=1 m=1
M22 VB4 VB4 VSS VSS nch l=0.15 w=1 nf=1 m=1
M3 net4 net6 net5 VSS nch l=0.15 w=1 nf=1 m=1
M4 net4 net4 VDD VDD pch l=0.15 w=1 nf=1 m=1
M5 net3 net4 VDD VDD pch l=0.15 w=1 nf=1 m=1
M6 net3 VSS net5 VSS nch l=0.15 w=1 nf=1 m=1
M7 net5 VB4 VSS VSS nch l=0.15 w=1 nf=1 m=1
M8 vco net3 VDD VDD pch l=0.15 w=1 nf=1 m=1
M9 vco VB4 VSS VSS nch l=0.15 w=1 nf=1 m=1
.ends dut
