* official Analog Canvas netlist; PDK X cards rewritten by convert.py
.model nch nmos
.model pch pmos

.subckt EA VDD VSS INN INP VCTRL VX2 VB1
M1 VCTRL net3 VDD VDD pch l=0.15 w=1 nf=1 m=1
M10 VBP VBP VDD VDD pch l=0.15 w=1 nf=1 m=1
M11 VBP VB1 VSS VSS nch l=0.15 w=1 nf=1 m=1
M12 VB1 VB1 VSS VSS nch l=0.15 w=1 nf=1 m=1
M13 VB1 net0 VDD VDD pch l=0.15 w=1 nf=1 m=1
M14 net0 net0 net1 VDD pch l=0.15 w=1 nf=1 m=1
M2 VCTRL net2 VSS VSS nch l=0.15 w=1 nf=1 m=1
M3 net2 INN net4 VDD pch l=0.15 w=1 nf=1 m=1
M4 net2 net2 VSS VSS nch l=0.15 w=1 nf=1 m=1
M5 net4 VBP VDD VDD pch l=0.15 w=1 nf=1 m=1
M6 VX2 INP net4 VDD pch l=0.15 w=1 nf=1 m=1
M7 VX2 VX2 VSS VSS nch l=0.15 w=1 nf=1 m=1
M8 net3 net3 VDD VDD pch l=0.15 w=1 nf=1 m=1
M9 net3 VX2 VSS VSS nch l=0.15 w=1 nf=1 m=1
R1 VDD net1 1k
R2 net0 VSS 1k
.ends EA

.subckt ISR VDD VSS VCTRL VB2 VS IOUT
M10 net0 net0 VS VDD pch l=0.15 w=1 nf=1 m=1
M11 IOUT net0 VS VDD pch l=0.15 w=1 nf=1 m=1
M6 net1 VB2 VSS VSS nch l=0.15 w=1 nf=1 m=1
M7 net1 net1 VSS VSS nch l=0.15 w=1 nf=1 m=1
M8 net0 net1 VSS VSS nch l=0.15 w=1 nf=1 m=1
M9 net1 VCTRL VS VDD pch l=0.15 w=1 nf=1 m=1
.ends ISR

.subckt dut VDD VSS VCONT1 VCONT2 VCONT3 VCONT4 VCONT5 VP VREF VB2 VB1 VIN
.model DIODE D(IS=1e-14 N=1)
CFLY VX1 VX2 1p
CO VP VN 1p
COP VP VSS 1p
D1 VN VX2 DIODE
L1 VX1 VX3 1n
M1 VIN VCONT1 net1 VDD pch l=0.15 w=1 nf=1 m=1
M2 VX1 VCONT2 VIN VDD pch l=0.15 w=1 nf=1 m=1
M3 VIN VCONT3 VX2 VDD pch l=0.15 w=1 nf=1 m=1
M4 VX3 VCONT4 VSS VSS nch l=0.15 w=1 nf=1 m=1
M5 VP VCONT5 VX3 VDD pch l=0.15 w=1 nf=1 m=1
R1 VP VFP1 1k
R2 VFP1 VSS 1k
X1 VDD VSS net0 VB2 net1 VX1 ISR
X2 VDD VSS VFP1 VREF net0 VX2 VB1 EA
.ends dut
