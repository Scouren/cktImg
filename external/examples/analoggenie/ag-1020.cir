* official Analog Canvas netlist; PDK X cards rewritten by convert.py
.model nch nmos
.model pch pmos

.subckt dut VDD VSS VB2 Vicm VB1
I1 VDD net3 DC 1m
I2 net1 VSS DC 1m
M1 net3 net2 VDD VDD pch l=0.15 w=1 nf=1 m=3
M2 net2 net2 VDD VDD pch l=0.15 w=1 nf=1 m=1
M3 net0 net0 VSS VSS nch l=0.15 w=1 nf=1 m=1
M4 net1 net0 VSS VSS nch l=0.15 w=1 nf=1 m=3
MB1 net2 VB1 net1 VSS nch l=0.15 w=1 nf=1 m=1
MB2 net0 VB2 net3 VDD pch l=0.15 w=1 nf=1 m=1
MN1 NC0004 Vicm net1 VSS nch l=0.15 w=1 nf=1 m=1
MN2 NC0003 Vicm net1 VSS nch l=0.15 w=1 nf=1 m=1
MP1 NC0001 Vicm net3 VDD pch l=0.15 w=1 nf=1 m=1
MP2 NC0002 Vicm net3 VDD pch l=0.15 w=1 nf=1 m=1
.ends dut
