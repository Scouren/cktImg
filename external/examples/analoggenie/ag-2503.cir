* official Analog Canvas netlist; PDK X cards rewritten by convert.py
.model nch nmos
.model pch pmos

.subckt dut VDD VSS VB1 VREF VB3 VB2 VB7 VB6 VIN VB5 VOUT
CF1 VOUT VFB 1p
Cm1 VO1 VOUT 1p
Cm2 VO1 VA 1p
M11 net8 VB1 VIN VDD pch l=0.15 w=1 nf=1 m=1
M12 net7 VFB net8 VDD pch l=0.15 w=1 nf=1 m=1
M13 net4 VREF net8 VDD pch l=0.15 w=1 nf=1 m=1
M16 VG VB5 VIN VDD pch l=0.15 w=1 nf=1 m=1
M17 VG VO1 VSS VSS nch l=0.15 w=1 nf=1 m=1
M18 VG VG VSS VSS nch l=0.15 w=1 nf=1 m=1
M21 net1 VO1 VSS VSS nch l=0.15 w=1 nf=1 m=1
M22 net5 VG VSS VSS nch l=0.15 w=1 nf=1 m=1
M23 net1 net1 VIN VDD pch l=0.15 w=1 nf=1 m=1
M24 net5 net1 VIN VDD pch l=0.15 w=1 nf=1 m=1
M31 VY VX VIN VDD pch l=0.15 w=1 nf=1 m=1
M32 VX VB3 VY VDD pch l=0.15 w=1 nf=1 m=1
M33 VX VC net7 VSS nch l=0.15 w=1 nf=1 m=1
M34 net7 VB2 VSS VSS nch l=0.15 w=1 nf=1 m=1
M35 net6 VX VIN VDD pch l=0.15 w=1 nf=1 m=1
M36 VO1 VB3 net6 VDD pch l=0.15 w=1 nf=1 m=1
M37 VO1 VC net4 VSS nch l=0.15 w=1 nf=1 m=1
M38 net4 VB2 VSS VSS nch l=0.15 w=1 nf=1 m=1
M39 net0 VP VIN VDD pch l=0.15 w=1 nf=1 m=1
M40 net0 net0 VSS VSS nch l=0.15 w=1 nf=1 m=1
M41 VP VP VIN VDD pch l=0.15 w=1 nf=1 m=1
M42 VP VB4 net2 VSS nch l=0.15 w=1 nf=1 m=1
M43 net2 net0 VSS VSS nch l=0.15 w=1 nf=1 m=1
M44 VB4 VP VIN VDD pch l=0.15 w=1 nf=1 m=1
M45 VB4 VB4 VSS VSS nch l=0.15 w=1 nf=1 m=1
M46 VC VP VIN VDD pch l=0.15 w=1 nf=1 m=1
M47 VC VC net10 VSS nch l=0.15 w=1 nf=1 m=1
M48 net10 VC VSS VSS nch l=0.15 w=1 nf=1 m=1
MD1 VA VO1 VSS VSS nch l=0.15 w=1 nf=1 m=1
MD2 VY VB6 VSS VSS nch l=0.15 w=1 nf=1 m=1
MD3 net9 VA VY VSS nch l=0.15 w=1 nf=1 m=1
MD4 net3 VB7 VY VSS nch l=0.15 w=1 nf=1 m=1
MD5 VA net3 VIN VDD pch l=0.15 w=1 nf=1 m=1
MD6 net3 net3 VIN VDD pch l=0.15 w=1 nf=1 m=1
MD7 net9 net9 VIN VDD pch l=0.15 w=1 nf=1 m=1
MPT VOUT net5 VIN VDD pch l=0.15 w=1 nf=1 m=1
RF1 VOUT VFB 1k
RF2 VFB VSS 1k
.ends dut
