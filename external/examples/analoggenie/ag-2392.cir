* official Analog Canvas netlist; PDK X cards rewritten by convert.py
.model nch nmos
.model pch pmos

.subckt dut VDD VSS VB1 VB3 VB2 VIN VOUT VERR
M1 net7 VEA VIN VDD pch l=0.15 w=1 nf=1 m=1
M10 VX VC net1 VSS nch l=0.15 w=1 nf=1 m=1
M11 net1 VX VSS VSS nch l=0.15 w=1 nf=1 m=1
M12 net4 VREF net5 VSS nch l=0.15 w=1 nf=1 m=1
M13 net2 VEA net5 VSS nch l=0.15 w=1 nf=1 m=1
M14 net5 VB2 VSS VSS nch l=0.15 w=1 nf=1 m=1
M15 VC VY VDD VDD pch l=0.15 w=1 nf=1 m=1
M16 VC VC VEA VSS nch l=0.15 w=1 nf=1 m=1
M17 VEA VC VSS VSS nch l=0.15 w=1 nf=1 m=1
M18 VY VY VDD VDD pch l=0.15 w=1 nf=1 m=1
M19 VX VY VDD VDD pch l=0.15 w=1 nf=1 m=1
M2 VX VX net7 VDD pch l=0.15 w=1 nf=1 m=1
M20 VY VX net6 VSS nch l=0.15 w=1 nf=1 m=1
M21 VX net6 VSS VSS nch l=0.15 w=1 nf=1 m=1
M3 VX nb VSS VSS nch l=0.15 w=1 nf=1 m=1
M4 net4 VB1 VDD VDD pch l=0.15 w=1 nf=1 m=1
M5 VEA VB3 net4 VDD pch l=0.15 w=1 nf=1 m=1
M6 VEA VC net0 VSS nch l=0.15 w=1 nf=1 m=1
M7 net0 VX VSS VSS nch l=0.15 w=1 nf=1 m=1
M8 net2 VB1 VDD VDD pch l=0.15 w=1 nf=1 m=1
M9 VX VB3 net2 VDD pch l=0.15 w=1 nf=1 m=1
MBIAS VERR nb VSS VSS nch l=0.15 w=1 nf=1 m=1
MCHG net3 pb VIN VDD pch l=0.15 w=1 nf=1 m=1
MCTRL VERR VX VOUT VDD pch l=0.15 w=1 nf=1 m=1
MGEN net8 net8 VSS VSS nch l=0.15 w=1 nf=1 m=1
MINJ VERR net8 VSS VSS nch l=0.15 w=1 nf=1 m=1
MRES VOUT VERR VIN VDD pch l=0.15 w=1 nf=1 m=1
MSEN net8 VEA net3 VDD pch l=0.15 w=1 nf=1 m=1
R1 net6 VSS 1k
.ends dut
