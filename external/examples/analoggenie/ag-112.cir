* official Analog Canvas netlist; PDK X cards rewritten by convert.py
.model nch nmos

.subckt dut VDD VSS Vb
I6 VDD net0 DC 1m
M5 net1 net1 VSS VSS nch l=0.15 w=1 nf=1 m=1
M6 Vb net0 net1 VSS nch l=0.15 w=1 nf=1 m=1
R6 net0 Vb 1k
.ends dut
