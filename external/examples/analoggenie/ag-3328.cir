* official Analog Canvas netlist; PDK X cards rewritten by convert.py
.model nch nmos
.model pch pmos

.subckt dut VDD VSS vci phi1 phi2 vco
C1 net5 net3 1p
C2 net7 vco 1p
M1 vci phi1 net3 VSS nch l=0.15 w=1 nf=1 m=1
M10 net4 net4 VDD VDD pch l=0.15 w=1 nf=1 m=1
M11 net4 VB1 VSS VSS nch l=0.15 w=1 nf=1 m=1
M12 net0 net0 VDD VDD pch l=0.15 w=1 nf=1 m=1
M13 net2 net0 VDD VDD pch l=0.15 w=1 nf=1 m=1
M14 net0 net2 VSS VSS nch l=0.15 w=1 nf=1 m=1
M15 net2 net2 VSS VSS nch l=0.15 w=1 nf=1 m=1
M16 net1 net2 VSS VSS nch l=0.15 w=1 nf=1 m=1
M17 net1 net1 VDD VDD pch l=0.15 w=1 nf=1 m=1
M18 VB1 net1 VDD VDD pch l=0.15 w=1 nf=1 m=1
M19 VB1 VB1 VSS VSS nch l=0.15 w=1 nf=1 m=1
M2 net3 phi2 VSS VSS nch l=0.15 w=1 nf=1 m=1
M3 net5 phi1 VSS VSS nch l=0.15 w=1 nf=1 m=1
M4 net5 phi2 net7 VSS nch l=0.15 w=1 nf=1 m=1
M5 net4 net7 net6 VSS nch l=0.15 w=1 nf=1 m=1
M6 vco VSS net6 VSS nch l=0.15 w=1 nf=1 m=1
M7 net6 VB1 VSS VSS nch l=0.15 w=1 nf=1 m=1
M8 net4 net4 VDD VDD pch l=0.15 w=1 nf=1 m=1
M9 vco net4 VDD VDD pch l=0.15 w=1 nf=1 m=1
R1 VDD net2 1k
.ends dut
