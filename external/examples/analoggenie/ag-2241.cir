* official Analog Canvas netlist; PDK X cards rewritten by convert.py
.model nch nmos
.model pch pmos

.subckt Opamp VDD VSS INN INP OUT VX VB1
M1 VX INN net3 VSS nch l=0.15 w=1 nf=1 m=1
M10 OUT net4 VSS VSS nch l=0.15 w=1 nf=1 m=1
M11 VB2 VB2 VSS VSS nch l=0.15 w=1 nf=1 m=1
M12 VB3 VB3 VDD VDD pch l=0.15 w=1 nf=1 m=1
M13 net2 VB3 VDD VDD pch l=0.15 w=1 nf=1 m=1
M14 VB3 net1 VSS VSS nch l=0.15 w=1 nf=1 m=1
M15 net2 net2 net1 VSS nch l=0.15 w=1 nf=1 m=1
M16 net1 net2 net5 VSS nch l=0.15 w=1 nf=1 m=1
M17 net6 VB3 VDD VDD pch l=0.15 w=1 nf=1 m=1
M18 net6 net6 net5 VSS nch l=0.15 w=1 nf=1 m=1
M19 net5 net6 VB1 VSS nch l=0.15 w=1 nf=1 m=1
M2 net0 INP net3 VSS nch l=0.15 w=1 nf=1 m=1
M20 VB1 VB1 VSS VSS nch l=0.15 w=1 nf=1 m=1
M21 VB1 VB3 VDD VDD pch l=0.15 w=1 nf=1 m=1
M3 VX VX VDD VDD pch l=0.15 w=1 nf=1 m=1
M4 net0 net0 VDD VDD pch l=0.15 w=1 nf=1 m=1
M5 net3 VB2 VSS VSS nch l=0.15 w=1 nf=1 m=1
M6 VB2 VB3 VDD VDD pch l=0.15 w=1 nf=1 m=1
M7 net4 VX VDD VDD pch l=0.15 w=1 nf=1 m=1
M8 OUT net0 VDD VDD pch l=0.15 w=1 nf=1 m=1
M9 net4 net4 VSS VSS nch l=0.15 w=1 nf=1 m=1
.ends Opamp

.subckt dut VDD VSS Vref VIN VOUT VB1
CL VOUT VX 1p
MNP VIN net0 VOUT VOUT nch l=0.15 w=1 nf=1 m=1
R1 VOUT FB 1k
R2 FB VSS 1k
R3 VX VSS 1k
X1 VDD VSS FB Vref net0 VX VB1 Opamp
.ends dut
