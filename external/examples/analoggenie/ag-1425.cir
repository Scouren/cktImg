* official Analog Canvas netlist; PDK X cards rewritten by convert.py
.model nch nmos
.model pch pmos

.subckt comparator VDD VSS IN OUT
M1 VB3 VB1 VDD VDD pch l=0.15 w=1 nf=1 m=1
M10 net1 VB2 VDD VDD pch l=0.15 w=1 nf=1 m=1
M11 net1 net1 VSS VSS nch l=0.15 w=1 nf=1 m=1
M12 OUT OUT VDD VDD pch l=0.15 w=1 nf=1 m=1
M13 OUT OUT VDD VDD pch l=0.15 w=1 nf=1 m=1
M14 OUT OUT net5 VSS nch l=0.15 w=1 nf=1 m=1
M15 net5 VB3 VSS VSS nch l=0.15 w=1 nf=1 m=1
M16 net4 net4 VDD VDD pch l=0.15 w=1 nf=1 m=1
M17 net4 IN net5 VSS nch l=0.15 w=1 nf=1 m=1
M18 net0 net4 VDD VDD pch l=0.15 w=1 nf=1 m=1
M19 net0 net0 VSS VSS nch l=0.15 w=1 nf=1 m=1
M2 VB3 VB3 VSS VSS nch l=0.15 w=1 nf=1 m=1
M20 OUT net0 VSS VSS nch l=0.15 w=1 nf=1 m=1
M3 VB1 VB1 VDD VDD pch l=0.15 w=1 nf=1 m=1
M4 VB1 net2 VSS VSS nch l=0.15 w=1 nf=1 m=1
M5 net2 VB2 VDD VDD pch l=0.15 w=1 nf=1 m=1
M6 net2 net2 VSS VSS nch l=0.15 w=1 nf=1 m=1
M7 VB2 VB2 VDD VDD pch l=0.15 w=1 nf=1 m=1
M8 VB2 net2 net3 VSS nch l=0.15 w=1 nf=1 m=1
M9 net3 net1 VSS VSS nch l=0.15 w=1 nf=1 m=1
.ends comparator

.subckt dut VDD VSS VSTO VCONT1 VCONT2 VCONT3 VOUT
CL VOUT VSS 1p
CSTO VSTO VSS 1p
LRX net2 net1 1n
MN1 net2 VCONT2 VSS VSS nch l=0.15 w=1 nf=1 m=1
MN2 net1 VCONT3 VSS VSS nch l=0.15 w=1 nf=1 m=1
MP2 net1 net0 VOUT VDD pch l=0.15 w=1 nf=1 m=1
MP3 net2 VCONT1 VSTO VDD pch l=0.15 w=1 nf=1 m=1
X1 VDD VSS net1 net0 comparator
.ends dut
