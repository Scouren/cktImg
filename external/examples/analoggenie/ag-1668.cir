* official Analog Canvas netlist; PDK X cards rewritten by convert.py
.model nch nmos
.model pch pmos
.model qpnp pnp

.subckt dut VDD VSS Vout
M1 net0 net0 net3 VSS nch l=0.15 w=1 nf=1 m=1
M10 net4 net1 VSS VSS nch l=0.15 w=1 nf=1 m=1
M11 net5 net1 VSS VSS nch l=0.15 w=1 nf=1 m=1
M12 VB4 net2 VDD VDD pch l=0.15 w=1 nf=1 m=1
M13 net2 net2 VDD VDD pch l=0.15 w=1 nf=1 m=1
M14 VB4 VB4 VSS VSS nch l=0.15 w=1 nf=1 m=1
M15 net2 VB4 VSS VSS nch l=0.15 w=1 nf=1 m=1
M16 VB5 net2 VDD VDD pch l=0.15 w=1 nf=1 m=1
M17 VB5 VB5 net9 VSS nch l=0.15 w=1 nf=1 m=1
M18 net9 VB5 VSS VSS nch l=0.15 w=1 nf=1 m=1
M2 net7 X net3 VSS nch l=0.15 w=1 nf=1 m=1
M3 net3 VB2 VSS VSS nch l=0.15 w=1 nf=1 m=1
M4 net0 VB1 VDD VDD pch l=0.15 w=1 nf=1 m=1
M5 net7 VB1 VDD VDD pch l=0.15 w=1 nf=1 m=1
M6 net1 VB3 net0 VDD pch l=0.15 w=1 nf=1 m=1
M7 Vout VB3 net7 VDD pch l=0.15 w=1 nf=1 m=1
M8 net1 VB5 net4 VSS nch l=0.15 w=1 nf=1 m=1
M9 Vout VB5 net5 VSS nch l=0.15 w=1 nf=1 m=1
Q1 VSS VSS net6 qpnp m=1
Q2 net6 net6 X qpnp m=1
Q3 VSS VSS net10 qpnp m=1
Q4 net10 net10 net8 qpnp m=1
R1 Vout X 1k
R2 Vout net0 1k
R3 net0 net8 1k
.ends dut
