* official Analog Canvas netlist; PDK X cards rewritten by convert.py
.model nch nmos
.model pch pmos

.subckt EA VDD VSS VREF VFP1 VCTRL VX2
MN1 VX2 VX2 VSS VSS nch l=0.15 w=1 nf=1 m=1
MN2 net4 VX2 VSS VSS nch l=0.15 w=1 nf=1 m=1
MN3 net1 net1 VSS VSS nch l=0.15 w=1 nf=1 m=1
MN4 VCTRL net1 VSS VSS nch l=0.15 w=1 nf=1 m=1
MN5 VBP net6 VSS VSS nch l=0.15 w=1 nf=1 m=1
MN6 net6 net6 VSS VSS nch l=0.15 w=1 nf=1 m=1
MN7 net2 net5 VSS VSS nch l=0.15 w=1 nf=1 m=1
MN8 net7 net5 VSS VSS nch l=0.15 w=1 nf=1 m=1
MP1 net4 net4 VDD VDD pch l=0.15 w=1 nf=1 m=1
MP2 VCTRL net4 VDD VDD pch l=0.15 w=1 nf=1 m=1
MP3 net3 VBP VDD VDD pch l=0.15 w=1 nf=1 m=1
MP4 VX2 VREF net3 net0 pch l=0.15 w=1 nf=1 m=1
MP5 net1 VFP1 net3 net0 pch l=0.15 w=1 nf=1 m=1
MP6 VBP VBP VDD VDD pch l=0.15 w=1 nf=1 m=1
MP7 net6 net2 VDD VDD pch l=0.15 w=1 nf=1 m=1
MP8 net2 net2 VDD VDD pch l=0.15 w=1 nf=1 m=1
MP9 net5 net2 VDD VDD pch l=0.15 w=1 nf=1 m=1
RBIAS net5 net7 1k
.ends EA

.subckt ISR VSS VS VC VB3 IOUT
MN1 net0 net0 VSS VSS nch l=0.15 w=1 nf=1 m=1
MN2 net1 net0 VSS VSS nch l=0.15 w=1 nf=1 m=1
MN3 net0 VB3 VSS VSS nch l=0.15 w=1 nf=1 m=1
MP1 net0 VC VS VS pch l=0.15 w=1 nf=1 m=1
MP2 net1 net1 VS VS pch l=0.15 w=1 nf=1 m=1
MP3 IOUT net1 VS VS pch l=0.15 w=1 nf=1 m=1
.ends ISR

.subckt dut VDD VSS VCONT1 VIN VCONT2 VCONT3 VCONT4 VCONT5 VP VREF VB3
.model DIODE D(IS=1e-14 N=1)
CFLY VX1 VX2 1p
CO VP VN 1p
COP VP VSS 1p
D1 VN VX2 DIODE
L1 VX1 VX3 1n
M1 VIN VCONT2 VX1 VIN pch l=0.15 w=1 nf=1 m=1
M2 VX2 VCONT3 VIN VIN pch l=0.15 w=1 nf=1 m=1
M3 VX3 VCONT5 VP VP pch l=0.15 w=1 nf=1 m=1
M4 VX3 VCONT4 VSS VSS nch l=0.15 w=1 nf=1 m=1
M5 net1 VCONT1 VIN VIN pch l=0.15 w=1 nf=1 m=1
R1 VP VFP1 1k
R2 VFP1 VSS 1k
X1 VDD VSS VREF VFP1 net0 VX2 EA
X2 VSS net1 net0 VB3 VX1 ISR
.ends dut
