* official Analog Canvas netlist; PDK X cards rewritten by convert.py
.model nch nmos
.model pch pmos

.subckt dut VDD VSS vout vin
I1 net2 net0 DC 100uA
M1 vin net1 VSS VSS nch l=0.15 w=1 nf=1 m=1
M2 vout net0 vin VSS nch l=0.15 w=1 nf=1 m=1
M3 vout net2 VDD VDD pch l=0.15 w=1 nf=1 m=1
M4 net1 net1 VSS VSS nch l=0.15 w=1 nf=1 m=1
M5 net0 net0 net1 VSS nch l=0.15 w=1 nf=1 m=1
M6 net2 net2 VDD VDD pch l=0.15 w=1 nf=1 m=1
.ends dut
