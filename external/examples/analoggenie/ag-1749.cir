* official Analog Canvas netlist; PDK X cards rewritten by convert.py
.model nch nmos
.model pch pmos
.model qpnp pnp

.subckt dut VDD VSS Vout
M1 X VG VDD VDD pch l=0.15 w=1 nf=1 m=1
M10 net1 Y Y VSS nch l=0.15 w=1 nf=1 m=1
M11 Y VB5 VSS VSS nch l=0.15 w=1 nf=1 m=1
M12 Z VB4 net2 VSS nch l=0.15 w=1 nf=1 m=1
M13 VG VB4 net4 VSS nch l=0.15 w=1 nf=1 m=1
M14 net2 Z VSS VSS nch l=0.15 w=1 nf=1 m=1
M15 net4 Z VSS VSS nch l=0.15 w=1 nf=1 m=1
M16 VB4 net5 VDD VDD pch l=0.15 w=1 nf=1 m=1
M17 VB4 VB4 VB5 VSS nch l=0.15 w=1 nf=1 m=1
M18 VB5 VB5 VSS VSS nch l=0.15 w=1 nf=1 m=1
M19 net5 net5 VDD VDD pch l=0.15 w=1 nf=1 m=1
M2 Vout VG VDD VDD pch l=0.15 w=1 nf=1 m=1
M20 VB3 net5 VDD VDD pch l=0.15 w=1 nf=1 m=1
M21 net5 VB3 VSS VSS nch l=0.15 w=1 nf=1 m=1
M22 VB3 VB3 VSS VSS nch l=0.15 w=1 nf=1 m=1
M3 net3 VG VDD VDD pch l=0.15 w=1 nf=1 m=1
M4 Z VG VDD VDD pch l=0.15 w=1 nf=1 m=1
M5 net6 VB1 VDD VDD pch l=0.15 w=1 nf=1 m=1
M6 net1 VB1 VDD VDD pch l=0.15 w=1 nf=1 m=1
M7 Z VB2 net6 VDD pch l=0.15 w=1 nf=1 m=1
M8 VG VB2 net1 VDD pch l=0.15 w=1 nf=1 m=1
M9 net6 X Y VSS nch l=0.15 w=1 nf=1 m=1
Q1 VSS VSS net3 qpnp m=1
Q2 VSS net3 X qpnp m=1
Q3 VSS VSS Z qpnp m=1
Q4 VSS Z net0 qpnp m=1
R1 Y net0 1k
R2 Vout Y 1k
.ends dut
