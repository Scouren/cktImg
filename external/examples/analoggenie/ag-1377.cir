* official Analog Canvas netlist; PDK X cards rewritten by convert.py
.model nch nmos
.model pch pmos

.subckt comp VDD VSS VB1 VB2 INN TAIL OUT VB3
M1 net4 VB1 VDD VDD pch l=0.15 w=1 nf=1 m=1
M10 net0 OUT TAIL VSS nch l=0.15 w=1 nf=1 m=1
M11 TAIL VB5 VSS VSS nch l=0.15 w=1 nf=1 m=1
M12 VBP VBP VDD VDD pch l=0.15 w=1 nf=1 m=1
M13 VBP VB3 net2 VSS nch l=0.15 w=1 nf=1 m=1
M14 VB3 VBP VDD VDD pch l=0.15 w=1 nf=1 m=1
M15 VB3 VB3 VSS VSS nch l=0.15 w=1 nf=1 m=1
M16 VB4 VBP VDD VDD pch l=0.15 w=1 nf=1 m=1
M17 VB4 VB4 VB5 VSS nch l=0.15 w=1 nf=1 m=1
M18 VB5 VB5 VSS VSS nch l=0.15 w=1 nf=1 m=1
M2 net0 VB1 VDD VDD pch l=0.15 w=1 nf=1 m=1
M3 VC VB2 net4 VDD pch l=0.15 w=1 nf=1 m=1
M4 OUT VB2 net0 VDD pch l=0.15 w=1 nf=1 m=1
M5 VC VB4 net3 VSS nch l=0.15 w=1 nf=1 m=1
M6 OUT VB4 net1 VSS nch l=0.15 w=1 nf=1 m=1
M7 net3 VC VSS VSS nch l=0.15 w=1 nf=1 m=1
M8 net1 VC VSS VSS nch l=0.15 w=1 nf=1 m=1
M9 net4 INN TAIL VSS nch l=0.15 w=1 nf=1 m=1
R1 net2 VSS 1k
.ends comp

.subckt dut VDD VSS VSTO VOUT VCONT1 VCONT2 VCONT3 VB1 VB2 VB3
CL VOUT VSS 1p
CSTO VSTO VSS 1p
LRX VX net1 1n
MN1 VX VCONT2 VSS VSS nch l=0.15 w=1 nf=1 m=1
MN2 net1 VCONT3 VSS VSS nch l=0.15 w=1 nf=1 m=1
MP2 net1 net0 VOUT VOUT pch l=0.15 w=1 nf=1 m=1
MP3 VX VCONT1 VSTO VSTO pch l=0.15 w=1 nf=1 m=1
X1 VDD VSS VB1 VB2 net1 VX net0 VB3 comp
.ends dut
