* official Analog Canvas netlist; PDK X cards rewritten by convert.py
.model nch nmos
.model pch pmos

.subckt dut VDD VSS GND vin+ vin- vout
C1 vout GND 1p
M1 net2 vin+ net0 VSS nch l=0.15 w=1 nf=1 m=1
M2 vout vin- net0 VSS nch l=0.15 w=1 nf=1 m=1
M3 net2 vin+ net1 VDD pch l=0.15 w=1 nf=1 m=1
M4 vout vin- net1 VDD pch l=0.15 w=1 nf=1 m=1
M5 net0 net2 VSS VSS nch l=0.15 w=1 nf=1 m=1
M6 net1 net2 VDD VDD pch l=0.15 w=1 nf=1 m=1
.ends dut
