* official Analog Canvas netlist; PDK X cards rewritten by convert.py
.model nch nmos
.model pch pmos

.subckt opamp VDD VSS INP INN OUT
M13 net0 VB3 VDD VDD pch l=0.15 w=1 nf=1 m=1
M14 net2 VB3 VDD VDD pch l=0.15 w=1 nf=1 m=1
M15 VX VB1 net0 VDD pch l=0.15 w=1 nf=1 m=1
M16 OUT VB1 net2 VDD pch l=0.15 w=1 nf=1 m=1
M17 VX VB2 net3 VSS nch l=0.15 w=1 nf=1 m=1
M18 OUT VB2 net1 VSS nch l=0.15 w=1 nf=1 m=1
M19 net3 VX VSS VSS nch l=0.15 w=1 nf=1 m=1
M20 net1 VX VSS VSS nch l=0.15 w=1 nf=1 m=1
M21 net0 INP IB VSS nch l=0.15 w=1 nf=1 m=1
M22 net2 INN IB VSS nch l=0.15 w=1 nf=1 m=1
.ends opamp

.subckt dut VDD VSS vin+ vout vin-
C1 net2 vout 1p
C2 vout net6 1p
C3 net1 vout 1p
C4 vout vout 1p
C5 net0 net5 1p
C6 net5 net4 1p
C7 net3 VSS 1p
M1 vin+ phi2 net2 VSS nch l=0.15 w=1 nf=1 m=1
M10 VSS phi1a net3 VSS nch l=0.15 w=1 nf=1 m=1
M11 VSS phi1 net4 VSS nch l=0.15 w=1 nf=1 m=1
M12 net4 phi2 VSS VSS nch l=0.15 w=1 nf=1 m=1
M2 VSS phi1 net2 VSS nch l=0.15 w=1 nf=1 m=1
M3 VSS phi2 net1 VSS nch l=0.15 w=1 nf=1 m=1
M4 net1 phi1 vout VSS nch l=0.15 w=1 nf=1 m=1
M5 net6 phi1a VSS VSS nch l=0.15 w=1 nf=1 m=1
M6 net6 phi2a vout VSS nch l=0.15 w=1 nf=1 m=1
M7 vin- phi2 net0 VSS nch l=0.15 w=1 nf=1 m=1
M8 net0 phi1 VSS VSS nch l=0.15 w=1 nf=1 m=1
M9 net5 phi2a net3 VSS nch l=0.15 w=1 nf=1 m=1
X1 VDD VSS net5 vout vout opamp
.ends dut
