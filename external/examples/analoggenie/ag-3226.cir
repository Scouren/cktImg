* official Analog Canvas netlist; PDK X cards rewritten by convert.py
.model nch nmos
.model pch pmos

.subckt opamp VDD VSS INN INP OUT
M10 net3 INP net1 VSS nch l=0.15 w=1 nf=1 m=1
M11 net1 VB3 VSS VSS nch l=0.15 w=1 nf=1 m=1
M12 net4 net4 VSS VSS nch l=0.15 w=1 nf=1 m=1
M13 OUT net4 VSS VSS nch l=0.15 w=1 nf=1 m=1
M14 VB3 VB1 VDD VDD pch l=0.15 w=1 nf=1 m=1
M15 VB1 VB1 VDD VDD pch l=0.15 w=1 nf=1 m=1
M16 VB2 VB2 VDD VDD pch l=0.15 w=1 nf=1 m=1
M17 net2 VB2 VDD VDD pch l=0.15 w=1 nf=1 m=1
M18 VB3 VB3 VSS VSS nch l=0.15 w=1 nf=1 m=1
M19 VB1 net5 VSS VSS nch l=0.15 w=1 nf=1 m=1
M20 VB2 net2 net5 VSS nch l=0.15 w=1 nf=1 m=1
M21 net2 net5 VSS VSS nch l=0.15 w=1 nf=1 m=1
M5 net0 net0 VDD VDD pch l=0.15 w=1 nf=1 m=1
M6 net4 net0 VDD VDD pch l=0.15 w=1 nf=1 m=1
M7 net3 net3 VDD VDD pch l=0.15 w=1 nf=1 m=1
M8 OUT net3 VDD VDD pch l=0.15 w=1 nf=1 m=1
M9 net0 INN net1 VSS nch l=0.15 w=1 nf=1 m=1
R1 net5 VSS 1k
.ends opamp

.subckt dut VDD VSS vci phi1 phi2 vco
C1 net0 net2 1p
C2 net1 vco 1p
M1 vci phi1 net0 VSS nch l=0.15 w=1 nf=1 m=1
M2 net0 phi2 VSS VSS nch l=0.15 w=1 nf=1 m=1
M3 net2 phi1 VSS VSS nch l=0.15 w=1 nf=1 m=1
M4 net2 phi2 net1 VSS nch l=0.15 w=1 nf=1 m=1
X1 VDD VSS net1 VSS vco opamp
.ends dut
