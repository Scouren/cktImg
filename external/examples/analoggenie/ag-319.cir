* official Analog Canvas netlist; PDK X cards rewritten by convert.py
.model nch nmos
.model pch pmos

.subckt dut VDD VSS Vin Vout Vb1 Vb2 Vb3
ISS net0 VSS DC 1m
M1 X Vin net0 VSS nch l=0.15 w=1 nf=1 m=1
M10 Y Vb1 VDD VDD pch l=0.15 w=1 nf=1 m=1
M2 Y Vout net0 VSS nch l=0.15 w=1 nf=1 m=1
M3 net1 Vb2 X VDD pch l=0.15 w=1 nf=1 m=1
M4 Vout Vb2 Y VDD pch l=0.15 w=1 nf=1 m=1
M5 net1 Vb3 net3 VSS nch l=0.15 w=1 nf=1 m=1
M6 Vout Vb3 net2 VSS nch l=0.15 w=1 nf=1 m=1
M7 net3 net1 VSS VSS nch l=0.15 w=1 nf=1 m=1
M8 net2 net1 VSS VSS nch l=0.15 w=1 nf=1 m=1
M9 X Vb1 VDD VDD pch l=0.15 w=1 nf=1 m=1
.ends dut
