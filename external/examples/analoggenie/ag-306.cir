* official Analog Canvas netlist; PDK X cards rewritten by convert.py
.model nch nmos
.model pch pmos

.subckt dut VDD VSS Vb4 Vb3 Vb2 Vb1 Vout1 Vout2 VoutCM
I1 net3 VSS DC 1m
I2 net2 VSS DC 1m
M10 net1 Vb4 VDD VDD pch l=0.15 w=1 nf=1 m=1
M11 Vout1 Vb3 net5 VDD pch l=0.15 w=1 nf=1 m=1
M12 Vout2 Vb3 net1 VDD pch l=0.15 w=1 nf=1 m=1
M3 Vout1 Vb2 net4 VSS nch l=0.15 w=1 nf=1 m=1
M4 Vout2 Vb2 net0 VSS nch l=0.15 w=1 nf=1 m=1
M5 net4 Vb1 VSS VSS nch l=0.15 w=1 nf=1 m=1
M6 net0 Vb1 VSS VSS nch l=0.15 w=1 nf=1 m=1
M7 VDD Vout1 net3 VSS nch l=0.15 w=1 nf=1 m=1
M8 VDD Vout2 net2 VSS nch l=0.15 w=1 nf=1 m=1
M9 net5 Vb4 VDD VDD pch l=0.15 w=1 nf=1 m=1
R1 VoutCM net2 1k
R2 net3 VoutCM 1k
.ends dut
