* official Analog Canvas netlist; PDK X cards rewritten by convert.py
.model nch nmos
.model pch pmos

.subckt AEA VDD VSS VB1 VB2 OUT VREF X
M10 net5 X VSS VSS nch l=0.15 w=1 nf=1 m=1
M11 net1 X VSS VSS nch l=0.15 w=1 nf=1 m=1
M12 net2 VREF net6 VSS nch l=0.15 w=1 nf=1 m=1
M13 net3 OUT net6 VSS nch l=0.15 w=1 nf=1 m=1
M14 net6 VB7 VSS VSS nch l=0.15 w=1 nf=1 m=1
M15 VB6 net4 VDD VDD pch l=0.15 w=1 nf=1 m=1
M16 net4 net4 VDD VDD pch l=0.15 w=1 nf=1 m=1
M17 net0 net4 VDD VDD pch l=0.15 w=1 nf=1 m=1
M18 VB6 VB6 VB7 VSS nch l=0.15 w=1 nf=1 m=1
M19 VB7 VB7 VSS VSS nch l=0.15 w=1 nf=1 m=1
M20 net4 net0 VSS VSS nch l=0.15 w=1 nf=1 m=1
M21 net0 net0 VSS VSS nch l=0.15 w=1 nf=1 m=1
M4 net2 VB1 VDD VDD pch l=0.15 w=1 nf=1 m=1
M5 net3 VB1 VDD VDD pch l=0.15 w=1 nf=1 m=1
M6 OUT VB2 net2 VDD pch l=0.15 w=1 nf=1 m=1
M7 X VB2 net3 VDD pch l=0.15 w=1 nf=1 m=1
M8 OUT VB6 net5 VSS nch l=0.15 w=1 nf=1 m=1
M9 X VB6 net1 VSS nch l=0.15 w=1 nf=1 m=1
.ends AEA

.subckt dut VDD VSS VIN VREF VB1 VB2 pb nb VOUT VERR
M1 net0 VEA VIN VDD pch l=0.15 w=1 nf=1 m=1
M2 net2 net2 net0 VDD pch l=0.15 w=1 nf=1 m=1
M3 net2 nb VSS VSS nch l=0.15 w=1 nf=1 m=1
MBIAS VERR nb VSS VSS nch l=0.15 w=1 nf=1 m=1
MCHG net1 pb VIN VDD pch l=0.15 w=1 nf=1 m=1
MCTRL VERR net2 VOUT VDD pch l=0.15 w=1 nf=1 m=1
MGEN net3 net3 VSS VSS nch l=0.15 w=1 nf=1 m=1
MINJ VERR net3 VSS VSS nch l=0.15 w=1 nf=1 m=1
MRES VOUT VERR VIN VDD pch l=0.15 w=1 nf=1 m=1
MSEN net3 VEA net1 VDD pch l=0.15 w=1 nf=1 m=1
X1 VDD VSS VB1 VB2 VEA VREF net2 AEA
.ends dut
