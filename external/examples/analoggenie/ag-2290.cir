* official Analog Canvas netlist; PDK X cards rewritten by convert.py
.model nch nmos
.model pch pmos

.subckt dut VDD VSS VB1 VB2 IBUF VIN VOUT
CL VOUT net4 1p
M1 net10 VB5 VSS VSS nch l=0.15 w=1 nf=1 m=1
M10 EAO VB2 net8 VDD pch l=0.15 w=1 nf=1 m=1
M11 net5 VB1 VDD VDD pch l=0.15 w=1 nf=1 m=1
M12 net8 VB1 VDD VDD pch l=0.15 w=1 nf=1 m=1
M13 net9 VB4 VDD VDD pch l=0.15 w=1 nf=1 m=1
M14 net0 EAO net9 VDD pch l=0.15 w=1 nf=1 m=1
M15 net0 net0 GND VSS nch l=0.15 w=1 nf=1 m=1
M16 GATE net0 GND VSS nch l=0.15 w=1 nf=1 m=1
M17 VDD net9 GATE VSS nch l=0.15 w=1 nf=1 m=1
M18 net1 EAO IBUF VSS nch l=0.15 w=1 nf=1 m=1
M19 net1 net1 VDD VDD pch l=0.15 w=1 nf=1 m=1
M2 VB5 VB5 VSS VSS nch l=0.15 w=1 nf=1 m=1
M20 GATE net1 VDD VDD pch l=0.15 w=1 nf=1 m=1
M21 GND IBUF GATE VDD pch l=0.15 w=1 nf=1 m=1
M22 VB6 VB6 VB5 VSS nch l=0.15 w=1 nf=1 m=1
M23 VB6 net2 VDD VDD pch l=0.15 w=1 nf=1 m=1
M24 net2 net2 VDD VDD pch l=0.15 w=1 nf=1 m=1
M25 net11 net2 VDD VDD pch l=0.15 w=1 nf=1 m=1
M26 net2 net11 VSS VSS nch l=0.15 w=1 nf=1 m=1
M27 net6 net11 VSS VSS nch l=0.15 w=1 nf=1 m=1
M3 net8 VREF net10 VSS nch l=0.15 w=1 nf=1 m=1
M4 net5 FB net10 VSS nch l=0.15 w=1 nf=1 m=1
M5 net3 VX VSS VSS nch l=0.15 w=1 nf=1 m=1
M6 net7 VX VSS VSS nch l=0.15 w=1 nf=1 m=1
M7 VX VB6 net3 VSS nch l=0.15 w=1 nf=1 m=1
M8 EAO VB6 net7 VSS nch l=0.15 w=1 nf=1 m=1
M9 VX VB2 net5 VDD pch l=0.15 w=1 nf=1 m=1
MNP VIN GATE VOUT VSS nch l=0.15 w=1 nf=1 m=1
R1 FB GND 1k
R2 VOUT FB 1k
R3 net11 net6 1k
R4 net4 GND 1k
RL VOUT GND 1k
.ends dut
