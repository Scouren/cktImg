* official Analog Canvas netlist; PDK X cards rewritten by convert.py
.model nch nmos
.model pch pmos

.subckt EA VDD VSS VFP1 VREF VCTRL VX2
MN1 VCTRL net1 VSS VSS nch l=0.15 w=1 nf=1 m=1
MN2 net1 net1 VSS VSS nch l=0.15 w=1 nf=1 m=1
MN3 VX2 VX2 VSS VSS nch l=0.15 w=1 nf=1 m=1
MN4 net4 VX2 VSS VSS nch l=0.15 w=1 nf=1 m=1
MN5 net2 net0 VSS VSS nch l=0.15 w=1 nf=1 m=1
MN6 net0 net0 VSS VSS nch l=0.15 w=1 nf=1 m=1
MN7 VBP net0 VSS VSS nch l=0.15 w=1 nf=1 m=1
MP1 VCTRL net4 VDD VDD pch l=0.15 w=1 nf=1 m=1
MP2 net4 net4 VDD VDD pch l=0.15 w=1 nf=1 m=1
MP3 net3 VBP VDD VDD pch l=0.15 w=1 nf=1 m=1
MP4 net1 VFP1 net3 net5 pch l=0.15 w=1 nf=1 m=1
MP5 VX2 VREF net3 net5 pch l=0.15 w=1 nf=1 m=1
MP6 VBP VBP VDD VDD pch l=0.15 w=1 nf=1 m=1
R3 VDD net2 1k
R4 VDD net0 1k
R5 net2 net0 1k
.ends EA

.subckt ISR VSS VS IOUT VCTRL VB1
MN10 net1 net1 VSS VSS nch l=0.15 w=1 nf=1 m=1
MN11 net1 VB1 VSS VSS nch l=0.15 w=1 nf=1 m=1
MN12 net0 net1 VSS VSS nch l=0.15 w=1 nf=1 m=1
MP10 net1 VCTRL VS VS pch l=0.15 w=1 nf=1 m=1
MP11 net0 net0 VS VS pch l=0.15 w=1 nf=1 m=1
MP12 IOUT net0 VS VS pch l=0.15 w=1 nf=1 m=1
.ends ISR

.subckt dut VDD VSS VIN VP VCONT1 VCONT2 VCONT3 VCONT4 VCONT5 VB1 VREF
.model DIODE D(IS=1e-14 N=1)
CFLY VX1 VX2 1p
CO VP VN 1p
COP VP VSS 1p
D1 VN VX2 DIODE
L1 VX1 VX3 1n
M1 VX1 VCONT2 VIN VIN pch l=0.15 w=1 nf=1 m=1
M2 VX2 VCONT3 VIN VIN pch l=0.15 w=1 nf=1 m=1
M3 VX3 VCONT4 VSS VSS nch l=0.15 w=1 nf=1 m=1
M4 VX3 VCONT5 VP VP pch l=0.15 w=1 nf=1 m=1
M5 net1 VCONT1 VIN VIN pch l=0.15 w=1 nf=1 m=1
R1 VP VFP1 1k
R2 VFP1 VSS 1k
X1 VSS net1 VX1 net0 VB1 ISR
X2 VDD VSS VFP1 VREF net0 VX2 EA
.ends dut
