* official Analog Canvas netlist; PDK X cards rewritten by convert.py
.model nch nmos
.model pch pmos

.subckt opamp VDD VSS INP INN OUT
M10 net4 net0 VSS VSS nch l=0.15 w=1 nf=1 m=1
M11 net6 net0 VSS VSS nch l=0.15 w=1 nf=1 m=1
M12 net1 net1 VDD VDD pch l=0.15 w=1 nf=1 m=1
M13 net1 net3 VSS VSS nch l=0.15 w=1 nf=1 m=1
M14 net3 VB1 VDD VDD pch l=0.15 w=1 nf=1 m=1
M15 net3 net3 VSS VSS nch l=0.15 w=1 nf=1 m=1
M16 VB1 VB1 VDD VDD pch l=0.15 w=1 nf=1 m=1
M17 VB1 net3 VSS VSS nch l=0.15 w=1 nf=1 m=1
M5 net2 net1 VDD VDD pch l=0.15 w=1 nf=1 m=1
M6 net0 INP net2 net5 pch l=0.15 w=1 nf=1 m=1
M7 OUT INN net2 net5 pch l=0.15 w=1 nf=1 m=1
M8 net0 VB2 net4 VSS nch l=0.15 w=1 nf=1 m=1
M9 OUT VB2 net6 VSS nch l=0.15 w=1 nf=1 m=1
.ends opamp

.subckt dut VDD VSS vci vco
C1 net1 net2 1p
C2 net0 vco 1p
M1 vci phi1 net1 VSS nch l=0.15 w=1 nf=1 m=1
M2 net1 phi2 VSS VSS nch l=0.15 w=1 nf=1 m=1
M3 net2 phi1 VSS VSS nch l=0.15 w=1 nf=1 m=1
M4 net2 phi2 net0 VSS nch l=0.15 w=1 nf=1 m=1
X1 VDD VSS VSS net0 vco opamp
.ends dut
