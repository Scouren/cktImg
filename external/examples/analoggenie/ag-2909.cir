* official Analog Canvas netlist; PDK X cards rewritten by convert.py
.model nch nmos
.model pch pmos

.subckt opamp VDD VSS INN OUT VX INP
M10 net0 net0 VDD VDD pch l=0.15 w=1 nf=1 m=1
M11 net0 net1 VSS VSS nch l=0.15 w=1 nf=1 m=1
M12 net1 VB1 VDD VDD pch l=0.15 w=1 nf=1 m=1
M13 net1 net1 VSS VSS nch l=0.15 w=1 nf=1 m=1
M14 VB1 VB1 VDD VDD pch l=0.15 w=1 nf=1 m=1
M15 VB1 net1 net5 VSS nch l=0.15 w=1 nf=1 m=1
M3 VX net0 VDD VDD pch l=0.15 w=1 nf=1 m=1
M4 OUT INN VX VDD pch l=0.15 w=1 nf=1 m=1
M5 net2 INP VX VDD pch l=0.15 w=1 nf=1 m=1
M6 OUT VB2 net3 VSS nch l=0.15 w=1 nf=1 m=1
M7 net2 VB2 net4 VSS nch l=0.15 w=1 nf=1 m=1
M8 net3 net2 VSS VSS nch l=0.15 w=1 nf=1 m=1
M9 net4 net2 VSS VSS nch l=0.15 w=1 nf=1 m=1
R1 net5 VSS 1k
.ends opamp

.subckt dut VDD VSS vci phi1 phi2 vco
C1 vcx VSS 1p
C2 net0 vco 1p
M1 vci phi1 vcx VSS nch l=0.15 w=1 nf=1 m=1
M2 vcx phi2 net0 VSS nch l=0.15 w=1 nf=1 m=1
X1 VDD VSS net0 vco vcx VSS opamp
.ends dut
