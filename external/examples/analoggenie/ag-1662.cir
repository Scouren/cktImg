* official Analog Canvas netlist; PDK X cards rewritten by convert.py
.model nch nmos
.model pch pmos
.model qpnp pnp

.subckt opamp VDD VSS INN INP OUT VB1 VB2
M1 INN VB1 VDD VDD pch l=0.15 w=1 nf=1 m=1
M10 net3 INP net5 VSS nch l=0.15 w=1 nf=1 m=1
M11 net5 VB4 VSS VSS nch l=0.15 w=1 nf=1 m=1
M12 net0 net0 net4 VDD pch l=0.15 w=1 nf=1 m=1
M13 VB3 net0 VDD VDD pch l=0.15 w=1 nf=1 m=1
M14 VB3 VB3 VB4 VSS nch l=0.15 w=1 nf=1 m=1
M15 VB4 VB4 VSS VSS nch l=0.15 w=1 nf=1 m=1
M2 net3 VB1 VDD VDD pch l=0.15 w=1 nf=1 m=1
M3 net2 VB2 INN VDD pch l=0.15 w=1 nf=1 m=1
M4 OUT VB2 net3 VDD pch l=0.15 w=1 nf=1 m=1
M5 net2 VB3 net6 VSS nch l=0.15 w=1 nf=1 m=1
M6 OUT VB3 net1 VSS nch l=0.15 w=1 nf=1 m=1
M7 net6 net2 VSS VSS nch l=0.15 w=1 nf=1 m=1
M8 net1 net2 VSS VSS nch l=0.15 w=1 nf=1 m=1
M9 INN INN net5 VSS nch l=0.15 w=1 nf=1 m=1
R1 VDD net4 1k
R2 net0 VSS 1k
.ends opamp

.subckt dut VDD VSS Vout VB1 VB2
Q1 VSS VSS net1 qpnp m=1
Q2 net1 net1 X qpnp m=1
Q3 VSS VSS net0 qpnp m=1
Q4 net0 net0 net2 qpnp m=1
R1 Vout X 1k
R2 Vout Y 1k
R3 Y net2 1k
X1 VDD VSS Y X Vout VB1 VB2 opamp
.ends dut
