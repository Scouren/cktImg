* official Analog Canvas netlist; PDK X cards rewritten by convert.py
.model nch nmos
.model pch pmos

.subckt dut VDD VSS v1 v2 vout
C1 vout VSS 10pF
Cc vout net4 1p
I1 net0 VSS DC 1m
M1 net4 v1 net2 VSS nch l=0.15 w=1 nf=1 m=1
M10 net3 net0 VDD VDD pch l=0.15 w=1 nf=1 m=1
M11 net4 net0 VDD VDD pch l=0.15 w=1 nf=1 m=1
M12 net1 net0 VDD VDD pch l=0.15 w=1 nf=1 m=1
M2 net1 v2 net2 VSS nch l=0.15 w=1 nf=1 m=1
M3 net1 net1 VSS VSS nch l=0.15 w=1 nf=1 m=1
M4 net4 net1 VSS VSS nch l=0.15 w=1 nf=1 m=1
M5 net2 net3 VSS VSS nch l=0.15 w=1 nf=1 m=1
M6 vout net4 VSS VSS nch l=0.15 w=1 nf=1 m=1
M7 vout net0 VDD VDD pch l=0.15 w=1 nf=1 m=1
M8 net3 net3 VSS VSS nch l=0.15 w=1 nf=1 m=1
M9 net0 net0 VDD VDD pch l=0.15 w=1 nf=1 m=1
.ends dut
