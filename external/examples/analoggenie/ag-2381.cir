* official Analog Canvas netlist; PDK X cards rewritten by convert.py
.model nch nmos
.model pch pmos

.subckt dut VDD VSS VIN VOUT VERR VREF
M1 net8 VEAOUT VIN VDD pch l=0.15 w=1 nf=1 m=1
M10 VEAOUT VB5 net7 VSS nch l=0.15 w=1 nf=1 m=1
M11 net7 VX VSS VSS nch l=0.15 w=1 nf=1 m=1
M12 net2 VEAOUT net4 VSS nch l=0.15 w=1 nf=1 m=1
M13 net0 VREF net4 VSS nch l=0.15 w=1 nf=1 m=1
M14 net4 VB6 VSS VSS nch l=0.15 w=1 nf=1 m=1
M15 net5 net5 VDD VDD pch l=0.15 w=1 nf=1 m=1
M16 VB5 net5 VDD VDD pch l=0.15 w=1 nf=1 m=1
M17 VB5 VB5 VB6 VSS nch l=0.15 w=1 nf=1 m=1
M18 VB6 VB6 VSS VSS nch l=0.15 w=1 nf=1 m=1
M2 VX VX net8 VDD pch l=0.15 w=1 nf=1 m=1
M3 VX nb VSS VSS nch l=0.15 w=1 nf=1 m=1
M4 net2 VB1 VDD VDD pch l=0.15 w=1 nf=1 m=1
M5 VX VB2 net2 VDD pch l=0.15 w=1 nf=1 m=1
M6 VX VB5 net3 VSS nch l=0.15 w=1 nf=1 m=1
M7 net3 VX VSS VSS nch l=0.15 w=1 nf=1 m=1
M8 net0 VB1 VDD VDD pch l=0.15 w=1 nf=1 m=1
M9 VEAOUT VB2 net0 VDD pch l=0.15 w=1 nf=1 m=1
MBIAS VERR nb VSS VSS nch l=0.15 w=1 nf=1 m=1
MCHG net6 pb VIN VDD pch l=0.15 w=1 nf=1 m=1
MCTRL VERR VX VOUT VDD pch l=0.15 w=1 nf=1 m=1
MGEN net1 net1 VSS VSS nch l=0.15 w=1 nf=1 m=1
MINJ VERR net1 VSS VSS nch l=0.15 w=1 nf=1 m=1
MRES VOUT VERR VIN VDD pch l=0.15 w=1 nf=1 m=1
MSEN net1 VEAOUT net6 VDD pch l=0.15 w=1 nf=1 m=1
R1 net5 VSS 1k
.ends dut
