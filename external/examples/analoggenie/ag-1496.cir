* official Analog Canvas netlist; PDK X cards rewritten by convert.py
.model nch nmos
.model pch pmos
.model qnpn npn

.subckt opamp VDD VSS INN INP OUT VB1 VB3 VC VB2
M1 net5 VB1 VDD VDD pch l=0.15 w=1 nf=1 m=1
M10 net3 net1 VSS VSS nch l=0.15 w=1 nf=1 m=1
M11 net0 VB2 VSS VSS nch l=0.15 w=1 nf=1 m=1
M2 net2 VB1 VDD VDD pch l=0.15 w=1 nf=1 m=1
M3 net2 INN net0 VSS nch l=0.15 w=1 nf=1 m=1
M4 net5 INP net0 VSS nch l=0.15 w=1 nf=1 m=1
M5 OUT VB3 net5 VDD pch l=0.15 w=1 nf=1 m=1
M6 net1 VB3 net2 VDD pch l=0.15 w=1 nf=1 m=1
M7 OUT VC net4 VSS nch l=0.15 w=1 nf=1 m=1
M8 net1 VC net3 VSS nch l=0.15 w=1 nf=1 m=1
M9 net4 net1 VSS VSS nch l=0.15 w=1 nf=1 m=1
.ends opamp

.subckt dut VDD VSS Vout VB1 VB2 VB3 VB5 VB4
M12 VC VP VDD VDD pch l=0.15 w=1 nf=1 m=1
M13 VP VP VDD VDD pch l=0.15 w=1 nf=1 m=1
M14 VB5 VP VDD VDD pch l=0.15 w=1 nf=1 m=1
M15 net0 VP VDD VDD pch l=0.15 w=1 nf=1 m=1
M16 VP VB5 VB4 VSS nch l=0.15 w=1 nf=1 m=1
M17 VB5 VB4 VSS VSS nch l=0.15 w=1 nf=1 m=1
M18 net0 net0 VSS VSS nch l=0.15 w=1 nf=1 m=1
M19 VB4 net0 VSS VSS nch l=0.15 w=1 nf=1 m=1
M20 VC VC Z VSS nch l=0.15 w=1 nf=1 m=1
M21 Z VC VSS VSS nch l=0.15 w=1 nf=1 m=1
Q1 net2 net2 VSS VSS qnpn m=1
Q2 Z Z VSS VSS qnpn m=1
R1 Vout net2 1k
R2 Vout net1 1k
R3 net1 Z 1k
X1 VDD VSS net1 net2 Vout VB1 VB3 VC VB2 opamp
.ends dut
