* official Analog Canvas netlist; PDK X cards rewritten by convert.py
.model nch nmos
.model pch pmos

.subckt AMP1 VDD VSS INP INN OUT VB1 VB2 n3
M10 net3 net0 VDD VDD pch l=0.15 w=1 nf=1 m=1
M11 net0 VB2 net1 VDD pch l=0.15 w=1 nf=1 m=1
M12 OUT VB2 net3 VDD pch l=0.15 w=1 nf=1 m=1
M13 net0 VBN2 net5 VSS nch l=0.15 w=1 nf=1 m=1
M14 OUT VBN2 net4 VSS nch l=0.15 w=1 nf=1 m=1
M15 net5 VBN1 VSS VSS nch l=0.15 w=1 nf=1 m=1
M16 net4 VBN1 VSS VSS nch l=0.15 w=1 nf=1 m=1
M17 VBN2 net2 VDD VDD pch l=0.15 w=1 nf=1 m=1
M18 net2 net2 VDD VDD pch l=0.15 w=1 nf=1 m=1
M19 VBN2 VBN2 VBN1 VSS nch l=0.15 w=1 nf=1 m=1
M20 VBN1 VBN1 VSS VSS nch l=0.15 w=1 nf=1 m=1
M6 n3 VB1 VDD VDD pch l=0.15 w=1 nf=1 m=1
M7 net5 INP n3 VDD pch l=0.15 w=1 nf=1 m=1
M8 net4 INN n3 VDD pch l=0.15 w=1 nf=1 m=1
M9 net1 net0 VDD VDD pch l=0.15 w=1 nf=1 m=1
R3 net2 VSS 1k
.ends AMP1

.subckt dut VDD VSS Vref Vout biasp biascas biasn VB1 VB2
C1 Vset VSS 1p
C2 n3 Vout 1p
M1 Vout n3 VDD VDD pch l=0.15 w=1 nf=1 m=1
M2 n1 Vset Vout VDD pch l=0.15 w=1 nf=1 m=1
M3 n1 biasn VSS VSS nch l=0.15 w=1 nf=1 m=1
M4 n3 biasp VDD VDD pch l=0.15 w=1 nf=1 m=1
M5 n3 biascas n1 VSS nch l=0.15 w=1 nf=1 m=1
R1 fb VSS 1k
R2 Vout fb 1k
X1 VDD VSS Vref fb Vset VB1 VB2 n3 AMP1
.ends dut
