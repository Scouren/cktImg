* official Analog Canvas netlist; PDK X cards rewritten by convert.py
.model nch nmos
.model pch pmos

.subckt opamp VDD VSS INP INN OUT VX
M10 net1 VY VSS VSS nch l=0.15 w=1 nf=1 m=1
M11 OUT net0 VSS VSS nch l=0.15 w=1 nf=1 m=1
M12 net1 net1 VDD VDD pch l=0.15 w=1 nf=1 m=1
M13 OUT net1 VDD VDD pch l=0.15 w=1 nf=1 m=1
M14 VB3 VB3 VDD VDD pch l=0.15 w=1 nf=1 m=1
M15 VB1 VB3 VDD VDD pch l=0.15 w=1 nf=1 m=1
M16 VB1 VB1 VSS VSS nch l=0.15 w=1 nf=1 m=1
M17 VB3 net2 VSS VSS nch l=0.15 w=1 nf=1 m=1
M18 net2 VB2 VDD VDD pch l=0.15 w=1 nf=1 m=1
M19 net2 net2 VSS VSS nch l=0.15 w=1 nf=1 m=1
M20 VB2 VB2 VDD VDD pch l=0.15 w=1 nf=1 m=1
M21 VB2 net2 VY VSS nch l=0.15 w=1 nf=1 m=1
M5 net3 VB3 VDD VDD pch l=0.15 w=1 nf=1 m=1
M6 VY INP net3 VX pch l=0.15 w=1 nf=1 m=1
M7 net0 INN net3 VX pch l=0.15 w=1 nf=1 m=1
M8 VY VY VSS VSS nch l=0.15 w=1 nf=1 m=1
M9 net0 net0 VSS VSS nch l=0.15 w=1 nf=1 m=1
R1 VY VSS 1k
.ends opamp

.subckt dut VDD VSS vci phi1 phi2 vco
C1 net0 VX 1p
C2 net1 vco 1p
M1 vci phi1 net0 VSS nch l=0.15 w=1 nf=1 m=1
M2 net0 phi2 VSS VSS nch l=0.15 w=1 nf=1 m=1
M3 VX phi1 VSS VSS nch l=0.15 w=1 nf=1 m=1
M4 VX phi2 net1 VSS nch l=0.15 w=1 nf=1 m=1
X1 VDD VSS VSS net1 vco VX opamp
.ends dut
