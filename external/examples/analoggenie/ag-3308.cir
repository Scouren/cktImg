* official Analog Canvas netlist; PDK X cards rewritten by convert.py
.model nch nmos
.model pch pmos

.subckt dut VDD VSS vci phi1 phi2 vco
C1 net1 net4 1p
C2 net5 vco 1p
M1 vci phi1 net1 VSS nch l=0.15 w=1 nf=1 m=1
M10 VB2 net0 VDD VDD pch l=0.15 w=1 nf=1 m=1
M11 VB2 VB2 VSS VSS nch l=0.15 w=1 nf=1 m=1
M12 net0 net0 VDD VDD pch l=0.15 w=1 nf=1 m=1
M13 net0 VB2 VSS VSS nch l=0.15 w=1 nf=1 m=1
M14 VB3 net0 VDD VDD pch l=0.15 w=1 nf=1 m=1
M15 VB3 VB3 VSS VSS nch l=0.15 w=1 nf=1 m=1
M2 net1 phi2 VSS VSS nch l=0.15 w=1 nf=1 m=1
M3 net4 phi1 VSS VSS nch l=0.15 w=1 nf=1 m=1
M4 net4 phi2 net5 VSS nch l=0.15 w=1 nf=1 m=1
M5 net2 net5 net3 VSS nch l=0.15 w=1 nf=1 m=1
M6 vco VSS net3 VSS nch l=0.15 w=1 nf=1 m=1
M7 net3 VB3 VSS VSS nch l=0.15 w=1 nf=1 m=1
M8 net2 net2 VDD VDD pch l=0.15 w=1 nf=1 m=1
M9 vco net2 VDD VDD pch l=0.15 w=1 nf=1 m=1
.ends dut
