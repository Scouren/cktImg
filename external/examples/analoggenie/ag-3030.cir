* official Analog Canvas netlist; PDK X cards rewritten by convert.py
.model nch nmos
.model pch pmos

.subckt opamp VDD VSS INP INN OUT
C3 net3 OUT 1p
M10 VB4 VB4 VDD VDD pch l=0.15 w=1 nf=1 m=1
M11 VB2 VB4 VDD VDD pch l=0.15 w=1 nf=1 m=1
M12 net0 VB4 VDD VDD pch l=0.15 w=1 nf=1 m=1
M13 VB3 VB3 VDD VDD pch l=0.15 w=1 nf=1 m=1
M14 VB1 VB3 VDD VDD pch l=0.15 w=1 nf=1 m=1
M15 VB4 VB2 net2 VSS nch l=0.15 w=1 nf=1 m=1
M16 VB2 VB2 VSS VSS nch l=0.15 w=1 nf=1 m=1
M17 net0 net0 VSS VSS nch l=0.15 w=1 nf=1 m=1
M18 VB3 net0 VSS VSS nch l=0.15 w=1 nf=1 m=1
M19 VB1 VB1 VSS VSS nch l=0.15 w=1 nf=1 m=1
M3 net1 INP net4 VDD pch l=0.15 w=1 nf=1 m=1
M4 net3 INN net4 VDD pch l=0.15 w=1 nf=1 m=1
M5 net4 VB3 VDD VDD pch l=0.15 w=1 nf=1 m=1
M6 net1 net1 VSS VSS nch l=0.15 w=1 nf=1 m=1
M7 net3 net1 VSS VSS nch l=0.15 w=1 nf=1 m=1
M8 OUT VB3 VDD VDD pch l=0.15 w=1 nf=1 m=1
M9 OUT net3 VSS VSS nch l=0.15 w=1 nf=1 m=1
R1 net2 VSS 1k
.ends opamp

.subckt dut VDD VSS vci phi1 phi2 vco
C1 net0 VSS 1p
C2 net1 vco 1p
M1 vci phi1 net0 VSS nch l=0.15 w=1 nf=1 m=1
M2 net0 phi2 net1 VSS nch l=0.15 w=1 nf=1 m=1
X1 VDD VSS VSS net1 vco opamp
.ends dut
