* official Analog Canvas netlist; PDK X cards rewritten by convert.py
.model nch nmos
.model pch pmos

.subckt dut VDD VSS vci phi1 phi2 vco VB1
C1 net1 net4 1p
C2 net6 vco 1p
M1 vci phi1 net1 VSS nch l=0.15 w=1 nf=1 m=1
M10 net0 net0 VDD VDD pch l=0.15 w=1 nf=1 m=1
M11 net0 VB2 VSS VSS nch l=0.15 w=1 nf=1 m=1
M12 VB2 net3 VDD VDD pch l=0.15 w=1 nf=1 m=1
M13 VB2 VB2 VSS VSS nch l=0.15 w=1 nf=1 m=1
M14 net3 net3 VDD VDD pch l=0.15 w=1 nf=1 m=1
M15 net3 VB1 VSS VSS nch l=0.15 w=1 nf=1 m=1
M16 VB1 net3 VDD VDD pch l=0.15 w=1 nf=1 m=1
M17 net5 VB1 VSS VSS nch l=0.15 w=1 nf=1 m=1
M2 net1 phi2 VSS VSS nch l=0.15 w=1 nf=1 m=1
M3 net4 phi1 VSS VSS nch l=0.15 w=1 nf=1 m=1
M4 net4 phi2 net6 VSS nch l=0.15 w=1 nf=1 m=1
M5 net0 net6 net2 VSS nch l=0.15 w=1 nf=1 m=1
M6 vco VSS net2 VSS nch l=0.15 w=1 nf=1 m=1
M7 net2 VB2 VSS VSS nch l=0.15 w=1 nf=1 m=1
M8 net0 net0 VDD VDD pch l=0.15 w=1 nf=1 m=1
M9 vco net0 VDD VDD pch l=0.15 w=1 nf=1 m=1
R1 VB1 net5 1k
.ends dut
