* official Analog Canvas netlist; PDK X cards rewritten by convert.py
.model nch nmos
.model pch pmos

.subckt opamp VDD VSS INP INN VB1 VB2 OUT
M1 net4 VX VDD VDD pch l=0.15 w=1 nf=1 m=1
M10 net2 INP net5 net7 pch l=0.15 w=1 nf=1 m=1
M11 net1 INN net5 net7 pch l=0.15 w=1 nf=1 m=1
M12 VB4 net0 VDD VDD pch l=0.15 w=1 nf=1 m=1
M13 VB4 VB4 VB5 VSS nch l=0.15 w=1 nf=1 m=1
M14 VB5 VB5 VSS VSS nch l=0.15 w=1 nf=1 m=1
M15 net0 net0 VDD VDD pch l=0.15 w=1 nf=1 m=1
M16 net0 VB3 net6 VSS nch l=0.15 w=1 nf=1 m=1
M17 VB3 net0 VDD VDD pch l=0.15 w=1 nf=1 m=1
M18 VB3 VB3 VSS VSS nch l=0.15 w=1 nf=1 m=1
M2 VX VB2 net4 VDD pch l=0.15 w=1 nf=1 m=1
M3 VX VB4 net2 VSS nch l=0.15 w=1 nf=1 m=1
M4 net2 VB5 VSS VSS nch l=0.15 w=1 nf=1 m=1
M5 net3 VX VDD VDD pch l=0.15 w=1 nf=1 m=1
M6 OUT VB2 net3 VDD pch l=0.15 w=1 nf=1 m=1
M7 OUT VB4 net1 VSS nch l=0.15 w=1 nf=1 m=1
M8 net1 VB5 VSS VSS nch l=0.15 w=1 nf=1 m=1
M9 net5 VB1 VDD VDD pch l=0.15 w=1 nf=1 m=1
R4 net6 VSS 1k
.ends opamp

.subckt dut VDD VSS VIN VOUT Vref VB1 VB2
CL VOUT net0 1p
MNP VIN net2 VOUT VOUT nch l=0.15 w=1 nf=1 m=1
R1 VOUT net1 1k
R2 net1 VSS 1k
R3 net0 VSS 1k
X1 VDD VSS Vref net1 VB1 VB2 net2 opamp
.ends dut
