* official Analog Canvas netlist; PDK X cards rewritten by convert.py
.model nch nmos
.model pch pmos
.model qpnp pnp

.global VDD

.subckt opamp VSS INN INP OUT Z
M10 OUT VB5 net2 VSS nch l=0.15 w=1 nf=1 m=1
M11 net1 Z VSS VSS nch l=0.15 w=1 nf=1 m=1
M12 net2 Z VSS VSS nch l=0.15 w=1 nf=1 m=1
M13 net3 INN INP VSS nch l=0.15 w=1 nf=1 m=1
M14 net6 INP INP VSS nch l=0.15 w=1 nf=1 m=1
M15 INP VB2 VSS VSS nch l=0.15 w=1 nf=1 m=1
M16 net0 net5 VDD VDD pch l=0.15 w=1 nf=1 m=1
M17 net5 net5 VDD VDD pch l=0.15 w=1 nf=1 m=1
M18 net0 net0 VSS VSS nch l=0.15 w=1 nf=1 m=1
M19 net5 net0 VSS VSS nch l=0.15 w=1 nf=1 m=1
M20 VB5 net5 VDD VDD pch l=0.15 w=1 nf=1 m=1
M21 VB5 VB5 net4 VSS nch l=0.15 w=1 nf=1 m=1
M22 net4 VB5 VSS VSS nch l=0.15 w=1 nf=1 m=1
M5 net3 VB1 VDD VDD pch l=0.15 w=1 nf=1 m=1
M6 net6 VB1 VDD VDD pch l=0.15 w=1 nf=1 m=1
M7 Z VB3 net3 VDD pch l=0.15 w=1 nf=1 m=1
M8 OUT VB3 net6 VDD pch l=0.15 w=1 nf=1 m=1
M9 Z VB5 net1 VSS nch l=0.15 w=1 nf=1 m=1
.ends opamp

.subckt dut VDD VSS Vout
M1 X VG VDD VDD pch l=0.15 w=1 nf=1 m=1
M2 Vout VG VDD VDD pch l=0.15 w=1 nf=1 m=1
M3 net0 VG VDD VDD pch l=0.15 w=1 nf=1 m=1
M4 Z VG VDD VDD pch l=0.15 w=1 nf=1 m=1
Q1 VSS VSS net0 qpnp m=1
Q2 VSS net0 X qpnp m=1
Q3 VSS VSS Z qpnp m=1
Q4 VSS Z net1 qpnp m=1
R1 Y net1 1k
R2 Vout Y 1k
X1 VSS X Y VG Z opamp
.ends dut
