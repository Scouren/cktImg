* official Analog Canvas netlist; PDK X cards rewritten by convert.py
.model nch nmos
.model pch pmos
.model qpnp pnp

.subckt A1 VDD VSS VB1 VB2 INN INP OUT VE4 VE3
M10 net3 net3 net0 VSS nch l=0.15 w=1 nf=1 m=1
M11 net0 net3 net1 VSS nch l=0.15 w=1 nf=1 m=1
M12 net5 net5 net1 VSS nch l=0.15 w=1 nf=1 m=1
M13 net1 net5 VB3 VSS nch l=0.15 w=1 nf=1 m=1
M14 VB3 VB3 VSS VSS nch l=0.15 w=1 nf=1 m=1
M15 VBC VBP VDD VDD pch l=0.15 w=1 nf=1 m=1
M16 VBC VBC VBN VSS nch l=0.15 w=1 nf=1 m=1
M17 VBN VBN VSS VSS nch l=0.15 w=1 nf=1 m=1
M18 net7 VE4 VDD VDD pch l=0.15 w=1 nf=1 m=1
M19 OUT VB2 net7 VDD pch l=0.15 w=1 nf=1 m=1
M20 OUT VBC net6 VSS nch l=0.15 w=1 nf=1 m=1
M21 net6 VBN VSS VSS nch l=0.15 w=1 nf=1 m=1
M22 VE3 VB1 VDD VDD pch l=0.15 w=1 nf=1 m=1
M23 net6 INN VE3 VDD pch l=0.15 w=1 nf=1 m=1
M24 net4 INP VE3 VDD pch l=0.15 w=1 nf=1 m=1
M25 net2 VE4 VDD VDD pch l=0.15 w=1 nf=1 m=1
M26 VE4 VB2 net2 VDD pch l=0.15 w=1 nf=1 m=1
M27 VE4 VBC net4 VSS nch l=0.15 w=1 nf=1 m=1
M28 net4 VBN VSS VSS nch l=0.15 w=1 nf=1 m=1
M5 VBP VBP VDD VDD pch l=0.15 w=1 nf=1 m=1
M6 net3 VBP VDD VDD pch l=0.15 w=1 nf=1 m=1
M7 net5 VBP VDD VDD pch l=0.15 w=1 nf=1 m=1
M8 VB3 VBP VDD VDD pch l=0.15 w=1 nf=1 m=1
M9 VBP net0 VSS VSS nch l=0.15 w=1 nf=1 m=1
.ends A1

.subckt dut VDD VSS Vout VB1 VB2
M1 X VG VDD VDD pch l=0.15 w=1 nf=1 m=1
M2 Vout VG VDD VDD pch l=0.15 w=1 nf=1 m=1
M3 net1 VG VDD VDD pch l=0.15 w=1 nf=1 m=1
M4 VE3 VG VDD VDD pch l=0.15 w=1 nf=1 m=1
Q1 VSS VSS net1 qpnp m=1
Q2 VSS net1 X qpnp m=1
Q3 VSS VSS VE3 qpnp m=1
Q4 VSS VE3 net0 qpnp m=1
R1 Y net0 1k
R2 Vout Y 1k
X1 VDD VSS VB1 VB2 X Y VG net0 VE3 A1
.ends dut
