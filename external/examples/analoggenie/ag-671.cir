* official Analog Canvas netlist; PDK X cards rewritten by convert.py
.model nch nmos

.subckt dut VDD VSS Iout
Iin VDD V1 DC 1m
M1 V1 V1 net1 VSS nch l=0.15 w=1 nf=1 m=1
M2 Iout V1 net0 VSS nch l=0.15 w=1 nf=1 m=1
Rs1 net1 VSS 1k
Rs2 net0 VSS 1k
.ends dut
