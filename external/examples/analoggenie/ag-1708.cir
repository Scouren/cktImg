* official Analog Canvas netlist; PDK X cards rewritten by convert.py
.model nch nmos
.model pch pmos
.model qpnp pnp

.subckt A1 VDD VSS INP INN OUT
M1 net2 INP net3 VSS nch l=0.15 w=1 nf=1 m=1
M10 VX VX VSS VSS nch l=0.15 w=1 nf=1 m=1
M11 net1 net1 VSS VSS nch l=0.15 w=1 nf=1 m=1
M12 VB1 net1 VSS VSS nch l=0.15 w=1 nf=1 m=1
M13 VB1 VB1 VDD VDD pch l=0.15 w=1 nf=1 m=1
M14 VB2 VB1 VDD VDD pch l=0.15 w=1 nf=1 m=1
M2 net0 INN net3 VSS nch l=0.15 w=1 nf=1 m=1
M3 net2 net2 VDD VDD pch l=0.15 w=1 nf=1 m=1
M4 net0 net0 VDD VDD pch l=0.15 w=1 nf=1 m=1
M5 net3 VB2 VSS VSS nch l=0.15 w=1 nf=1 m=1
M6 VB2 VB2 VSS VSS nch l=0.15 w=1 nf=1 m=1
M7 VX net2 VDD VDD pch l=0.15 w=1 nf=1 m=1
M8 OUT net0 VDD VDD pch l=0.15 w=1 nf=1 m=1
M9 OUT VX VSS VSS nch l=0.15 w=1 nf=1 m=1
R4 VDD net1 1k
.ends A1

.subckt dut VDD VSS Vout
Q1 VSS VSS net2 qpnp m=1
Q2 net2 net2 net0 qpnp m=1
Q3 VSS VSS net1 qpnp m=1
Q4 net1 net1 Y qpnp m=1
R1 Vout X 1k
R2 Vout Y 1k
R3 X net0 1k
X1 VDD VSS X Y Vout A1
.ends dut
