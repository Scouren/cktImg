* official Analog Canvas netlist; PDK X cards rewritten by convert.py
.model nch nmos
.model pch pmos

.subckt AMP1 VDD VSS INN INP OUT
M10 VX VX VSS VSS nch l=0.15 w=1 nf=1 m=1
M11 net2 INN net3 VSS nch l=0.15 w=1 nf=1 m=1
M12 INN INP net3 VSS nch l=0.15 w=1 nf=1 m=1
M13 OUT VX VSS VSS nch l=0.15 w=1 nf=1 m=1
M14 net3 VBN VSS VSS nch l=0.15 w=1 nf=1 m=1
M15 net0 net0 net1 VDD pch l=0.15 w=1 nf=1 m=1
M16 VBN net0 VDD VDD pch l=0.15 w=1 nf=1 m=1
M17 VBN VBN VSS VSS nch l=0.15 w=1 nf=1 m=1
M6 VX net2 VDD VDD pch l=0.15 w=1 nf=1 m=1
M7 net2 net2 VDD VDD pch l=0.15 w=1 nf=1 m=1
M8 INN INN VDD VDD pch l=0.15 w=1 nf=1 m=1
M9 OUT INN VDD VDD pch l=0.15 w=1 nf=1 m=1
R3 VDD net1 1k
R4 net0 VSS 1k
.ends AMP1

.subckt dut VDD VSS Vref biasp biascas biasn Vout
C1 Vset VSS 1p
C2 n3 Vout 1p
M1 Vout n3 VDD VDD pch l=0.15 w=1 nf=1 m=1
M2 n1 Vset Vout VDD pch l=0.15 w=1 nf=1 m=1
M3 n1 biasn VSS VSS nch l=0.15 w=1 nf=1 m=1
M4 n3 biasp VDD VDD pch l=0.15 w=1 nf=1 m=1
M5 n3 biascas n1 VSS nch l=0.15 w=1 nf=1 m=1
R1 fb VSS 1k
R2 Vout fb 1k
X1 VDD VSS fb Vref Vset AMP1
.ends dut
