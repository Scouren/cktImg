* official Analog Canvas netlist; PDK X cards rewritten by convert.py
.model nch nmos

.subckt dut VDD VSS D D_bar CK CK_bar
CD1 X VSS 1p
CD2 Y VSS 1p
ISS net4 VSS DC 1m
LD1 VDD net0 1n
LD2 VDD net2 1n
M1 X D net1 VSS nch l=0.15 w=1 nf=1 m=1
M2 Y D_bar net1 VSS nch l=0.15 w=1 nf=1 m=1
M3 Y X net3 VSS nch l=0.15 w=1 nf=1 m=1
M4 X Y net3 VSS nch l=0.15 w=1 nf=1 m=1
M5 net1 CK net4 VSS nch l=0.15 w=1 nf=1 m=1
M6 net3 CK_bar net4 VSS nch l=0.15 w=1 nf=1 m=1
RD1 net0 X 1k
RD2 net2 Y 1k
.ends dut
