* official Analog Canvas netlist; PDK X cards rewritten by convert.py
.model nch nmos
.model pch pmos

.subckt dut VDD VSS Up Down Vcont
C1 net4 VSS 1p
C2 Vcont VSS 1p
IREF VDD net1 DC 1m
M1 Vcont Up net2 VDD pch l=0.15 w=1 nf=1 m=1
M2 Vcont Down net3 VSS nch l=0.15 w=1 nf=1 m=1
M3 net2 net0 VDD VDD pch l=0.15 w=1 nf=1 m=1
M4 net3 net1 VSS VSS nch l=0.15 w=1 nf=1 m=1
M5 net0 net0 VDD VDD pch l=0.15 w=1 nf=1 m=1
M6 net0 net1 VSS VSS nch l=0.15 w=1 nf=1 m=1
MREF net1 net1 VSS VSS nch l=0.15 w=1 nf=1 m=1
R1 Vcont net4 1k
.ends dut
