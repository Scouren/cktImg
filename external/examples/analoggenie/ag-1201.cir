* official Analog Canvas netlist; PDK X cards rewritten by convert.py
.model nch nmos
.model pch pmos

.subckt EA1 VDD VSS VB1 VB2 VREF VFP1 VEA VX1
MN1 net9 VB5 net5 VSS nch l=0.15 w=1 nf=1 m=1
MN10 VX1 net0 VSS VSS nch l=0.15 w=1 nf=1 m=1
MN11 net10 net0 VSS VSS nch l=0.15 w=1 nf=1 m=1
MN12 VB5 VB5 net7 VSS nch l=0.15 w=1 nf=1 m=1
MN13 net7 VB5 VSS VSS nch l=0.15 w=1 nf=1 m=1
MN14 net2 VB3 VSS VSS nch l=0.15 w=1 nf=1 m=1
MN15 net4 VB3 VSS VSS nch l=0.15 w=1 nf=1 m=1
MN2 net1 VB5 net6 VSS nch l=0.15 w=1 nf=1 m=1
MN3 net0 VB5 VX1 VSS nch l=0.15 w=1 nf=1 m=1
MN4 VEA VB5 net10 VSS nch l=0.15 w=1 nf=1 m=1
MN8 net5 net1 VSS VSS nch l=0.15 w=1 nf=1 m=1
MN9 net6 net1 VSS VSS nch l=0.15 w=1 nf=1 m=1
MP1 net11 net9 VDD VDD pch l=0.15 w=1 nf=1 m=1
MP10 net0 VFP1 net8 VDD pch l=0.15 w=1 nf=1 m=1
MP11 VB5 net2 VDD VDD pch l=0.15 w=1 nf=1 m=1
MP12 net2 net2 VDD VDD pch l=0.15 w=1 nf=1 m=1
MP13 VB3 net2 VDD VDD pch l=0.15 w=1 nf=1 m=1
MP2 net3 net9 VDD VDD pch l=0.15 w=1 nf=1 m=1
MP6 net9 VB1 net11 VDD pch l=0.15 w=1 nf=1 m=1
MP7 VEA VB1 net3 VDD pch l=0.15 w=1 nf=1 m=1
MP8 net8 VB2 VDD VDD pch l=0.15 w=1 nf=1 m=1
MP9 net1 VREF net8 VDD pch l=0.15 w=1 nf=1 m=1
RBIAS VB3 net4 1k
.ends EA1

.subckt ISR VDD VSS VB4 VISR VEA VX1
MN5 net0 net0 VSS VSS nch l=0.15 w=1 nf=1 m=1
MN6 net1 net0 VSS VSS nch l=0.15 w=1 nf=1 m=1
MN7 net0 VB4 VSS VSS nch l=0.15 w=1 nf=1 m=1
MP3 net0 VEA VISR VDD pch l=0.15 w=1 nf=1 m=1
MP4 net1 net1 VISR VDD pch l=0.15 w=1 nf=1 m=1
MP5 VX1 net1 VISR VDD pch l=0.15 w=1 nf=1 m=1
.ends ISR

.subckt dut VDD VSS VIN VP VG5 VG1 VG2 VG4 VG3 VREF VB4 VB1 VB2
.model DIODE D(IS=1e-14 N=1)
CFLY VX1 VX2 1p
CO VP VN 1p
COP VP VSS 1p
D1 VN VX2 DIODE
L1 VX1 VX3 1n
M1 VX1 VG1 VIN VDD pch l=0.15 w=1 nf=1 m=1
M2 VX2 VG2 VIN VDD pch l=0.15 w=1 nf=1 m=1
M3 VP VG3 VX3 VDD pch l=0.15 w=1 nf=1 m=1
M4 VX3 VG4 VSS VSS nch l=0.15 w=1 nf=1 m=1
M5 VISR VG5 VIN VDD pch l=0.15 w=1 nf=1 m=1
R1 VP VFP1 1k
R2 VFP1 VSS 1k
X1 VDD VSS VB1 VB2 VREF VFP1 net0 VX1 EA1
X2 VDD VSS VB4 VISR net0 VX1 ISR
.ends dut
