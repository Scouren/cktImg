* official Analog Canvas netlist; PDK X cards rewritten by convert.py
.model nch nmos
.model pch pmos

.subckt dut VDD VSS GND vin vout
CL vout GND 1p
I1 VDD net2 DC 200uA
M1 net0 vout net3 VSS nch l=0.15 w=1 nf=1 m=1
M10 net2 net2 VSS VSS nch l=0.15 w=1 nf=1 m=1
M2 net1 vin net3 VSS nch l=0.15 w=1 nf=1 m=1
M3 net0 net0 VDD VDD pch l=0.15 w=1 nf=1 m=1
M4 net1 net1 VDD VDD pch l=0.15 w=1 nf=1 m=1
M5 net3 net2 VSS VSS nch l=0.15 w=1 nf=1 m=1
M6 vout net1 VDD VDD pch l=0.15 w=1 nf=1 m=1
M7 vout net4 VSS VSS nch l=0.15 w=1 nf=1 m=1
M8 net4 net0 VDD VDD pch l=0.15 w=1 nf=1 m=1
M9 net4 net4 VSS VSS nch l=0.15 w=1 nf=1 m=1
.ends dut
