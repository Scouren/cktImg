* official Analog Canvas netlist; PDK X cards rewritten by convert.py
.model nch nmos
.model pch pmos

.subckt dut VDD VSS Vb1 Vin VBIAS vOUT
Cc net1 vOUT 1p
M10 net0 net0 VSS VSS nch l=0.15 w=1 nf=1 m=1
M11 net0 Vb1 VDD VDD pch l=0.15 w=1 nf=1 m=1
M4 net1 Vb1 VDD VDD pch l=0.15 w=1 nf=1 m=1
M6 vOUT Vin VSS VSS nch l=0.15 w=1 nf=1 m=1
M7 vOUT Vb1 VDD VDD pch l=0.15 w=1 nf=1 m=1
M8 Vin VBIAS net1 VDD pch l=0.15 w=1 nf=1 m=1
M9 Vin net0 VSS VSS nch l=0.15 w=1 nf=1 m=1
.ends dut
