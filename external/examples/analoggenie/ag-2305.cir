* official Analog Canvas netlist; PDK X cards rewritten by convert.py
.model nch nmos
.model pch pmos

.subckt bias VDD VSS VBN VB4
M22 VBN VP VDD VDD pch l=0.15 w=1 nf=1 m=1
M23 VBN VBN net2 VSS nch l=0.15 w=1 nf=1 m=1
M24 net2 VBN VSS VSS nch l=0.15 w=1 nf=1 m=1
M25 net0 VP VDD VDD pch l=0.15 w=1 nf=1 m=1
M26 net0 net0 VSS VSS nch l=0.15 w=1 nf=1 m=1
M27 VP VP VDD VDD pch l=0.15 w=1 nf=1 m=1
M28 VP VB4 net1 VSS nch l=0.15 w=1 nf=1 m=1
M29 net1 net0 VSS VSS nch l=0.15 w=1 nf=1 m=1
M30 VB4 VP VDD VDD pch l=0.15 w=1 nf=1 m=1
M31 VB4 VB4 VSS VSS nch l=0.15 w=1 nf=1 m=1
.ends bias

.subckt dut VDD VSS VREF VB2 VB1 VB3 VB5 IBUF VIN VOUT VB4
CL VOUT net6 1p
M10 EAO VB3 net7 VDD pch l=0.15 w=1 nf=1 m=1
M11 net0 VB1 VDD VDD pch l=0.15 w=1 nf=1 m=1
M12 net7 VB1 VDD VDD pch l=0.15 w=1 nf=1 m=1
M13 VX VB5 VDD VDD pch l=0.15 w=1 nf=1 m=1
M14 net1 EAO VX VDD pch l=0.15 w=1 nf=1 m=1
M15 net1 net1 VSS VSS nch l=0.15 w=1 nf=1 m=1
M16 GATE net1 VSS VSS nch l=0.15 w=1 nf=1 m=1
M17 VDD VX GATE VSS nch l=0.15 w=1 nf=1 m=1
M18 net4 EAO IBUF VSS nch l=0.15 w=1 nf=1 m=1
M19 net4 net4 VDD VDD pch l=0.15 w=1 nf=1 m=1
M2 net5 VB2 VSS VSS nch l=0.15 w=1 nf=1 m=1
M20 GATE net4 VDD VDD pch l=0.15 w=1 nf=1 m=1
M21 VSS IBUF GATE VDD pch l=0.15 w=1 nf=1 m=1
M3 net7 VREF net5 VSS nch l=0.15 w=1 nf=1 m=1
M4 net0 FB net5 VSS nch l=0.15 w=1 nf=1 m=1
M5 net8 net3 VSS VSS nch l=0.15 w=1 nf=1 m=1
M6 net2 net3 VSS VSS nch l=0.15 w=1 nf=1 m=1
M7 net3 VBN net8 VSS nch l=0.15 w=1 nf=1 m=1
M8 EAO VBN net2 VSS nch l=0.15 w=1 nf=1 m=1
M9 net3 VB3 net0 VDD pch l=0.15 w=1 nf=1 m=1
MNP VIN GATE VOUT VSS nch l=0.15 w=1 nf=1 m=1
R1 FB VSS 1k
R2 VOUT FB 1k
R3 net6 VSS 1k
RL VOUT VSS 1k
X1 VDD VSS VBN VB4 bias
.ends dut
