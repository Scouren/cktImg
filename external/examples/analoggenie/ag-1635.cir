* official Analog Canvas netlist; PDK X cards rewritten by convert.py
.model nch nmos
.model pch pmos
.model qpnp pnp

.subckt opamp VDD VSS INN INP OUT
M1 net2 INN net0 VSS nch l=0.15 w=1 nf=1 m=1
M10 net1 net1 net5 VSS nch l=0.15 w=1 nf=1 m=1
M11 net4 net1 VSS VSS nch l=0.15 w=1 nf=1 m=1
M12 net4 net4 VDD VDD pch l=0.15 w=1 nf=1 m=1
M13 VB2 net4 VDD VDD pch l=0.15 w=1 nf=1 m=1
M14 VB2 VB2 VSS VSS nch l=0.15 w=1 nf=1 m=1
M15 VB1 VB2 VSS VSS nch l=0.15 w=1 nf=1 m=1
M16 VB1 VB1 VDD VDD pch l=0.15 w=1 nf=1 m=1
M2 net3 INP net0 VSS nch l=0.15 w=1 nf=1 m=1
M3 net2 net2 VDD VDD pch l=0.15 w=1 nf=1 m=1
M4 net3 net3 VDD VDD pch l=0.15 w=1 nf=1 m=1
M5 VX net2 VDD VDD pch l=0.15 w=1 nf=1 m=1
M6 OUT net3 VDD VDD pch l=0.15 w=1 nf=1 m=1
M7 VX VX VSS VSS nch l=0.15 w=1 nf=1 m=1
M8 OUT VX VSS VSS nch l=0.15 w=1 nf=1 m=1
M9 net0 VB2 VSS VSS nch l=0.15 w=1 nf=1 m=1
R1 VDD net1 1k
R2 net5 VSS 1k
.ends opamp

.subckt dut VDD VSS Vout
Q1 VSS VSS X qpnp m=1
Q2 VSS VSS net0 qpnp m=1
R1 Vout X 1k
R2 Vout Y 1k
R3 Y net0 1k
X1 VDD VSS Y X Vout opamp
.ends dut
