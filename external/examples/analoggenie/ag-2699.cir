* official Analog Canvas netlist; PDK X cards rewritten by convert.py
.model nch nmos
.model pch pmos

.subckt opamp VDD VSS vn vp vcx vo
M10 net0 net0 VSS VSS nch l=0.15 w=1 nf=1 m=1
M11 vo net0 VSS VSS nch l=0.15 w=1 nf=1 m=1
M12 VB2 VB2 VDD VDD pch l=0.15 w=1 nf=1 m=1
M13 net2 VB2 VDD VDD pch l=0.15 w=1 nf=1 m=1
M14 net5 VB2 VDD VDD pch l=0.15 w=1 nf=1 m=1
M15 net4 VB2 VDD VDD pch l=0.15 w=1 nf=1 m=1
M16 net3 net3 VDD VDD pch l=0.15 w=1 nf=1 m=1
M17 VB3 net3 VDD VDD pch l=0.15 w=1 nf=1 m=1
M18 VB2 net7 VSS VSS nch l=0.15 w=1 nf=1 m=1
M19 net2 net2 net7 VSS nch l=0.15 w=1 nf=1 m=1
M20 net7 net2 net6 VSS nch l=0.15 w=1 nf=1 m=1
M21 net5 net5 net6 VSS nch l=0.15 w=1 nf=1 m=1
M22 net6 net5 net4 VSS nch l=0.15 w=1 nf=1 m=1
M23 net4 net4 VSS VSS nch l=0.15 w=1 nf=1 m=1
M24 net3 net4 VSS VSS nch l=0.15 w=1 nf=1 m=1
M25 VB3 VB3 VSS VSS nch l=0.15 w=1 nf=1 m=1
M3 net0 vcx VDD VDD pch l=0.15 w=1 nf=1 m=1
M4 vcx vcx VDD VDD pch l=0.15 w=1 nf=1 m=1
M5 net1 net1 VDD VDD pch l=0.15 w=1 nf=1 m=1
M6 vo net1 VDD VDD pch l=0.15 w=1 nf=1 m=1
M7 vcx vn net8 VSS nch l=0.15 w=1 nf=1 m=1
M8 net1 vp net8 VSS nch l=0.15 w=1 nf=1 m=1
M9 net8 VB3 VSS VSS nch l=0.15 w=1 nf=1 m=1
.ends opamp

.subckt dut VDD VSS vci vco phi1 phi2
C1 vcx VSS 1p
C2 net0 vco 1p
M1 vci phi1 vcx VSS nch l=0.15 w=1 nf=1 m=1
M2 vcx phi2 net0 VSS nch l=0.15 w=1 nf=1 m=1
X1 VDD VSS net0 VSS vcx vco opamp
.ends dut
