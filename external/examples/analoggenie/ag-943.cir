* official Analog Canvas netlist; PDK X cards rewritten by convert.py
.model nch nmos
.model pch pmos

.subckt dut VDD VSS Iout
.model DIODE D(IS=1e-14 N=1)
D1 net3 VSS DIODE
D2 net4 VSS DIODE
M1 net2 net2 net3 VSS nch l=0.15 w=1 nf=1 m=1
M2 net1 net2 net0 VSS nch l=0.15 w=1 nf=1 m=1
M3 net2 net1 VDD VDD pch l=0.15 w=1 nf=1 m=1
M4 net1 net1 VDD VDD pch l=0.15 w=1 nf=1 m=1
M5 Iout net1 VDD VDD pch l=0.15 w=1 nf=1 m=1
R net0 net4 1k
.ends dut
