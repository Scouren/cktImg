* official Analog Canvas netlist; PDK X cards rewritten by convert.py
.model nch nmos
.model pch pmos

.subckt opamp VDD VSS INN INP OUT VX VB1
M10 net4 INP VX VDD pch l=0.15 w=1 nf=1 m=1
M11 OUT INN VX VDD pch l=0.15 w=1 nf=1 m=1
M12 net4 VB2 net0 VSS nch l=0.15 w=1 nf=1 m=1
M13 OUT VB2 net1 VSS nch l=0.15 w=1 nf=1 m=1
M14 net0 net4 VSS VSS nch l=0.15 w=1 nf=1 m=1
M15 net1 net4 VSS VSS nch l=0.15 w=1 nf=1 m=1
M3 VB1 VB1 VDD VDD pch l=0.15 w=1 nf=1 m=1
M4 net2 VB1 VDD VDD pch l=0.15 w=1 nf=1 m=1
M5 net3 net3 VDD VDD pch l=0.15 w=1 nf=1 m=1
M6 VB1 net2 VSS VSS nch l=0.15 w=1 nf=1 m=1
M7 net2 net2 VSS VSS nch l=0.15 w=1 nf=1 m=1
M8 net3 net2 VSS VSS nch l=0.15 w=1 nf=1 m=1
M9 VX net3 VDD VDD pch l=0.15 w=1 nf=1 m=1
.ends opamp

.subckt dut VDD VSS vci phi1 phi2 vco VB1
C1 net0 VSS 1p
C2 net1 vco 1p
M1 vci phi1 net0 VSS nch l=0.15 w=1 nf=1 m=1
M2 net0 phi2 net1 VSS nch l=0.15 w=1 nf=1 m=1
X1 VDD VSS net1 VSS vco net0 VB1 opamp
.ends dut
