* official Analog Canvas netlist; PDK X cards rewritten by convert.py
.model nch nmos

.subckt dut VDD VSS LO LO_bar VBB+ VBB- X Y
L1 X Y 1n
M1 X LO VBB- VSS nch l=0.15 w=1 nf=1 m=1
M2 Y LO VBB+ VSS nch l=0.15 w=1 nf=1 m=1
M3 X LO_bar VBB+ VSS nch l=0.15 w=1 nf=1 m=1
M4 Y LO_bar VBB- VSS nch l=0.15 w=1 nf=1 m=1
R1 X Y 1k
.ends dut
