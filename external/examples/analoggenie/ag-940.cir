* official Analog Canvas netlist; PDK X cards rewritten by convert.py
.model nch nmos
.model pch pmos

.subckt dut VDD VSS I5 I6
M1 net1 net0 VSS VSS nch l=0.15 w=1 nf=1 m=1
M2 net2 net1 net0 VSS nch l=0.15 w=1 nf=1 m=1
M3 net1 net2 VDD VDD pch l=0.15 w=1 nf=1 m=1
M4 net2 net2 VDD VDD pch l=0.15 w=1 nf=1 m=1
M5 I5 net2 VDD VDD pch l=0.15 w=1 nf=1 m=1
M6 I6 net0 VSS VSS nch l=0.15 w=1 nf=1 m=1
R net0 VSS 1k
.ends dut
