* official Analog Canvas netlist; PDK X cards rewritten by convert.py
.model nch nmos
.model pch pmos

.subckt dut VDD VSS Vo2 Vo1 Vid2p Vid2n Vid1n Vid1p
CC Vo2 net3 1p
CCR net4 Vo1 1p
I1 VDD net0 DC 1m
I1R VDD net1 DC 1m
I2 net2 VSS DC 1m
I2R net5 VSS DC 1m
I3 VDD Vo2 DC 1m
I3R VDD Vo1 DC 1m
M1 net2 Vid2n net0 VDD pch l=0.15 w=1 nf=1 m=1
M1X net2 Vid1n net1 VDD pch l=0.15 w=1 nf=1 m=1
M2 net5 Vid2p net0 VDD pch l=0.15 w=1 nf=1 m=1
M2X net5 Vid1p net1 VDD pch l=0.15 w=1 nf=1 m=1
M6 Vo1 net5 VSS VSS nch l=0.15 w=1 nf=1 m=1
M9 Vo2 net2 VSS VSS nch l=0.15 w=1 nf=1 m=1
RZ net3 net2 1k
RZR net5 net4 1k
.ends dut
