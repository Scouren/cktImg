* official Analog Canvas netlist; PDK X cards rewritten by convert.py
.model nch nmos
.model pch pmos

.subckt dut VDD VSS biasp biascas biasn Vout Vref VB1 VB2
C1 Vset VSS 1p
C2 n3 Vout 1p
M1 Vout n3 VDD VDD pch l=0.15 w=1 nf=1 m=1
M10 net4 net2 VDD VDD pch l=0.15 w=1 nf=1 m=1
M11 net2 VB2 net5 VDD pch l=0.15 w=1 nf=1 m=1
M12 Vset VB2 net4 VDD pch l=0.15 w=1 nf=1 m=1
M13 net2 VBN2 net3 VSS nch l=0.15 w=1 nf=1 m=1
M14 Vset VBN2 net0 VSS nch l=0.15 w=1 nf=1 m=1
M15 net3 VBN1 VSS VSS nch l=0.15 w=1 nf=1 m=1
M16 net0 VBN1 VSS VSS nch l=0.15 w=1 nf=1 m=1
M17 VBN2 net1 VDD VDD pch l=0.15 w=1 nf=1 m=1
M18 VBN2 VBN2 VBN1 VSS nch l=0.15 w=1 nf=1 m=1
M19 VBN1 VBN1 VSS VSS nch l=0.15 w=1 nf=1 m=1
M2 n1 Vset Vout VDD pch l=0.15 w=1 nf=1 m=1
M20 net1 net1 net6 VDD pch l=0.15 w=1 nf=1 m=1
M3 n1 biasn VSS VSS nch l=0.15 w=1 nf=1 m=1
M4 n3 biasp VDD VDD pch l=0.15 w=1 nf=1 m=1
M5 n3 biascas n1 VSS nch l=0.15 w=1 nf=1 m=1
M6 n3 VB1 VDD VDD pch l=0.15 w=1 nf=1 m=1
M7 net3 Vref n3 VDD pch l=0.15 w=1 nf=1 m=1
M8 net0 fb n3 VDD pch l=0.15 w=1 nf=1 m=1
M9 net5 net2 VDD VDD pch l=0.15 w=1 nf=1 m=1
R1 fb VSS 1k
R2 Vout fb 1k
R3 VDD net6 1k
R4 net1 VSS 1k
.ends dut
