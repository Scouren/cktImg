* official Analog Canvas netlist; PDK X cards rewritten by convert.py
.model nch nmos
.model pch pmos

.subckt dut VDD VSS Vb3 Vb2 Vb1 Vin1 Vin2 Vb4 Vout1 Vout2
C1 Y net3 0.9pF
CC net4 X 1p
I1 net0 VSS DC 20uA
M1 net6 Vin1 net2 VSS nch l=0.15 w=1 nf=1 m=1
M10 Vout2 Y VDD VDD pch l=0.15 w=1 nf=1 m=1
M11 Vout1 net0 VSS VSS nch l=0.15 w=1 nf=1 m=1
M12 Vout2 net0 VSS VSS nch l=0.15 w=1 nf=1 m=1
M13 net2 Vb4 VSS VSS nch l=0.15 w=1 nf=1 m=1
M2 net7 Vin2 net2 VSS nch l=0.15 w=1 nf=1 m=1
M3 X Vb1 net6 VSS nch l=0.15 w=1 nf=1 m=1
M4 Y Vb1 net7 VSS nch l=0.15 w=1 nf=1 m=1
M5 X Vb2 net1 VDD pch l=0.15 w=1 nf=1 m=1
M6 Y Vb2 net5 VDD pch l=0.15 w=1 nf=1 m=1
M7 net1 Vb3 VDD VDD pch l=0.15 w=1 nf=1 m=1
M8 net5 Vb3 VDD VDD pch l=0.15 w=1 nf=1 m=1
M9 Vout1 X VDD VDD pch l=0.15 w=1 nf=1 m=1
R1 net3 Vout2 950Ω
R2 Vout1 net0 1k
R3 net0 Vout2 20kΩ
Rz Vout1 net4 1k
.ends dut
