* official Analog Canvas netlist; PDK X cards rewritten by convert.py
.model nch nmos

.subckt dut VDD VSS Vb1 Vout
C1 net1 net0 1p
L1 VDD Vout 1n
M1 Vout Vb1 net0 VSS nch l=0.15 w=1 nf=1 m=1
RB net0 VSS 1k
RS net2 net1 1k
Vin net2 VSS DC 1
.ends dut
