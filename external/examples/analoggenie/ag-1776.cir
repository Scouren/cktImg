* official Analog Canvas netlist; PDK X cards rewritten by convert.py
.model nch nmos
.model pch pmos
.model qpnp pnp

.subckt A1 VDD VSS INN INP VT OUT VE
M10 OUT VB3 net0 VDD pch l=0.15 w=1 nf=1 m=1
M11 VE VB3 net4 VDD pch l=0.15 w=1 nf=1 m=1
M12 OUT VN net1 VSS nch l=0.15 w=1 nf=1 m=1
M13 VE VN net2 VSS nch l=0.15 w=1 nf=1 m=1
M14 net1 VB2 VSS VSS nch l=0.15 w=1 nf=1 m=1
M15 net2 VB2 VSS VSS nch l=0.15 w=1 nf=1 m=1
M16 VC VC VDD VDD pch l=0.15 w=1 nf=1 m=1
M17 VC VB4 VSS VSS nch l=0.15 w=1 nf=1 m=1
M18 VB4 VC VDD VDD pch l=0.15 w=1 nf=1 m=1
M19 VB4 VB4 VSS VSS nch l=0.15 w=1 nf=1 m=1
M20 VN VC VDD VDD pch l=0.15 w=1 nf=1 m=1
M21 VN VN net3 VSS nch l=0.15 w=1 nf=1 m=1
M22 net3 VN VSS VSS nch l=0.15 w=1 nf=1 m=1
M5 VT VB1 VDD VDD pch l=0.15 w=1 nf=1 m=1
M6 net1 INN VT VDD pch l=0.15 w=1 nf=1 m=1
M7 net2 INP VT VDD pch l=0.15 w=1 nf=1 m=1
M8 net0 VE VDD VDD pch l=0.15 w=1 nf=1 m=1
M9 net4 VE VDD VDD pch l=0.15 w=1 nf=1 m=1
.ends A1

.subckt dut VDD VSS Vout
M1 X net2 VDD VDD pch l=0.15 w=1 nf=1 m=1
M2 Vout net2 VDD VDD pch l=0.15 w=1 nf=1 m=1
M3 net0 net2 VDD VDD pch l=0.15 w=1 nf=1 m=1
M4 VT net2 VDD VDD pch l=0.15 w=1 nf=1 m=1
Q1 VSS VSS net0 qpnp m=1
Q2 VSS net0 X qpnp m=1
Q3 VSS VSS VT qpnp m=1
Q4 VSS VT net1 qpnp m=1
R1 Y net1 1k
R2 Vout Y 1k
X1 VDD VSS X Y VT net2 net1 A1
.ends dut
