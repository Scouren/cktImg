* official Analog Canvas netlist; PDK X cards rewritten by convert.py
.model nch nmos
.model pch pmos
.model qpnp pnp

.subckt dut VDD VSS VB2 VB1 Vout VB3
M1 VG Y net6 VDD pch l=0.15 w=1 nf=1 m=1
M10 net2 VB1 net11 VDD pch l=0.15 w=1 nf=1 m=1
M11 Vout VB1 net10 VDD pch l=0.15 w=1 nf=1 m=1
M12 net2 VB4 net7 VSS nch l=0.15 w=1 nf=1 m=1
M13 Vout VB4 VZ VSS nch l=0.15 w=1 nf=1 m=1
M14 net7 net0 VSS VSS nch l=0.15 w=1 nf=1 m=1
M15 VZ VG VSS VSS nch l=0.15 w=1 nf=1 m=1
M16 net8 net4 VDD VDD pch l=0.15 w=1 nf=1 m=1
M17 net4 net4 VDD VDD pch l=0.15 w=1 nf=1 m=1
M18 VB4 net4 VDD VDD pch l=0.15 w=1 nf=1 m=1
M19 net4 net8 VB3 VSS nch l=0.15 w=1 nf=1 m=1
M2 net0 X net6 VDD pch l=0.15 w=1 nf=1 m=1
M20 net8 VB3 VSS VSS nch l=0.15 w=1 nf=1 m=1
M21 VB4 VB4 net3 VSS nch l=0.15 w=1 nf=1 m=1
M22 net3 VB4 VSS VSS nch l=0.15 w=1 nf=1 m=1
M3 net6 VB2 VDD VDD pch l=0.15 w=1 nf=1 m=1
M4 VG VB4 net5 VSS nch l=0.15 w=1 nf=1 m=1
M5 net0 VB4 Y VSS nch l=0.15 w=1 nf=1 m=1
M6 net5 VG VSS VSS nch l=0.15 w=1 nf=1 m=1
M7 Y net0 VSS VSS nch l=0.15 w=1 nf=1 m=1
M8 net11 net2 VDD VDD pch l=0.15 w=1 nf=1 m=1
M9 net10 net2 VDD VDD pch l=0.15 w=1 nf=1 m=1
Q1 VSS VSS VZ qpnp m=1
Q2 VZ VZ X qpnp m=1
Q3 VSS VSS net1 qpnp m=1
Q4 net1 net1 net9 qpnp m=1
R1 Vout X 1k
R2 Vout Y 1k
R3 Y net9 1k
R4 VB3 VSS 1k
.ends dut
