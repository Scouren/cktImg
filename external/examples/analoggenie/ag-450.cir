* official Analog Canvas netlist; PDK X cards rewritten by convert.py
.model nch nmos
.model pch pmos

.subckt dut VDD VSS Vin Vout Vb
M1 Vout Vb Vin VSS nch l=0.15 w=1 nf=1 m=1
M2 Vout Vout VDD VDD pch l=0.15 w=1 nf=1 m=1
.ends dut
