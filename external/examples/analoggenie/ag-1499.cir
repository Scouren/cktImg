* official Analog Canvas netlist; PDK X cards rewritten by convert.py
.model nch nmos
.model pch pmos
.model qnpn npn

.subckt opamp VDD VSS VB1 INP INN VB2 OUT
M0 net1 VB1 VDD VDD pch l=0.15 w=1 nf=1 m=1
M1 net5 VX VDD VDD pch l=0.15 w=1 nf=1 m=1
M10 net4 VB4 VSS VSS nch l=0.15 w=1 nf=1 m=1
M11 net0 net0 VDD VDD pch l=0.15 w=1 nf=1 m=1
M13 VB4 VB4 VSS VSS nch l=0.15 w=1 nf=1 m=1
M14 VB3 net0 VDD VDD pch l=0.15 w=1 nf=1 m=1
M15 VB3 VB3 VB4 VSS nch l=0.15 w=1 nf=1 m=1
M2 net2 VX VDD VDD pch l=0.15 w=1 nf=1 m=1
M3 net4 INP net1 VDD pch l=0.15 w=1 nf=1 m=1
M4 net3 INN net1 VDD pch l=0.15 w=1 nf=1 m=1
M5 OUT VB2 net5 VDD pch l=0.15 w=1 nf=1 m=1
M6 VX VB2 net2 VDD pch l=0.15 w=1 nf=1 m=1
M7 OUT VB3 net3 VSS nch l=0.15 w=1 nf=1 m=1
M8 VX VB3 net4 VSS nch l=0.15 w=1 nf=1 m=1
M9 net3 VB4 VSS VSS nch l=0.15 w=1 nf=1 m=1
R1 net0 VSS 1k
.ends opamp

.subckt dut VDD VSS Vout VB1 VB2
Q1 X X VSS VSS qnpn m=1
Q2 net0 net0 VSS VSS qnpn m=1
R1 Vout X 1k
R2 Vout Y 1k
R3 Y net0 1k
X1 VDD VSS VB1 X Y VB2 Vout opamp
.ends dut
