* official Analog Canvas netlist; PDK X cards rewritten by convert.py
.model nch nmos
.model pch pmos
.model qpnp pnp

.subckt dut VDD VSS Vout VB2 VB1
M1 net9 VB2 VDD VDD pch l=0.15 w=1 nf=1 m=1
M10 Vout VB3 VQ VSS nch l=0.15 w=1 nf=1 m=1
M11 VQ net7 VSS VSS nch l=0.15 w=1 nf=1 m=1
M12 net2 net0 VDD VDD pch l=0.15 w=1 nf=1 m=1
M13 net0 VB1 net2 VDD pch l=0.15 w=1 nf=1 m=1
M14 net0 VB3 net5 VSS nch l=0.15 w=1 nf=1 m=1
M15 net5 VN1 VSS VSS nch l=0.15 w=1 nf=1 m=1
M16 net4 net4 VDD VDD pch l=0.15 w=1 nf=1 m=1
M17 VB3 net4 VDD VDD pch l=0.15 w=1 nf=1 m=1
M18 VB3 VB3 net6 VSS nch l=0.15 w=1 nf=1 m=1
M19 net6 VB3 VSS VSS nch l=0.15 w=1 nf=1 m=1
M2 VN1 X net9 VDD pch l=0.15 w=1 nf=1 m=1
M3 net7 Y net9 VDD pch l=0.15 w=1 nf=1 m=1
M4 VN1 VB3 Y VSS nch l=0.15 w=1 nf=1 m=1
M5 net7 VB3 net1 VSS nch l=0.15 w=1 nf=1 m=1
M6 Y VN1 VSS VSS nch l=0.15 w=1 nf=1 m=1
M7 net1 net7 VSS VSS nch l=0.15 w=1 nf=1 m=1
M8 net8 net0 VDD VDD pch l=0.15 w=1 nf=1 m=1
M9 Vout VB1 net8 VDD pch l=0.15 w=1 nf=1 m=1
Q1 VSS VSS VQ qpnp m=1
Q2 VQ VQ X qpnp m=1
Q3 VSS VSS net10 qpnp m=1
Q4 net10 net10 net3 qpnp m=1
R1 Vout X 1k
R2 Vout Y 1k
R3 Y net3 1k
R4 net4 VSS 1k
.ends dut
