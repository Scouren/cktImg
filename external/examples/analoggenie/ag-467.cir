* official Analog Canvas netlist; PDK X cards rewritten by convert.py
.model nch nmos

.subckt dut VDD VSS Vb Vout
C1 Vout VSS 1p
L1 VDD Vout 1n
M1 Vout Vb X VSS nch l=0.15 w=1 nf=1 m=1
R1 VDD Vout 1k
RS net0 X 1k
Vin net0 VSS DC 1
.ends dut
