* official Analog Canvas netlist; PDK X cards rewritten by convert.py
.model nch nmos
.model pch pmos

.subckt dut VDD VSS In Peak
C1 Peak VSS 100nF
I1 VDD net3 DC 10uA
I2 VDD net2 DC 10uA
M1 net1 In net3 VDD pch l=2 w=10 nf=1 m=1
M2 net0 Peak net3 VDD pch l=2 w=10 nf=1 m=1
M3 net1 net0 VSS VSS nch l=5 w=5 nf=1 m=1
M4 net0 net0 VSS VSS nch l=5 w=5 nf=1 m=1
M5 net2 net1 VSS VSS nch l=5 w=5 nf=1 m=2
M6 VDD net2 net4 VSS nch l=0.35 w=10 nf=1 m=1
R1 net4 Peak 1kΩ
.ends dut
