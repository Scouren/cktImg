* official Analog Canvas netlist; PDK X cards rewritten by convert.py
.model nch nmos
.model pch pmos

.subckt dut VDD VSS VB1 VREF VB2 VB4 VB6 VB5 VB3 VOUT VIN
CF1 VOUT VFB 1p
Cm1 VOUT VO1 1p
Cm2 VO1 VT 1p
M11 VT VB2 VSS VSS nch l=0.15 w=1 nf=1 m=1
M12 net7 VFB VT VSS nch l=0.15 w=1 nf=1 m=1
M13 net2 VREF VT VSS nch l=0.15 w=1 nf=1 m=1
M14 net4 net6 VSS VSS nch l=0.15 w=1 nf=1 m=1
M15 net0 net6 VSS VSS nch l=0.15 w=1 nf=1 m=1
M16 VC VB4 VIN VDD pch l=0.15 w=1 nf=1 m=1
M17 VC VC VSS VSS nch l=0.15 w=1 nf=1 m=1
M18 VC VO1 VSS VSS nch l=0.15 w=1 nf=1 m=1
M19 net6 VN net4 VSS nch l=0.15 w=1 nf=1 m=1
M20 VO1 VN net0 VSS nch l=0.15 w=1 nf=1 m=1
M21 VG2 VO1 VSS VSS nch l=0.15 w=1 nf=1 m=1
M22 VG1 VC VSS VSS nch l=0.15 w=1 nf=1 m=1
M23 VG2 VG2 VIN VDD pch l=0.15 w=1 nf=1 m=1
M24 VG1 VG2 VIN VDD pch l=0.15 w=1 nf=1 m=1
M25 net5 net2 VIN VDD pch l=0.15 w=1 nf=1 m=1
M26 net11 net2 VIN VDD pch l=0.15 w=1 nf=1 m=1
M27 VG1 net7 VIN VDD pch l=0.15 w=1 nf=1 m=1
M28 VG2 net7 VIN VDD pch l=0.15 w=1 nf=1 m=1
M29 net2 VB1 net5 VDD pch l=0.15 w=1 nf=1 m=1
M30 net6 VB1 net11 VDD pch l=0.15 w=1 nf=1 m=1
M31 net7 VB1 VG1 VDD pch l=0.15 w=1 nf=1 m=1
M32 VO1 VB1 VG2 VDD pch l=0.15 w=1 nf=1 m=1
M33 VN net3 VIN VDD pch l=0.15 w=1 nf=1 m=1
M34 net3 net3 VIN VDD pch l=0.15 w=1 nf=1 m=1
M35 VB3 net3 VIN VDD pch l=0.15 w=1 nf=1 m=1
M36 net3 VB3 net9 VSS nch l=0.15 w=1 nf=1 m=1
M37 VB3 VB3 VSS VSS nch l=0.15 w=1 nf=1 m=1
M38 VN VN net10 VSS nch l=0.15 w=1 nf=1 m=1
M39 net10 VN VSS VSS nch l=0.15 w=1 nf=1 m=1
MD1 VT VO1 VSS VSS nch l=0.15 w=1 nf=1 m=1
MD2 net12 VB5 VSS VSS nch l=0.15 w=1 nf=1 m=1
MD3 net8 VT net12 VSS nch l=0.15 w=1 nf=1 m=1
MD4 net1 VB6 net12 VSS nch l=0.15 w=1 nf=1 m=1
MD5 VT net1 VIN VDD pch l=0.15 w=1 nf=1 m=1
MD6 net1 net1 VIN VDD pch l=0.15 w=1 nf=1 m=1
MD7 net8 net8 VIN VDD pch l=0.15 w=1 nf=1 m=1
MPT VOUT VG1 VIN VDD pch l=0.15 w=1 nf=1 m=1
R1 net9 VSS 1k
RF1 VOUT VFB 1k
RF2 VFB VSS 1k
.ends dut
