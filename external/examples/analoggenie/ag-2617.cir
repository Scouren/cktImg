* official Analog Canvas netlist; PDK X cards rewritten by convert.py
.model nch nmos
.model pch pmos

.subckt opamp VDD VSS INP INN IB OUT
M10 INN INP net0 VSS nch l=0.15 w=1 nf=1 m=1
M11 net1 INN net0 VSS nch l=0.15 w=1 nf=1 m=1
M12 net0 IB VSS VSS nch l=0.15 w=1 nf=1 m=1
M13 OUT net2 VSS VSS nch l=0.15 w=1 nf=1 m=1
M14 net2 net2 VSS VSS nch l=0.15 w=1 nf=1 m=1
M6 OUT INN VDD VDD pch l=0.15 w=1 nf=1 m=1
M7 INN INN VDD VDD pch l=0.15 w=1 nf=1 m=1
M8 net1 net1 VDD VDD pch l=0.15 w=1 nf=1 m=1
M9 net2 net1 VDD VDD pch l=0.15 w=1 nf=1 m=1
.ends opamp

.subckt dut VDD VSS biasp biascas biasn Vref Vout VB1 VB2
C1 Vset VSS 1p
C2 n3 Vout 1p
M1 Vout n3 VDD VDD pch l=0.15 w=1 nf=1 m=1
M15 VB2 VB2 VDD VDD pch l=0.15 w=1 nf=1 m=1
M16 net1 VB2 VDD VDD pch l=0.15 w=1 nf=1 m=1
M17 net0 net0 VDD VDD pch l=0.15 w=1 nf=1 m=1
M18 VBN net0 VDD VDD pch l=0.15 w=1 nf=1 m=1
M19 VB1 VB1 VDD VDD pch l=0.15 w=1 nf=1 m=1
M2 n1 Vset Vout VDD pch l=0.15 w=1 nf=1 m=1
M20 VB2 net1 VSS VSS nch l=0.15 w=1 nf=1 m=1
M21 net1 net1 VSS VSS nch l=0.15 w=1 nf=1 m=1
M22 net0 net1 VSS VSS nch l=0.15 w=1 nf=1 m=1
M23 VBN VBN VSS VSS nch l=0.15 w=1 nf=1 m=1
M24 VB1 VBN VSS VSS nch l=0.15 w=1 nf=1 m=1
M3 n1 biasn VSS VSS nch l=0.15 w=1 nf=1 m=1
M4 n3 biasp VDD VDD pch l=0.15 w=1 nf=1 m=1
M5 n3 biascas n1 VSS nch l=0.15 w=1 nf=1 m=1
R1 fb VSS 1k
R2 Vout fb 1k
X1 VDD VSS Vref fb VBN Vset opamp
.ends dut
