* official Analog Canvas netlist; PDK X cards rewritten by convert.py
.model nch nmos
.model pch pmos
.model qpnp pnp

.subckt A1 VDD VSS INN INP OUT VP VE
M10 OUT VB2 net4 VDD pch l=0.15 w=1 nf=1 m=1
M11 VE VB2 net1 VDD pch l=0.15 w=1 nf=1 m=1
M12 OUT VB5 net3 VSS nch l=0.15 w=1 nf=1 m=1
M13 VE VB5 net5 VSS nch l=0.15 w=1 nf=1 m=1
M14 net3 VB6 VSS VSS nch l=0.15 w=1 nf=1 m=1
M15 net5 VB6 VSS VSS nch l=0.15 w=1 nf=1 m=1
M16 net0 net2 VDD VDD pch l=0.15 w=1 nf=1 m=1
M17 net2 net2 VDD VDD pch l=0.15 w=1 nf=1 m=1
M18 VB4 net2 VDD VDD pch l=0.15 w=1 nf=1 m=1
M19 VB5 net2 VDD VDD pch l=0.15 w=1 nf=1 m=1
M20 net0 net0 VSS VSS nch l=0.15 w=1 nf=1 m=1
M21 net2 VB4 VB3 VSS nch l=0.15 w=1 nf=1 m=1
M22 VB3 net0 VSS VSS nch l=0.15 w=1 nf=1 m=1
M23 VB4 VB3 VSS VSS nch l=0.15 w=1 nf=1 m=1
M24 VB5 VB5 VB6 VSS nch l=0.15 w=1 nf=1 m=1
M25 VB6 VB6 VSS VSS nch l=0.15 w=1 nf=1 m=1
M5 VP VB1 VDD VDD pch l=0.15 w=1 nf=1 m=1
M6 net3 INN VP VDD pch l=0.15 w=1 nf=1 m=1
M7 net5 INP VP VDD pch l=0.15 w=1 nf=1 m=1
M8 net4 VE VDD VDD pch l=0.15 w=1 nf=1 m=1
M9 net1 VE VDD VDD pch l=0.15 w=1 nf=1 m=1
.ends A1

.subckt dut VDD VSS Vout
M1 X net0 VDD VDD pch l=0.15 w=1 nf=1 m=1
M2 Vout net0 VDD VDD pch l=0.15 w=1 nf=1 m=1
M3 net2 net0 VDD VDD pch l=0.15 w=1 nf=1 m=1
M4 VP net0 VDD VDD pch l=0.15 w=1 nf=1 m=1
Q1 VSS VSS net2 qpnp m=1
Q2 VSS net2 X qpnp m=1
Q3 VSS VSS VP qpnp m=1
Q4 VSS VP net1 qpnp m=1
R1 Y net1 1k
R2 Vout Y 1k
X1 VDD VSS X Y net0 VP net1 A1
.ends dut
