* official Analog Canvas netlist; PDK X cards rewritten by convert.py
.model nch nmos
.model pch pmos

.subckt dut VDD VSS Vctrl1 Vctrl2 Voutp Voutn
C1 net2 Vctrl2 1p
C2 net3 Vctrl2 1p
M1 net0 net1 net2 VSS nch l=0.15 w=1 nf=1 m=1
M10 Voutn net3 VSS VSS nch l=0.15 w=1 nf=1 m=1
M2 net1 net0 net3 VSS nch l=0.15 w=1 nf=1 m=1
M3 VDD net1 net2 VSS nch l=0.15 w=1 nf=1 m=1
M4 VDD net0 net3 VSS nch l=0.15 w=1 nf=1 m=1
M5 net1 Vctrl1 VDD VDD pch l=0.15 w=1 nf=1 m=1
M6 net0 Vctrl1 VDD VDD pch l=0.15 w=1 nf=1 m=1
M7 net2 net3 VSS VSS nch l=0.15 w=1 nf=1 m=1
M8 net3 net2 VSS VSS nch l=0.15 w=1 nf=1 m=1
M9 Voutp net2 VSS VSS nch l=0.15 w=1 nf=1 m=1
.ends dut
