* official Analog Canvas netlist; PDK X cards rewritten by convert.py
.model nch nmos
.model pch pmos

.subckt BIAS VDD VSS VB4 VB2
M21 net3 VB5 VDD VDD pch l=0.15 w=1 nf=1 m=1
M22 net3 net3 VSS VSS nch l=0.15 w=1 nf=1 m=1
M23 VB4 net3 VSS VSS nch l=0.15 w=1 nf=1 m=1
M24 VB4 VB4 VDD VDD pch l=0.15 w=1 nf=1 m=1
M25 VB1 VB4 VDD VDD pch l=0.15 w=1 nf=1 m=1
M26 VB1 VB1 VSS VSS nch l=0.15 w=1 nf=1 m=1
M27 VB5 VB5 VDD VDD pch l=0.15 w=1 nf=1 m=1
M28 net2 VB5 VDD VDD pch l=0.15 w=1 nf=1 m=1
M29 VB5 net4 VSS VSS nch l=0.15 w=1 nf=1 m=1
M30 net2 net2 net4 VSS nch l=0.15 w=1 nf=1 m=1
M31 net4 net2 net1 VSS nch l=0.15 w=1 nf=1 m=1
M32 net0 VB5 VDD VDD pch l=0.15 w=1 nf=1 m=1
M33 VB2 VB5 VDD VDD pch l=0.15 w=1 nf=1 m=1
M34 net0 net0 net1 VSS nch l=0.15 w=1 nf=1 m=1
M35 net1 net0 VB2 VSS nch l=0.15 w=1 nf=1 m=1
M36 VB2 VB2 VSS VSS nch l=0.15 w=1 nf=1 m=1
.ends BIAS

.subckt EA VDD VSS VB4 INN INP VX2 TOP VB3 ISR
M10 VCTRL net1 VDD VDD pch l=0.15 w=1 nf=1 m=1
M11 net1 VX2 VSS VSS nch l=0.15 w=1 nf=1 m=1
M12 VCTRL net2 VSS VSS nch l=0.15 w=1 nf=1 m=1
M13 net2 net2 VSS VSS nch l=0.15 w=1 nf=1 m=1
M14 VX2 VX2 VSS VSS nch l=0.15 w=1 nf=1 m=1
M15 net0 VCTRL TOP VDD pch l=0.15 w=1 nf=1 m=1
M16 net0 net0 VSS VSS nch l=0.15 w=1 nf=1 m=1
M17 net4 net0 VSS VSS nch l=0.15 w=1 nf=1 m=1
M18 net0 VB3 VSS VSS nch l=0.15 w=1 nf=1 m=1
M19 net4 net4 TOP VDD pch l=0.15 w=1 nf=1 m=1
M20 ISR net4 TOP VDD pch l=0.15 w=1 nf=1 m=1
M6 net3 VB4 VDD VDD pch l=0.15 w=1 nf=1 m=1
M7 net2 INN net3 VDD pch l=0.15 w=1 nf=1 m=1
M8 VX2 INP net3 VDD pch l=0.15 w=1 nf=1 m=1
M9 net1 net1 VDD VDD pch l=0.15 w=1 nf=1 m=1
.ends EA

.subckt dut VDD VSS VIN VC5 VC1 VC2 VC3 VC4 VB3 VREF VP VB2
.model DIODE D(IS=1e-14 N=1)
CFLY VX1 VX2 1p
CO VP VN 1p
COP VP VSS 1p
D1 VN VX2 DIODE
L1 VX1 VX3 1n
M1 VX1 VC1 VIN VDD pch l=0.15 w=1 nf=1 m=1
M2 VX2 VC2 VIN VDD pch l=0.15 w=1 nf=1 m=1
M3 VP VC3 VX3 VDD pch l=0.15 w=1 nf=1 m=1
M4 VX3 VC4 VSS VSS nch l=0.15 w=1 nf=1 m=1
M5 net0 VC5 VIN VDD pch l=0.15 w=1 nf=1 m=1
R1 VP VFP1 1k
R2 VFP1 VSS 1k
X1 VDD VSS VB4 VFP1 VREF VX2 net0 VB3 VX1 EA
X2 VDD VSS VB4 VB2 BIAS
.ends dut
