* official Analog Canvas netlist; PDK X cards rewritten by convert.py
.model pch pmos

.subckt dut VDD VSS X Y
I1 Vb2 VSS DC 15uA
I2 Vb3 VSS DC 15uA
M17 net3 Vb3 VDD VDD pch l=0.15 w=1 nf=1 m=1
M18 Vb3 Vb2 net3 net3 pch l=0.15 w=1 nf=1 m=1
M19 net0 Vb2 VDD VDD pch l=0.15 w=1 nf=1 m=1
M20 Vb2 Vb2 net0 net0 pch l=0.15 w=1 nf=1 m=1
M5 X Vb2 net2 net2 pch l=0.15 w=1 nf=1 m=1
M6 Y Vb2 net1 net1 pch l=0.15 w=1 nf=1 m=1
M7 net2 Vb3 VDD VDD pch l=0.15 w=1 nf=1 m=1
M8 net1 Vb3 VDD VDD pch l=0.15 w=1 nf=1 m=1
.ends dut
