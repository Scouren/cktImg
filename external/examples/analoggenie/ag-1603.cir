* official Analog Canvas netlist; PDK X cards rewritten by convert.py
.model nch nmos
.model pch pmos
.model qpnp pnp

.subckt opamp VDD VSS VB1 INN INP OUT VB2 VB3
M10 net8 net3 VDD VDD pch l=0.15 w=1 nf=1 m=1
M11 OUT VB3 net8 VDD pch l=0.15 w=1 nf=1 m=1
M12 OUT VB5 net0 VSS nch l=0.15 w=1 nf=1 m=1
M13 net0 VB2 VSS VSS nch l=0.15 w=1 nf=1 m=1
M14 net6 VB6 VDD VDD pch l=0.15 w=1 nf=1 m=1
M15 net6 net6 VSS VSS nch l=0.15 w=1 nf=1 m=1
M16 VB6 VB6 VDD VDD pch l=0.15 w=1 nf=1 m=1
M17 VB6 VB4 net4 VSS nch l=0.15 w=1 nf=1 m=1
M18 net4 net6 VSS VSS nch l=0.15 w=1 nf=1 m=1
M19 VB4 VB6 VDD VDD pch l=0.15 w=1 nf=1 m=1
M20 VB4 VB4 VSS VSS nch l=0.15 w=1 nf=1 m=1
M21 VB5 VB6 VDD VDD pch l=0.15 w=1 nf=1 m=1
M22 VB5 VB5 net2 VSS nch l=0.15 w=1 nf=1 m=1
M23 net2 VB5 VSS VSS nch l=0.15 w=1 nf=1 m=1
M3 net7 VB1 VDD VDD pch l=0.15 w=1 nf=1 m=1
M4 net0 INN net7 VDD pch l=0.15 w=1 nf=1 m=1
M5 net1 INP net7 VDD pch l=0.15 w=1 nf=1 m=1
M6 net5 net3 VDD VDD pch l=0.15 w=1 nf=1 m=1
M7 net3 VB3 net5 VDD pch l=0.15 w=1 nf=1 m=1
M8 net3 VB5 net1 VSS nch l=0.15 w=1 nf=1 m=1
M9 net1 VB2 VSS VSS nch l=0.15 w=1 nf=1 m=1
.ends opamp

.subckt dut VDD VSS Vout VB1 VB2 VB3
Q1 VSS VSS X qpnp m=1
Q2 VSS VSS net0 qpnp m=1
R1 Vout X 1k
R2 Vout Y 1k
R3 Y net0 1k
X1 VDD VSS VB1 Y X Vout VB2 VB3 opamp
.ends dut
