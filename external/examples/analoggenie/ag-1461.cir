* official Analog Canvas netlist; PDK X cards rewritten by convert.py
.model nch nmos
.model pch pmos
.model qnpn npn

.subckt opamp VDD VSS INN INP OUT SU
M1 net8 net3 VDD VDD pch l=0.15 w=1 nf=1 m=1
M10 VX VB1 net2 VDD pch l=0.15 w=1 nf=1 m=1
M11 net3 VB1 net8 VDD pch l=0.15 w=1 nf=1 m=1
M12 net4 VB1 net9 VDD pch l=0.15 w=1 nf=1 m=1
M13 OUT VB4 net6 VSS nch l=0.15 w=1 nf=1 m=1
M14 VX VB4 net5 VSS nch l=0.15 w=1 nf=1 m=1
M15 net6 VX VSS VSS nch l=0.15 w=1 nf=1 m=1
M16 VB3 net1 VDD VDD pch l=0.15 w=1 nf=1 m=1
M17 VB3 VB3 VSS VSS nch l=0.15 w=1 nf=1 m=1
M18 net1 net1 VDD VDD pch l=0.15 w=1 nf=1 m=1
M19 net1 VB3 VSS VSS nch l=0.15 w=1 nf=1 m=1
M2 net9 net4 VDD VDD pch l=0.15 w=1 nf=1 m=1
M20 VB4 net1 VDD VDD pch l=0.15 w=1 nf=1 m=1
M21 VB4 VB4 SU VSS nch l=0.15 w=1 nf=1 m=1
M22 SU VB4 VSS VSS nch l=0.15 w=1 nf=1 m=1
M3 net4 INN net7 VSS nch l=0.15 w=1 nf=1 m=1
M4 net3 INP net7 VSS nch l=0.15 w=1 nf=1 m=1
M5 net0 net3 VDD VDD pch l=0.15 w=1 nf=1 m=1
M6 net2 net4 VDD VDD pch l=0.15 w=1 nf=1 m=1
M7 net7 VB2 VSS VSS nch l=0.15 w=1 nf=1 m=1
M8 net5 VX VSS VSS nch l=0.15 w=1 nf=1 m=1
M9 OUT VB1 net0 VDD pch l=0.15 w=1 nf=1 m=1
.ends opamp

.subckt dut VDD VSS Vout
Q1 X X VSS VSS qnpn m=1
Q2 net0 net0 VSS VSS qnpn m=1
R1 Vout X 1k
R2 Vout Y 1k
R3 Y net0 1k
X1 VDD VSS Y X Vout net0 opamp
.ends dut
