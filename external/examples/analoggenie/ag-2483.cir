* official Analog Canvas netlist; PDK X cards rewritten by convert.py
.model nch nmos
.model pch pmos

.subckt dut VDD VSS VB1 VB3 VB2 VREF VB7 VB6 VIN VB4 VB5 VOUT
CF1 VOUT VFB 1p
Cm1 VOUT VO1 1p
Cm2 VO1 net9 1p
M11 net0 VB2 VSS VSS nch l=0.15 w=1 nf=1 m=1
M12 net3 VFB net0 VSS nch l=0.15 w=1 nf=1 m=1
M13 VX VREF net0 VSS nch l=0.15 w=1 nf=1 m=1
M14 net5 net6 VSS VSS nch l=0.15 w=1 nf=1 m=1
M15 net8 net6 VSS VSS nch l=0.15 w=1 nf=1 m=1
M16 VY VB5 VIN VDD pch l=0.15 w=1 nf=1 m=1
M17 VY VO1 VSS VSS nch l=0.15 w=1 nf=1 m=1
M18 VY VY VSS VSS nch l=0.15 w=1 nf=1 m=1
M19 net3 VB1 VIN VDD pch l=0.15 w=1 nf=1 m=1
M20 VX VB1 VIN VDD pch l=0.15 w=1 nf=1 m=1
M21 net1 VO1 VSS VSS nch l=0.15 w=1 nf=1 m=1
M22 net12 VY VSS VSS nch l=0.15 w=1 nf=1 m=1
M23 net1 net1 VIN VDD pch l=0.15 w=1 nf=1 m=1
M24 net12 net1 VIN VDD pch l=0.15 w=1 nf=1 m=1
M25 VO1 VB3 net3 VDD pch l=0.15 w=1 nf=1 m=1
M26 net6 VB3 VX VDD pch l=0.15 w=1 nf=1 m=1
M27 VO1 VB8 net5 VSS nch l=0.15 w=1 nf=1 m=1
M28 net6 VB8 net8 VSS nch l=0.15 w=1 nf=1 m=1
M31 VB8 net2 VIN VDD pch l=0.15 w=1 nf=1 m=1
M32 net2 net2 VIN VDD pch l=0.15 w=1 nf=1 m=1
M33 VB4 net2 VIN VDD pch l=0.15 w=1 nf=1 m=1
M34 VB4 VB4 VSS VSS nch l=0.15 w=1 nf=1 m=1
M35 net2 VB4 net11 VSS nch l=0.15 w=1 nf=1 m=1
M36 VB8 VB8 net4 VSS nch l=0.15 w=1 nf=1 m=1
M37 net4 VB8 VSS VSS nch l=0.15 w=1 nf=1 m=1
MD1 net9 VO1 VSS VSS nch l=0.15 w=1 nf=1 m=1
MD2 net10 VB6 VSS VSS nch l=0.15 w=1 nf=1 m=1
MD3 VX net9 net10 VSS nch l=0.15 w=1 nf=1 m=1
MD4 net7 VB7 net10 VSS nch l=0.15 w=1 nf=1 m=1
MD5 net9 net7 VIN VDD pch l=0.15 w=1 nf=1 m=1
MD6 net7 net7 VIN VDD pch l=0.15 w=1 nf=1 m=1
MD7 VX VX VIN VDD pch l=0.15 w=1 nf=1 m=1
MPT VOUT net12 VIN VDD pch l=0.15 w=1 nf=1 m=1
RB net11 VSS 1k
RF1 VOUT VFB 1k
RF2 VFB VSS 1k
.ends dut
