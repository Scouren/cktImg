* official Analog Canvas netlist; PDK X cards rewritten by convert.py
.model nch nmos
.model pch pmos

.subckt opamp VDD VSS INP INN OUT VX
M10 net1 net1 net4 VSS nch l=0.15 w=1 nf=1 m=1
M11 VB3 VB3 VDD VDD pch l=0.15 w=1 nf=1 m=1
M12 VB3 net1 VSS VSS nch l=0.15 w=1 nf=1 m=1
M13 VB1 VB3 VDD VDD pch l=0.15 w=1 nf=1 m=1
M14 VB1 VB1 VSS VSS nch l=0.15 w=1 nf=1 m=1
M3 VX VB3 VDD VDD pch l=0.15 w=1 nf=1 m=1
M4 net3 INP VX VDD pch l=0.15 w=1 nf=1 m=1
M5 OUT INN VX VDD pch l=0.15 w=1 nf=1 m=1
M6 net3 VB2 net2 VSS nch l=0.15 w=1 nf=1 m=1
M7 OUT VB2 net0 VSS nch l=0.15 w=1 nf=1 m=1
M8 net2 net3 VSS VSS nch l=0.15 w=1 nf=1 m=1
M9 net0 net3 VSS VSS nch l=0.15 w=1 nf=1 m=1
R1 VDD net1 1k
R2 net4 VSS 1k
.ends opamp

.subckt dut VDD VSS vci phi1 phi2 vco
C1 vcx VSS 1p
C2 net0 vco 1p
M1 vci phi1 vcx VSS nch l=0.15 w=1 nf=1 m=1
M2 vcx phi2 net0 VSS nch l=0.15 w=1 nf=1 m=1
X1 VDD VSS VSS net0 vco vcx opamp
.ends dut
