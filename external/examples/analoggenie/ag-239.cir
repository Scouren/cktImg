* official Analog Canvas netlist; PDK X cards rewritten by convert.py
.model nch nmos

.subckt dut VDD VSS Vin Iout
M1 X Vin VSS VSS nch l=0.15 w=1 nf=1 m=1
M2 Iout X VSS VSS nch l=0.15 w=1 nf=1 m=1
RD VDD X 1k
.ends dut
