* official Analog Canvas netlist; PDK X cards rewritten by convert.py
.model nch nmos
.model pch pmos
.model qpnp pnp

.subckt opamp VDD VSS VN VP Vout VE
M0 net6 VN net7 VSS nch l=0.15 w=1 nf=1 m=1
M1 net3 net1 VDD VDD pch l=0.15 w=1 nf=1 m=1
M10 VX VB1 net12 VDD pch l=0.15 w=1 nf=1 m=1
M11 net1 VB1 net3 VDD pch l=0.15 w=1 nf=1 m=1
M12 net6 VB1 net0 VDD pch l=0.15 w=1 nf=1 m=1
M13 Vout VB4 VE VSS nch l=0.15 w=1 nf=1 m=1
M14 VX VB4 net11 VSS nch l=0.15 w=1 nf=1 m=1
M15 VB4 VBP VDD VDD pch l=0.15 w=1 nf=1 m=1
M16 VB4 VB4 net9 VSS nch l=0.15 w=1 nf=1 m=1
M17 net9 VB4 VSS VSS nch l=0.15 w=1 nf=1 m=1
M18 VBP VBP VDD VDD pch l=0.15 w=1 nf=1 m=1
M19 VBP net8 VSS VSS nch l=0.15 w=1 nf=1 m=1
M2 net0 net6 VDD VDD pch l=0.15 w=1 nf=1 m=1
M20 net4 VBP VDD VDD pch l=0.15 w=1 nf=1 m=1
M21 net4 net4 net8 VSS nch l=0.15 w=1 nf=1 m=1
M22 net8 net4 net2 VSS nch l=0.15 w=1 nf=1 m=1
M23 net2 net5 VB3 VSS nch l=0.15 w=1 nf=1 m=1
M24 VB3 VB3 VSS VSS nch l=0.15 w=1 nf=1 m=1
M25 net5 VBP VDD VDD pch l=0.15 w=1 nf=1 m=1
M26 net5 net5 net2 VSS nch l=0.15 w=1 nf=1 m=1
M27 VB3 VBP VDD VDD pch l=0.15 w=1 nf=1 m=1
M3 net1 VP net7 VSS nch l=0.15 w=1 nf=1 m=1
M4 net7 VB2 VSS VSS nch l=0.15 w=1 nf=1 m=1
M5 net10 net1 VDD VDD pch l=0.15 w=1 nf=1 m=1
M6 net12 net6 VDD VDD pch l=0.15 w=1 nf=1 m=1
M7 VE VX VSS VSS nch l=0.15 w=1 nf=1 m=1
M8 net11 VX VSS VSS nch l=0.15 w=1 nf=1 m=1
M9 Vout VB1 net10 VDD pch l=0.15 w=1 nf=1 m=1
.ends opamp

.subckt dut VDD VSS Vout
Q1 VSS VSS net0 qpnp m=1
Q2 net0 net0 X qpnp m=1
Q3 VSS VSS net2 qpnp m=1
Q4 net2 net2 net1 qpnp m=1
R1 Vout X 1k
R2 Vout Y 1k
R3 Y net1 1k
X1 VDD VSS Y X Vout net1 opamp
.ends dut
