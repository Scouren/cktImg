* official Analog Canvas netlist; PDK X cards rewritten by convert.py
.model nch nmos
.model pch pmos

.subckt AEA VDD VSS VB1 VB2 VREF VX OUT
M10 net5 VB1 net8 VDD pch l=0.15 w=1 nf=1 m=1
M11 OUT VB1 net0 VDD pch l=0.15 w=1 nf=1 m=1
M12 VY VB6 net7 VSS nch l=0.15 w=1 nf=1 m=1
M13 VX OUT net6 VSS nch l=0.15 w=1 nf=1 m=1
M14 net5 VREF net6 VSS nch l=0.15 w=1 nf=1 m=1
M15 OUT VB6 net2 VSS nch l=0.15 w=1 nf=1 m=1
M16 net7 VY VSS VSS nch l=0.15 w=1 nf=1 m=1
M17 net6 VB2 VSS VSS nch l=0.15 w=1 nf=1 m=1
M18 net2 VY VSS VSS nch l=0.15 w=1 nf=1 m=1
M19 VB6 net4 VDD VDD pch l=0.15 w=1 nf=1 m=1
M20 VB6 VB6 OUT VSS nch l=0.15 w=1 nf=1 m=1
M21 OUT VB6 VSS VSS nch l=0.15 w=1 nf=1 m=1
M22 net4 net4 VDD VDD pch l=0.15 w=1 nf=1 m=1
M23 net4 VB3 VSS VSS nch l=0.15 w=1 nf=1 m=1
M24 VB3 net4 VDD VDD pch l=0.15 w=1 nf=1 m=1
M25 net3 VB3 VSS VSS nch l=0.15 w=1 nf=1 m=1
M4 net9 VX VDD VDD pch l=0.15 w=1 nf=1 m=1
M5 net1 VX VDD VDD pch l=0.15 w=1 nf=1 m=1
M6 net8 net5 VDD VDD pch l=0.15 w=1 nf=1 m=1
M7 net0 net5 VDD VDD pch l=0.15 w=1 nf=1 m=1
M8 VY VB1 net9 VDD pch l=0.15 w=1 nf=1 m=1
M9 VX VB1 net1 VDD pch l=0.15 w=1 nf=1 m=1
R1 VB3 net3 1k
.ends AEA

.subckt dut VDD VSS VIN VREF VB1 VB2 pb nb VOUT VERR
M1 net0 VEAOUT VIN VDD pch l=0.15 w=1 nf=1 m=1
M2 net3 net3 net0 VDD pch l=0.15 w=1 nf=1 m=1
M3 net3 nb VSS VSS nch l=0.15 w=1 nf=1 m=1
MBIAS VERR nb VSS VSS nch l=0.15 w=1 nf=1 m=1
MCHG net1 pb VIN VDD pch l=0.15 w=1 nf=1 m=1
MCTRL VERR net3 VOUT VDD pch l=0.15 w=1 nf=1 m=1
MGEN net2 net2 VSS VSS nch l=0.15 w=1 nf=1 m=1
MINJ VERR net2 VSS VSS nch l=0.15 w=1 nf=1 m=1
MRES VOUT VERR VIN VDD pch l=0.15 w=1 nf=1 m=1
MSEN net2 VEAOUT net1 VDD pch l=0.15 w=1 nf=1 m=1
X1 VDD VSS VB1 VB2 VREF net3 VEAOUT AEA
.ends dut
