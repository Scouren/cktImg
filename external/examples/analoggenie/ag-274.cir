* official Analog Canvas netlist; PDK X cards rewritten by convert.py
.model nch nmos
.model pch pmos

.subckt dut VDD VSS Vb Vin Vout
M1 X Vin net0 VSS nch l=0.15 w=1 nf=1 m=1
M2 X Vb VDD VDD pch l=0.15 w=1 nf=1 m=1
M3 Vout X VDD VDD pch l=0.15 w=1 nf=1 m=1
RD2 Vout VSS 1k
RF net0 Vout 1k
RS1 net0 VSS 1k
.ends dut
