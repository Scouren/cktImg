* official Analog Canvas netlist; PDK X cards rewritten by convert.py
.model nch nmos
.model pch pmos

.subckt icm_opamp_vdd_vss VDD VSS VIP VIN VOUT params: gain=1e6
Blin nlin 0 V={gain*(V(VIP)-V(VIN))}
Bcore VOUT 0 V={0.5*(V(VDD)+(0.5*(V(VSS)+V(nlin)+sqrt((V(nlin)-V(VSS))*(V(nlin)-V(VSS))+(1e-4*(V(VDD)-V(VSS)))*(1e-4*(V(VDD)-V(VSS)))+1e-12)))-sqrt((V(VDD)-(0.5*(V(VSS)+V(nlin)+sqrt((V(nlin)-V(VSS))*(V(nlin)-V(VSS))+(1e-4*(V(VDD)-V(VSS)))*(1e-4*(V(VDD)-V(VSS)))+1e-12))))*(V(VDD)-(0.5*(V(VSS)+V(nlin)+sqrt((V(nlin)-V(VSS))*(V(nlin)-V(VSS))+(1e-4*(V(VDD)-V(VSS)))*(1e-4*(V(VDD)-V(VSS)))+1e-12))))+(1e-4*(V(VDD)-V(VSS)))*(1e-4*(V(VDD)-V(VSS)))+1e-12))}
.ends icm_opamp_vdd_vss

.subckt dut VDD VSS GND vi2 vi1 vout
VB1 VDD net2 DC 1
CL vout GND 1p
M1 vout net1 VSS VSS nch l=0.15 w=1 nf=1 m=1
M2 vout v1 VDD VDD pch l=0.15 w=1 nf=1 m=1
M3 net0 v1 net2 VSS nch l=0.15 w=1 nf=1 m=1
M4 net0 net0 VDD VDD pch l=0.15 w=1 nf=1 m=1
M5 net1 net0 VDD VDD pch l=0.15 w=1 nf=1 m=1
M6 net1 net1 VSS VSS nch l=0.15 w=1 nf=1 m=1
M7 net2 net1 VSS VSS nch l=0.15 w=1 nf=1 m=1
X1 VDD VSS vi1 vi2 v1 icm_opamp_vdd_vss gain=1e6
.ends dut
