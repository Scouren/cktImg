* official Analog Canvas netlist; PDK X cards rewritten by convert.py
.model nch nmos
.model pch pmos

* Ideal inverter: switches at V(VDD,VSS)/2; vt sets the step width, td the delay
.subckt inverter VDD VSS A Y params: vt=10m td=10p
BhA hA 0 V={0.5*(1+tanh((V(A,VSS)-0.5*V(VDD,VSS))/vt))}
Bf nfn VSS V={V(VDD,VSS)*(1-V(hA))}
Rd nfn ndl 1k
Cd ndl VSS {td/1000}
BY Y VSS V={V(ndl,VSS)}
.ends inverter

.subckt dut VDD VSS A0 B0 A1 B1 A2 B2 A3 B3 EQ
M1 EQ A0 net1 VSS nch l=0.15 w=1 nf=1 m=1
M10 EQ B2 net14 VSS nch l=0.15 w=1 nf=1 m=1
M11 net14 net11 VSS VSS nch l=0.15 w=1 nf=1 m=1
M12 net2 net12 VSS VSS nch l=0.15 w=1 nf=1 m=1
M13 EQ A3 net6 VSS nch l=0.15 w=1 nf=1 m=1
M14 EQ B3 net15 VSS nch l=0.15 w=1 nf=1 m=1
M15 net15 net9 VSS VSS nch l=0.15 w=1 nf=1 m=1
M16 net6 net3 VSS VSS nch l=0.15 w=1 nf=1 m=1
M17 EQ VSS VDD VDD pch l=0.15 w=1 nf=1 m=1
M2 EQ B0 net0 VSS nch l=0.15 w=1 nf=1 m=1
M3 net0 net10 VSS VSS nch l=0.15 w=1 nf=1 m=1
M4 net1 net8 VSS VSS nch l=0.15 w=1 nf=1 m=1
M5 EQ A1 net5 VSS nch l=0.15 w=1 nf=1 m=1
M6 EQ B1 net4 VSS nch l=0.15 w=1 nf=1 m=1
M7 net4 net13 VSS VSS nch l=0.15 w=1 nf=1 m=1
M8 net5 net7 VSS VSS nch l=0.15 w=1 nf=1 m=1
M9 EQ A2 net2 VSS nch l=0.15 w=1 nf=1 m=1
X1 VDD VSS A0 net10 inverter td=10p vt=10m
X2 VDD VSS B0 net8 inverter td=10p vt=10m
X3 VDD VSS A1 net13 inverter td=10p vt=10m
X4 VDD VSS B1 net7 inverter td=10p vt=10m
X5 VDD VSS A2 net11 inverter td=10p vt=10m
X6 VDD VSS B2 net12 inverter td=10p vt=10m
X7 VDD VSS A3 net9 inverter td=10p vt=10m
X8 VDD VSS B3 net3 inverter td=10p vt=10m
.ends dut
