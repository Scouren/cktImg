* official Analog Canvas netlist; PDK X cards rewritten by convert.py
.model nch nmos
.model pch pmos

.subckt dut VDD VSS VCONT1 VB2 VIN VCONT2 VCONT3 VCONT4 VCONT5 VP VREF VB1
.model DIODE D(IS=1e-14 N=1)
CFLY VX1 VX2 1p
CO VP VN 1p
COP VP VSS 1p
D1 VN VX2 DIODE
L1 VX1 VX3 1n
M1 VX1 VCONT2 VIN VDD pch l=0.15 w=1 nf=1 m=1
M2 VX2 VCONT3 VIN VDD pch l=0.15 w=1 nf=1 m=1
M3 VP VCONT5 VX3 VDD pch l=0.15 w=1 nf=1 m=1
M4 VX3 VCONT4 VSS VSS nch l=0.15 w=1 nf=1 m=1
M5 net0 VCONT1 VIN VDD pch l=0.15 w=1 nf=1 m=1
MN1 net2 VFP1 net3 VSS nch l=0.15 w=1 nf=1 m=1
MN10 net7 VB4 VSS VSS nch l=0.15 w=1 nf=1 m=1
MN11 net1 net1 VSS VSS nch l=0.15 w=1 nf=1 m=1
MN12 net5 net1 VSS VSS nch l=0.15 w=1 nf=1 m=1
MN13 net1 VB2 VSS VSS nch l=0.15 w=1 nf=1 m=1
MN2 VX3 VREF net3 VSS nch l=0.15 w=1 nf=1 m=1
MN3 VB3 VB3 VSS VSS nch l=0.15 w=1 nf=1 m=1
MN4 net3 VB3 VSS VSS nch l=0.15 w=1 nf=1 m=1
MN5 net6 net6 VSS VSS nch l=0.15 w=1 nf=1 m=1
MN6 VEA net6 VSS VSS nch l=0.15 w=1 nf=1 m=1
MN7 VB1 VB3 VSS VSS nch l=0.15 w=1 nf=1 m=1
MN8 net4 VB4 VSS VSS nch l=0.15 w=1 nf=1 m=1
MN9 VB4 VB4 VSS VSS nch l=0.15 w=1 nf=1 m=1
MP1 net2 net2 VDD VDD pch l=0.15 w=1 nf=1 m=1
MP10 net5 net5 net0 VDD pch l=0.15 w=1 nf=1 m=1
MP11 VX1 net5 net0 VDD pch l=0.15 w=1 nf=1 m=1
MP2 VX3 VX3 VDD VDD pch l=0.15 w=1 nf=1 m=1
MP3 net6 net2 VDD VDD pch l=0.15 w=1 nf=1 m=1
MP4 VEA VX3 VDD VDD pch l=0.15 w=1 nf=1 m=1
MP5 VB1 VB1 VDD VDD pch l=0.15 w=1 nf=1 m=1
MP6 VB3 net4 VDD VDD pch l=0.15 w=1 nf=1 m=1
MP7 net4 net4 VDD VDD pch l=0.15 w=1 nf=1 m=1
MP8 VB4 net7 VDD VDD pch l=0.15 w=1 nf=1 m=1
MP9 net1 VEA net0 VDD pch l=0.15 w=1 nf=1 m=1
R1 VP VFP1 1k
R2 VFP1 VSS 1k
R3 VDD net7 1k
RBIAS VDD VB4 1k
.ends dut
