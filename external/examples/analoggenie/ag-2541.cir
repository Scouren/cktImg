* official Analog Canvas netlist; PDK X cards rewritten by convert.py
.model nch nmos
.model pch pmos

.subckt AMP1 VDD VSS VB1 VB2 INN INP n3 OUT
M10 VX VB1 net8 VDD pch l=0.15 w=1 nf=1 m=1
M11 n3 VB1 net10 VDD pch l=0.15 w=1 nf=1 m=1
M12 net4 VB1 net5 VDD pch l=0.15 w=1 nf=1 m=1
M13 OUT VB1 net7 VDD pch l=0.15 w=1 nf=1 m=1
M14 VX VC net0 VSS nch l=0.15 w=1 nf=1 m=1
M15 n3 INN net6 VSS nch l=0.15 w=1 nf=1 m=1
M16 net4 INP net6 VSS nch l=0.15 w=1 nf=1 m=1
M17 OUT VC net1 VSS nch l=0.15 w=1 nf=1 m=1
M18 net0 VX VSS VSS nch l=0.15 w=1 nf=1 m=1
M19 net6 VB2 VSS VSS nch l=0.15 w=1 nf=1 m=1
M20 net1 VX VSS VSS nch l=0.15 w=1 nf=1 m=1
M21 VC net2 VDD VDD pch l=0.15 w=1 nf=1 m=1
M22 VC VC net3 VSS nch l=0.15 w=1 nf=1 m=1
M23 net3 VC VSS VSS nch l=0.15 w=1 nf=1 m=1
M24 net2 net2 VDD VDD pch l=0.15 w=1 nf=1 m=1
M25 net2 net9 VSS VSS nch l=0.15 w=1 nf=1 m=1
M26 net9 net2 VDD VDD pch l=0.15 w=1 nf=1 m=1
M27 net9 net9 VSS VSS nch l=0.15 w=1 nf=1 m=1
M6 net8 n3 VDD VDD pch l=0.15 w=1 nf=1 m=1
M7 net10 n3 VDD VDD pch l=0.15 w=1 nf=1 m=1
M8 net5 net4 VDD VDD pch l=0.15 w=1 nf=1 m=1
M9 net7 net4 VDD VDD pch l=0.15 w=1 nf=1 m=1
.ends AMP1

.subckt dut VDD VSS Vref Vout biasp biascas biasn VB1 VB2
C1 Vset VSS 1p
C2 n3 Vout 1p
M1 Vout n3 VDD VDD pch l=0.15 w=1 nf=1 m=1
M2 n1 Vset Vout VDD pch l=0.15 w=1 nf=1 m=1
M3 n1 biasn VSS VSS nch l=0.15 w=1 nf=1 m=1
M4 n3 biasp VDD VDD pch l=0.15 w=1 nf=1 m=1
M5 n3 biascas n1 VSS nch l=0.15 w=1 nf=1 m=1
R1 fb VSS 1k
R2 Vout fb 1k
X1 VDD VSS VB1 VB2 fb Vref n3 Vset AMP1
.ends dut
