* official Analog Canvas netlist; PDK X cards rewritten by convert.py
.model nch nmos
.model pch pmos
.model qpnp pnp

.subckt dut VDD VSS Vout VB2
M1 X VG VDD VDD pch l=0.15 w=1 nf=1 m=1
M10 VZ VB1 net8 VDD pch l=0.15 w=1 nf=1 m=1
M11 net5 VB1 net9 VDD pch l=0.15 w=1 nf=1 m=1
M12 VG VB1 net2 VDD pch l=0.15 w=1 nf=1 m=1
M13 VZ X net1 VSS nch l=0.15 w=1 nf=1 m=1
M14 net5 Y net1 VSS nch l=0.15 w=1 nf=1 m=1
M15 net1 VB2 VSS VSS nch l=0.15 w=1 nf=1 m=1
M16 Y VB5 net10 VSS nch l=0.15 w=1 nf=1 m=1
M17 net10 Y VSS VSS nch l=0.15 w=1 nf=1 m=1
M18 VG VB5 net4 VSS nch l=0.15 w=1 nf=1 m=1
M19 net4 Y VSS VSS nch l=0.15 w=1 nf=1 m=1
M2 Vout VG VDD VDD pch l=0.15 w=1 nf=1 m=1
M20 VB4 VB6 VDD VDD pch l=0.15 w=1 nf=1 m=1
M21 VB4 VB3 VSS VSS nch l=0.15 w=1 nf=1 m=1
M22 VB6 VB6 VDD VDD pch l=0.15 w=1 nf=1 m=1
M23 VB6 VB4 VB3 VSS nch l=0.15 w=1 nf=1 m=1
M24 VB3 net0 VSS VSS nch l=0.15 w=1 nf=1 m=1
M25 net0 VB6 VDD VDD pch l=0.15 w=1 nf=1 m=1
M26 net0 net0 VSS VSS nch l=0.15 w=1 nf=1 m=1
M27 VB5 VB6 VDD VDD pch l=0.15 w=1 nf=1 m=1
M28 VB5 VB5 net7 VSS nch l=0.15 w=1 nf=1 m=1
M29 net7 VB5 VSS VSS nch l=0.15 w=1 nf=1 m=1
M3 net11 VG VDD VDD pch l=0.15 w=1 nf=1 m=1
M4 VZ VG VDD VDD pch l=0.15 w=1 nf=1 m=1
M5 net6 VZ VDD VDD pch l=0.15 w=1 nf=1 m=1
M6 net8 VZ VDD VDD pch l=0.15 w=1 nf=1 m=1
M7 net9 net5 VDD VDD pch l=0.15 w=1 nf=1 m=1
M8 net2 net5 VDD VDD pch l=0.15 w=1 nf=1 m=1
M9 Y VB1 net6 VDD pch l=0.15 w=1 nf=1 m=1
Q1 VSS VSS net11 qpnp m=1
Q2 VSS net11 X qpnp m=1
Q3 VSS VSS VZ qpnp m=1
Q4 VSS VZ net3 qpnp m=1
R1 Y net3 1k
R2 Vout Y 1k
.ends dut
