* official Analog Canvas netlist; PDK X cards rewritten by convert.py
.model nch nmos
.model pch pmos
.model qnpn npn

.subckt dut VDD VSS Vout VB2 VB1
M1 VZ net2 VDD VDD pch l=0.15 w=1 nf=1 m=1
M10 VB2 VB2 VDD VDD pch l=0.15 w=1 nf=1 m=1
M11 net1 VB2 VDD VDD pch l=0.15 w=1 nf=1 m=1
M12 VB1 VB1 VDD VDD pch l=0.15 w=1 nf=1 m=1
M13 VB3 VB1 VDD VDD pch l=0.15 w=1 nf=1 m=1
M14 VB2 net1 VSS VSS nch l=0.15 w=1 nf=1 m=1
M15 net3 net1 VSS VSS nch l=0.15 w=1 nf=1 m=1
M16 VB1 net1 VSS VSS nch l=0.15 w=1 nf=1 m=1
M17 VB3 VB3 VSS VSS nch l=0.15 w=1 nf=1 m=1
M2 net2 net2 VDD VDD pch l=0.15 w=1 nf=1 m=1
M3 net0 net0 VDD VDD pch l=0.15 w=1 nf=1 m=1
M4 Vout net0 VDD VDD pch l=0.15 w=1 nf=1 m=1
M5 net2 Y net4 VSS nch l=0.15 w=1 nf=1 m=1
M6 net0 X net4 VSS nch l=0.15 w=1 nf=1 m=1
M7 net4 VB3 VSS VSS nch l=0.15 w=1 nf=1 m=1
M8 VZ VZ VSS VSS nch l=0.15 w=1 nf=1 m=1
M9 Vout VZ VSS VSS nch l=0.15 w=1 nf=1 m=1
Q1 X X VSS VSS qnpn m=1
Q2 VZ VZ VSS VSS qnpn m=1
R1 Vout X 1k
R2 Vout Y 1k
R3 Y VZ 1k
R4 net1 net3 1k
.ends dut
