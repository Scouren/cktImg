* official Analog Canvas netlist; PDK X cards rewritten by convert.py
.model nch nmos
.model pch pmos

.subckt opamp VDD VSS INN INP OUT VX
M1 VX INN net2 VSS nch l=0.15 w=1 nf=1 m=1
M10 OUT VB3 VSS VSS nch l=0.15 w=1 nf=1 m=1
M11 VB3 OUT VDD VDD pch l=0.15 w=1 nf=1 m=1
M12 VB3 VB3 VSS VSS nch l=0.15 w=1 nf=1 m=1
M13 VB1 VB1 VDD VDD pch l=0.15 w=1 nf=1 m=1
M14 VB2 VB1 VDD VDD pch l=0.15 w=1 nf=1 m=1
M15 VB2 VB2 VSS VSS nch l=0.15 w=1 nf=1 m=1
M16 VB1 VB3 VSS VSS nch l=0.15 w=1 nf=1 m=1
M2 net1 INP net2 VSS nch l=0.15 w=1 nf=1 m=1
M3 net2 VB2 VSS VSS nch l=0.15 w=1 nf=1 m=1
M4 VX VX VDD VDD pch l=0.15 w=1 nf=1 m=1
M5 net1 net1 VDD VDD pch l=0.15 w=1 nf=1 m=1
M6 net0 VX VDD VDD pch l=0.15 w=1 nf=1 m=1
M7 OUT net1 VDD VDD pch l=0.15 w=1 nf=1 m=1
M8 net0 net0 VSS VSS nch l=0.15 w=1 nf=1 m=1
M9 OUT net0 VSS VSS nch l=0.15 w=1 nf=1 m=1
R4 VDD OUT 1k
R5 VDD VB3 1k
.ends opamp

.subckt dut VDD VSS VIN VOUT Vref
CL VOUT VX 1p
MNP VIN net0 VOUT VSS nch l=0.15 w=1 nf=1 m=1
R1 VOUT FB 1k
R2 FB VSS 1k
R3 VX VSS 1k
X1 VDD VSS FB Vref net0 VX opamp
.ends dut
