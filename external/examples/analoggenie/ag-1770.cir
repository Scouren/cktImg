* official Analog Canvas netlist; PDK X cards rewritten by convert.py
.model nch nmos
.model pch pmos
.model qpnp pnp

.subckt opamp VDD VSS INN INP VX X OUT
M10 X VB2 net2 VDD pch l=0.15 w=1 nf=1 m=1
M11 OUT VB2 net1 VDD pch l=0.15 w=1 nf=1 m=1
M12 X VB3 net4 VSS nch l=0.15 w=1 nf=1 m=1
M13 OUT VB3 net3 VSS nch l=0.15 w=1 nf=1 m=1
M14 net4 VB4 VSS VSS nch l=0.15 w=1 nf=1 m=1
M15 net3 VB4 VSS VSS nch l=0.15 w=1 nf=1 m=1
M16 net0 net0 INN VDD pch l=0.15 w=1 nf=1 m=1
M17 VB3 net0 VDD VDD pch l=0.15 w=1 nf=1 m=1
M18 VB3 VB3 VB4 VSS nch l=0.15 w=1 nf=1 m=1
M19 VB4 VB4 VSS VSS nch l=0.15 w=1 nf=1 m=1
M5 VX VB1 VDD VDD pch l=0.15 w=1 nf=1 m=1
M6 net3 INN VX VDD pch l=0.15 w=1 nf=1 m=1
M7 net4 INP VX VDD pch l=0.15 w=1 nf=1 m=1
M8 net2 X VDD VDD pch l=0.15 w=1 nf=1 m=1
M9 net1 X VDD VDD pch l=0.15 w=1 nf=1 m=1
R3 VDD INN 1k
R4 net0 VSS 1k
.ends opamp

.subckt dut VDD VSS Vout
M1 Vout net0 VDD VDD pch l=0.15 w=1 nf=1 m=1
M2 net1 net0 VDD VDD pch l=0.15 w=1 nf=1 m=1
M3 VX net0 VDD VDD pch l=0.15 w=1 nf=1 m=1
M4 net2 net0 VDD VDD pch l=0.15 w=1 nf=1 m=1
Q1 VSS VSS VX qpnp m=1
Q2 VSS VX X qpnp m=1
Q3 VSS VSS net2 qpnp m=1
Q4 VSS net2 net1 qpnp m=1
R1 Y X 1k
R2 Vout Y 1k
X1 VDD VSS net1 Y VX X net0 opamp
.ends dut
