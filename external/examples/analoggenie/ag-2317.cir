* official Analog Canvas netlist; PDK X cards rewritten by convert.py
.model nch nmos
.model pch pmos

.subckt bias VDD VSS VBN
M22 net0 VBN VSS VSS nch l=0.15 w=1 nf=1 m=1
M23 VBN VBN net0 VSS nch l=0.15 w=1 nf=1 m=1
M24 VBN net2 VDD VDD pch l=0.15 w=1 nf=1 m=1
M25 net2 VB4 VSS VSS nch l=0.15 w=1 nf=1 m=1
M26 net1 VB4 VSS VSS nch l=0.15 w=1 nf=1 m=1
M27 net2 net2 VDD VDD pch l=0.15 w=1 nf=1 m=1
M28 VB4 net2 VDD VDD pch l=0.15 w=1 nf=1 m=1
R3 VB4 net1 1k
.ends bias

.subckt dut VDD VSS VB1 VREF VB5 IBUF VIN VOUT
CL VOUT net2 1p
M10 EAO VB3 VY VDD pch l=0.15 w=1 nf=1 m=1
M11 net5 VX VDD VDD pch l=0.15 w=1 nf=1 m=1
M12 VY VX VDD VDD pch l=0.15 w=1 nf=1 m=1
M13 net4 VB5 VDD VDD pch l=0.15 w=1 nf=1 m=1
M14 VX EAO net4 VDD pch l=0.15 w=1 nf=1 m=1
M15 VX VX VSS VSS nch l=0.15 w=1 nf=1 m=1
M16 GATE VX VSS VSS nch l=0.15 w=1 nf=1 m=1
M17 VDD net4 GATE VSS nch l=0.15 w=1 nf=1 m=1
M18 VY EAO IBUF VSS nch l=0.15 w=1 nf=1 m=1
M19 VY VY VDD VDD pch l=0.15 w=1 nf=1 m=1
M2 net0 VB1 VDD VDD pch l=0.15 w=1 nf=1 m=1
M20 GATE VY VDD VDD pch l=0.15 w=1 nf=1 m=1
M21 VSS IBUF GATE VDD pch l=0.15 w=1 nf=1 m=1
M3 net1 VREF net0 VDD pch l=0.15 w=1 nf=1 m=1
M4 net3 FB net0 VDD pch l=0.15 w=1 nf=1 m=1
M5 net1 VB2 VSS VSS nch l=0.15 w=1 nf=1 m=1
M6 net3 VB2 VSS VSS nch l=0.15 w=1 nf=1 m=1
M7 VX VBN net1 VSS nch l=0.15 w=1 nf=1 m=1
M8 EAO VBN net3 VSS nch l=0.15 w=1 nf=1 m=1
M9 VX VB3 net5 VDD pch l=0.15 w=1 nf=1 m=1
MNP VIN GATE VOUT VSS nch l=0.15 w=1 nf=1 m=1
R1 FB VSS 1k
R2 VOUT FB 1k
R4 net2 VSS 1k
RL VOUT VSS 1k
X1 VDD VSS VBN bias
.ends dut
