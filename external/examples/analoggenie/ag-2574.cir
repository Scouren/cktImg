* official Analog Canvas netlist; PDK X cards rewritten by convert.py
.model nch nmos
.model pch pmos

.subckt dut VDD VSS VB4 Vref VB2 VB3 biasp biascas biasn Vout
C1 Vset VSS 1p
C2 n3 Vout 1p
M1 Vout n3 VDD VDD pch l=0.15 w=1 nf=1 m=1
M10 Vset VC n1 VSS nch l=0.15 w=1 nf=1 m=1
M11 n3 VC net5 VSS nch l=0.15 w=1 nf=1 m=1
M12 n1 n3 VSS VSS nch l=0.15 w=1 nf=1 m=1
M13 net5 n3 VSS VSS nch l=0.15 w=1 nf=1 m=1
M14 net6 fb net7 VSS nch l=0.15 w=1 nf=1 m=1
M15 net8 Vref net7 VSS nch l=0.15 w=1 nf=1 m=1
M16 net7 VB2 VSS VSS nch l=0.15 w=1 nf=1 m=1
M17 VP VP VDD VDD pch l=0.15 w=1 nf=1 m=1
M18 net0 VP VDD VDD pch l=0.15 w=1 nf=1 m=1
M19 net2 VP VDD VDD pch l=0.15 w=1 nf=1 m=1
M2 n1 Vset Vout VDD pch l=0.15 w=1 nf=1 m=1
M20 VB4 VP VDD VDD pch l=0.15 w=1 nf=1 m=1
M21 VC VP VDD VDD pch l=0.15 w=1 nf=1 m=1
M22 VP net1 VSS VSS nch l=0.15 w=1 nf=1 m=1
M23 net0 net0 net1 VSS nch l=0.15 w=1 nf=1 m=1
M24 net1 net0 net4 VSS nch l=0.15 w=1 nf=1 m=1
M25 net2 net2 net4 VSS nch l=0.15 w=1 nf=1 m=1
M26 net4 net2 VB4 VSS nch l=0.15 w=1 nf=1 m=1
M27 VB4 VB4 VSS VSS nch l=0.15 w=1 nf=1 m=1
M28 VC VC net3 VSS nch l=0.15 w=1 nf=1 m=1
M29 net3 VC VSS VSS nch l=0.15 w=1 nf=1 m=1
M3 n1 biasn VSS VSS nch l=0.15 w=1 nf=1 m=1
M4 n3 biasp VDD VDD pch l=0.15 w=1 nf=1 m=1
M5 n3 biascas n1 VSS nch l=0.15 w=1 nf=1 m=1
M6 net8 VB1 VDD VDD pch l=0.15 w=1 nf=1 m=1
M7 net6 VB1 VDD VDD pch l=0.15 w=1 nf=1 m=1
M8 Vset VB3 net8 VDD pch l=0.15 w=1 nf=1 m=1
M9 n3 VB3 net6 VDD pch l=0.15 w=1 nf=1 m=1
R1 fb VSS 1k
R2 Vout fb 1k
.ends dut
