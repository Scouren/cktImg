* official Analog Canvas netlist; PDK X cards rewritten by convert.py
.model nch nmos
.model pch pmos

.subckt dut VDD VSS VCONT
I1 net0 VSS DC 1m
L1 net2 net0 1n
L2 net1 net0 1n
M3 net2 net1 VDD VDD pch l=0.15 w=1 nf=1 m=1
M4 net1 net2 VDD VDD pch l=0.15 w=1 nf=1 m=1
Mv1 VCONT net2 VCONT VSS nch l=0.15 w=1 nf=1 m=1
Mv2 VCONT net1 VCONT VSS nch l=0.15 w=1 nf=1 m=1
.ends dut
