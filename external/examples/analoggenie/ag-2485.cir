* official Analog Canvas netlist; PDK X cards rewritten by convert.py
.model nch nmos
.model pch pmos

.subckt dut VDD VSS VB1 VB3 VB2 VB5 VB7 VB6 VOUT VIN VB4 VREF
CF1 VOUT VFB 1p
Cm1 net9 VOUT 1p
Cm2 net9 net3 1p
M1 net7 VB1 VIN VDD pch l=0.15 w=1 nf=1 m=1
M11 net14 VB2 VSS VSS nch l=0.15 w=1 nf=1 m=1
M12 net7 VFB net14 VSS nch l=0.15 w=1 nf=1 m=1
M13 VX VREF net14 VSS nch l=0.15 w=1 nf=1 m=1
M14 net2 net4 VSS VSS nch l=0.15 w=1 nf=1 m=1
M15 net15 net4 VSS VSS nch l=0.15 w=1 nf=1 m=1
M16 net12 VB5 VIN VDD pch l=0.15 w=1 nf=1 m=1
M17 net12 net9 VSS VSS nch l=0.15 w=1 nf=1 m=1
M18 net12 net12 VSS VSS nch l=0.15 w=1 nf=1 m=1
M2 VX VB1 VIN VDD pch l=0.15 w=1 nf=1 m=1
M21 net0 net9 VSS VSS nch l=0.15 w=1 nf=1 m=1
M22 net6 net12 VSS VSS nch l=0.15 w=1 nf=1 m=1
M23 net0 net0 VIN VDD pch l=0.15 w=1 nf=1 m=1
M24 net6 net0 VIN VDD pch l=0.15 w=1 nf=1 m=1
M3 net9 VB3 net7 VDD pch l=0.15 w=1 nf=1 m=1
M4 net4 VB3 VX VDD pch l=0.15 w=1 nf=1 m=1
M5 net9 VC net2 VSS nch l=0.15 w=1 nf=1 m=1
M6 net4 VC net15 VSS nch l=0.15 w=1 nf=1 m=1
MB1 VC net8 VIN VDD pch l=0.15 w=1 nf=1 m=1
MB10 VB4 VB4 VSS VSS nch l=0.15 w=1 nf=1 m=1
MB2 VC VC net10 VSS nch l=0.15 w=1 nf=1 m=1
MB3 net10 VC VSS VSS nch l=0.15 w=1 nf=1 m=1
MB4 net8 net8 VIN VDD pch l=0.15 w=1 nf=1 m=1
MB5 net8 VB4 net11 VSS nch l=0.15 w=1 nf=1 m=1
MB6 net11 net13 VSS VSS nch l=0.15 w=1 nf=1 m=1
MB7 net13 net13 VSS VSS nch l=0.15 w=1 nf=1 m=1
MB8 net13 net8 VIN VDD pch l=0.15 w=1 nf=1 m=1
MB9 VB4 net8 VIN VDD pch l=0.15 w=1 nf=1 m=1
MD1 net3 net9 VSS VSS nch l=0.15 w=1 nf=1 m=1
MD2 net5 VB6 VSS VSS nch l=0.15 w=1 nf=1 m=1
MD3 VX net3 net5 VSS nch l=0.15 w=1 nf=1 m=1
MD4 net1 VB7 net5 VSS nch l=0.15 w=1 nf=1 m=1
MD5 net3 net1 VIN VDD pch l=0.15 w=1 nf=1 m=1
MD6 net1 net1 VIN VDD pch l=0.15 w=1 nf=1 m=1
MD7 VX VX VIN VDD pch l=0.15 w=1 nf=1 m=1
MPT VOUT net6 VIN VDD pch l=0.15 w=1 nf=1 m=1
RF1 VOUT VFB 1k
RF2 VFB VSS 1k
.ends dut
