* official Analog Canvas netlist; PDK X cards rewritten by convert.py
.model nch nmos
.model pch pmos
.model qpnp pnp

.subckt dut VDD VSS VB1 VB2 Vout
M1 net6 VB1 VDD VDD pch l=0.15 w=1 nf=1 m=1
M10 net2 VB4 VSS VSS nch l=0.15 w=1 nf=1 m=1
M11 VC VB4 VSS VSS nch l=0.15 w=1 nf=1 m=1
M12 VB4 VB4 VSS VSS nch l=0.15 w=1 nf=1 m=1
M13 VB3 net0 VDD VDD pch l=0.15 w=1 nf=1 m=1
M14 VB3 VB3 VB4 VSS nch l=0.15 w=1 nf=1 m=1
M15 net0 net0 net3 VDD pch l=0.15 w=1 nf=1 m=1
M2 X VA VDD VDD pch l=0.15 w=1 nf=1 m=1
M3 net4 VA VDD VDD pch l=0.15 w=1 nf=1 m=1
M4 VC X net6 VDD pch l=0.15 w=1 nf=1 m=1
M5 net2 Y net6 VDD pch l=0.15 w=1 nf=1 m=1
M6 Vout VB2 X VDD pch l=0.15 w=1 nf=1 m=1
M7 VA VB2 net4 VDD pch l=0.15 w=1 nf=1 m=1
M8 Vout VB3 net2 VSS nch l=0.15 w=1 nf=1 m=1
M9 VA VB3 VC VSS nch l=0.15 w=1 nf=1 m=1
Q1 VSS VSS VC qpnp m=1
Q2 VC VC X qpnp m=1
Q3 VSS VSS net5 qpnp m=1
Q4 net5 net5 net1 qpnp m=1
R1 Vout X 1k
R2 Vout Y 1k
R3 Y net1 1k
R4 VDD net3 1k
R5 net0 VSS 1k
.ends dut
