* official Analog Canvas netlist; PDK X cards rewritten by convert.py
.model nch nmos

.subckt dut VDD VSS Vb2 Vb1
I1 VDD Vb2 DC 50uA
M1 Vb1 Vb1 VSS VSS nch l=0.15 w=1 nf=1 m=1
M2 net0 Vb1 VSS VSS nch l=0.15 w=1 nf=1 m=1
M3 VDD Vb2 net0 VSS nch l=0.15 w=1 nf=1 m=1
M4 net1 Vb1 VSS VSS nch l=0.15 w=1 nf=1 m=1
M5 VDD Vb2 net1 VSS nch l=0.15 w=1 nf=1 m=1
R1 Vb2 Vb1 10kΩ
.ends dut
