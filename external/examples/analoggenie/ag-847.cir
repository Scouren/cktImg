* official Analog Canvas netlist; PDK X cards rewritten by convert.py
.model qnpn npn
.model qpnp pnp

.subckt dut VCC VEE vi1 vi2 vo
IBIAS VCC net0 DC 1m
Q1 net1 vi1 net2 VEE qnpn m=1
Q2 vo vi2 net2 VEE qnpn m=1
Q3 net1 net1 VCC qpnp m=1
Q4 vo net1 VCC qpnp m=1
Q5 net2 net0 VEE VEE qnpn m=1
Q6 net0 net0 VEE VEE qnpn m=1
.ends dut
