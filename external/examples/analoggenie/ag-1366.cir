* official Analog Canvas netlist; PDK X cards rewritten by convert.py
.model nch nmos
.model pch pmos

.subckt comp VDD VSS OUT INN VB2 VB1
M1 net9 VC VDD VDD pch l=0.15 w=1 nf=1 m=1
M10 VX INN net8 VDD pch l=0.15 w=1 nf=1 m=1
M11 VX VBN net4 VSS nch l=0.15 w=1 nf=1 m=1
M12 net4 VX VSS VSS nch l=0.15 w=1 nf=1 m=1
M13 VY OUT net8 VDD pch l=0.15 w=1 nf=1 m=1
M14 VY VBN net7 VSS nch l=0.15 w=1 nf=1 m=1
M15 net7 VY VSS VSS nch l=0.15 w=1 nf=1 m=1
M16 net1 net1 net2 VDD pch l=0.15 w=1 nf=1 m=1
M17 VBN net1 VDD VDD pch l=0.15 w=1 nf=1 m=1
M18 VBN VBN net0 VSS nch l=0.15 w=1 nf=1 m=1
M19 net0 VBN VSS VSS nch l=0.15 w=1 nf=1 m=1
M2 OUT VB1 net9 VDD pch l=0.15 w=1 nf=1 m=1
M3 OUT VBN net3 VSS nch l=0.15 w=1 nf=1 m=1
M4 net3 VX VSS VSS nch l=0.15 w=1 nf=1 m=1
M5 net6 VC VDD VDD pch l=0.15 w=1 nf=1 m=1
M6 VC VB1 net6 VDD pch l=0.15 w=1 nf=1 m=1
M7 VC VBN net5 VSS nch l=0.15 w=1 nf=1 m=1
M8 net5 VY VSS VSS nch l=0.15 w=1 nf=1 m=1
M9 net8 VB2 VDD VDD pch l=0.15 w=1 nf=1 m=1
R1 VDD net2 1k
R2 net1 VSS 1k
.ends comp

.subckt dut VDD VSS VSTO VOUT VCONT1 VCONT2 VCONT3 VB1 VB2
CL VOUT VSS 1p
CSTO VSTO VSS 1p
LRX net0 net2 1n
MN1 net0 VCONT2 VSS VSS nch l=0.15 w=1 nf=1 m=1
MN2 net2 VCONT3 VSS VSS nch l=0.15 w=1 nf=1 m=1
MP2 net2 net1 VOUT VDD pch l=0.15 w=1 nf=1 m=1
MP3 net0 VCONT1 VSTO VDD pch l=0.15 w=1 nf=1 m=1
X1 VDD VSS net1 net2 VB2 VB1 comp
.ends dut
