* official Analog Canvas netlist; PDK X cards rewritten by convert.py
.model nch nmos
.model pch pmos

.subckt ErrorAmp VDD VSS VREF OUT
M10 net0 VREF net5 VSS nch l=0.15 w=1 nf=1 m=1
M11 net2 OUT net5 VSS nch l=0.15 w=1 nf=1 m=1
M12 net5 net3 VSS VSS nch l=0.15 w=1 nf=1 m=1
M13 net3 net1 VDD VDD pch l=0.15 w=1 nf=1 m=1
M14 net1 net1 VDD VDD pch l=0.15 w=1 nf=1 m=1
M15 VB1 net1 VDD VDD pch l=0.15 w=1 nf=1 m=1
M16 net3 net3 VSS VSS nch l=0.15 w=1 nf=1 m=1
M17 net1 VB1 net4 VSS nch l=0.15 w=1 nf=1 m=1
M18 VB1 VB1 VSS VSS nch l=0.15 w=1 nf=1 m=1
M4 net0 net0 VDD VDD pch l=0.15 w=1 nf=1 m=1
M5 OUT net0 VDD VDD pch l=0.15 w=1 nf=1 m=1
M6 OUT net2 VDD VDD pch l=0.15 w=1 nf=1 m=1
M7 net2 net2 VDD VDD pch l=0.15 w=1 nf=1 m=1
M8 OUT OUT VSS VSS nch l=0.15 w=1 nf=1 m=1
M9 OUT OUT VSS VSS nch l=0.15 w=1 nf=1 m=1
R1 net4 VSS 1k
.ends ErrorAmp

.subckt dut VDD VSS VIN VREF VOUT VERR pb
M1 net0 VEAOUT VIN VDD pch l=0.15 w=1 nf=1 m=1
M2 net2 net2 net0 VDD pch l=0.15 w=1 nf=1 m=1
M3 net2 nb VSS VSS nch l=0.15 w=1 nf=1 m=1
MBIAS VERR nb VSS VSS nch l=0.15 w=1 nf=1 m=1
MCHG net3 pb VIN VDD pch l=0.15 w=1 nf=1 m=1
MCTRL VERR net2 VOUT VDD pch l=0.15 w=1 nf=1 m=1
MGEN net1 net1 VSS VSS nch l=0.15 w=1 nf=1 m=1
MINJ VERR net1 VSS VSS nch l=0.15 w=1 nf=1 m=1
MRES VOUT VERR VIN VDD pch l=0.15 w=1 nf=1 m=1
MSEN net1 VEAOUT net3 VDD pch l=0.15 w=1 nf=1 m=1
X1 VDD VSS VREF VEAOUT ErrorAmp
.ends dut
