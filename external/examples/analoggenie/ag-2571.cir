* official Analog Canvas netlist; PDK X cards rewritten by convert.py
.model nch nmos
.model pch pmos

.subckt dut VDD VSS biasp biascas biasn Vout Vref
C1 Vset VSS 1p
C2 n3 Vout 1p
M1 Vout n3 VDD VDD pch l=0.15 w=1 nf=1 m=1
M10 net4 VB1 VDD VDD pch l=0.15 w=1 nf=1 m=1
M11 n3 VB3 net5 VDD pch l=0.15 w=1 nf=1 m=1
M12 Vset VB3 net4 VDD pch l=0.15 w=1 nf=1 m=1
M13 n3 VX net2 VSS nch l=0.15 w=1 nf=1 m=1
M14 Vset VX n1 VSS nch l=0.15 w=1 nf=1 m=1
M15 net2 n3 VSS VSS nch l=0.15 w=1 nf=1 m=1
M16 n1 n3 VSS VSS nch l=0.15 w=1 nf=1 m=1
M17 VX net0 VDD VDD pch l=0.15 w=1 nf=1 m=1
M18 VX VX net6 VSS nch l=0.15 w=1 nf=1 m=1
M19 net6 VX VSS VSS nch l=0.15 w=1 nf=1 m=1
M2 n1 Vset Vout VDD pch l=0.15 w=1 nf=1 m=1
M20 net0 net0 net1 VDD pch l=0.15 w=1 nf=1 m=1
M3 n1 biasn VSS VSS nch l=0.15 w=1 nf=1 m=1
M4 n3 biasp VDD VDD pch l=0.15 w=1 nf=1 m=1
M5 n3 biascas n1 VSS nch l=0.15 w=1 nf=1 m=1
M6 net5 fb net3 VSS nch l=0.15 w=1 nf=1 m=1
M7 net4 Vref net3 VSS nch l=0.15 w=1 nf=1 m=1
M8 net3 VB2 VSS VSS nch l=0.15 w=1 nf=1 m=1
M9 net5 VB1 VDD VDD pch l=0.15 w=1 nf=1 m=1
R1 fb VSS 1k
R2 Vout fb 1k
R3 VDD net1 1k
R4 net0 VSS 1k
.ends dut
