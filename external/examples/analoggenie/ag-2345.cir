* official Analog Canvas netlist; PDK X cards rewritten by convert.py
.model nch nmos
.model pch pmos

.subckt BIAS VDD VSS VX VB3
M10 net1 net1 VDD VDD pch l=0.15 w=1 nf=1 m=1
M11 VB3 net1 VDD VDD pch l=0.15 w=1 nf=1 m=1
M12 net1 net0 VSS VSS nch l=0.15 w=1 nf=1 m=1
M22 VB3 VB3 VSS VSS nch l=0.15 w=1 nf=1 m=1
M23 VB1 VB3 VSS VSS nch l=0.15 w=1 nf=1 m=1
M24 VB1 VB1 VDD VDD pch l=0.15 w=1 nf=1 m=1
M25 net0 net0 VSS VSS nch l=0.15 w=1 nf=1 m=1
M26 VX net0 VSS VSS nch l=0.15 w=1 nf=1 m=1
M27 net0 VX VDD VDD pch l=0.15 w=1 nf=1 m=1
M28 VX VX VDD VDD pch l=0.15 w=1 nf=1 m=1
R3 VDD net0 1k
.ends BIAS

.subckt dut VDD VSS VREF VB4 IBUF VIN VOUT
CL VOUT net0 1p
M1 net2 net2 VDD VDD pch l=0.15 w=1 nf=1 m=1
M13 net3 VB4 VDD VDD pch l=0.15 w=1 nf=1 m=1
M14 VY EAO net3 VDD pch l=0.15 w=1 nf=1 m=1
M15 VY VY VSS VSS nch l=0.15 w=1 nf=1 m=1
M16 GATE VY VSS VSS nch l=0.15 w=1 nf=1 m=1
M17 VDD net3 GATE VSS nch l=0.15 w=1 nf=1 m=1
M18 net1 EAO IBUF VSS nch l=0.15 w=1 nf=1 m=1
M19 net1 net1 VDD VDD pch l=0.15 w=1 nf=1 m=1
M2 net4 net4 VDD VDD pch l=0.15 w=1 nf=1 m=1
M20 GATE net1 VDD VDD pch l=0.15 w=1 nf=1 m=1
M21 VSS IBUF GATE VDD pch l=0.15 w=1 nf=1 m=1
M3 net2 VREF VY VSS nch l=0.15 w=1 nf=1 m=1
M4 net4 FB VY VSS nch l=0.15 w=1 nf=1 m=1
M5 VY VB3 VSS VSS nch l=0.15 w=1 nf=1 m=1
M6 EAO net2 VDD VDD pch l=0.15 w=1 nf=1 m=1
M7 VX net4 VDD VDD pch l=0.15 w=1 nf=1 m=1
M8 EAO VX VSS VSS nch l=0.15 w=1 nf=1 m=1
M9 VX VX VSS VSS nch l=0.15 w=1 nf=1 m=1
MNP VIN GATE VOUT VSS nch l=0.15 w=1 nf=1 m=1
R1 FB VSS 1k
R2 VOUT FB 1k
R4 net0 VSS 1k
RL VOUT VSS 1k
X1 VDD VSS VX VB3 BIAS
.ends dut
