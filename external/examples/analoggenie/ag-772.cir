* official Analog Canvas netlist; PDK X cards rewritten by convert.py
.model nch nmos

.subckt icm_opamp_vdd_vss VDD VSS VIP VIN VOUT params: gain=1e6
Blin nlin 0 V={gain*(V(VIP)-V(VIN))}
Bcore VOUT 0 V={0.5*(V(VDD)+(0.5*(V(VSS)+V(nlin)+sqrt((V(nlin)-V(VSS))*(V(nlin)-V(VSS))+(1e-4*(V(VDD)-V(VSS)))*(1e-4*(V(VDD)-V(VSS)))+1e-12)))-sqrt((V(VDD)-(0.5*(V(VSS)+V(nlin)+sqrt((V(nlin)-V(VSS))*(V(nlin)-V(VSS))+(1e-4*(V(VDD)-V(VSS)))*(1e-4*(V(VDD)-V(VSS)))+1e-12))))*(V(VDD)-(0.5*(V(VSS)+V(nlin)+sqrt((V(nlin)-V(VSS))*(V(nlin)-V(VSS))+(1e-4*(V(VDD)-V(VSS)))*(1e-4*(V(VDD)-V(VSS)))+1e-12))))+(1e-4*(V(VDD)-V(VSS)))*(1e-4*(V(VDD)-V(VSS)))+1e-12))}
.ends icm_opamp_vdd_vss

.subckt dut VCC VSS VC Iout1 Iout2
VB1 net2 VSS DC 1
VB2 net3 VSS DC 1
I1 VCC Iout1 DC 1m
I2 VCC Iout2 DC 1m
M1 net0 net6 VSS VSS nch l=0.15 w=1 nf=1 m=1
M2 net7 net4 VSS VSS nch l=0.15 w=1 nf=1 m=1
M3 Iout1 net5 net0 VSS nch l=0.15 w=1 nf=1 m=1
M4 Iout2 net1 net7 VSS nch l=0.15 w=1 nf=1 m=1
V1 net6 net2 DC 1
V2 net4 net3 DC 1
X1 VCC VSS VC net0 net5 icm_opamp_vdd_vss gain=1e6
X2 VCC VSS VC net7 net1 icm_opamp_vdd_vss gain=1e6
.ends dut
