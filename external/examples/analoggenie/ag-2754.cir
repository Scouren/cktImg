* official Analog Canvas netlist; PDK X cards rewritten by convert.py
.model nch nmos
.model pch pmos

.subckt opamp VDD VSS INN INP OUT
M10 OUT net0 VDD VDD pch l=0.15 w=1 nf=1 m=1
M11 OUT VX VSS VSS nch l=0.15 w=1 nf=1 m=1
M12 VB2 VX VDD VDD pch l=0.15 w=1 nf=1 m=1
M13 VB2 VB2 VSS VSS nch l=0.15 w=1 nf=1 m=1
M14 VB1 VB2 VSS VSS nch l=0.15 w=1 nf=1 m=1
M15 VB1 VB1 VDD VDD pch l=0.15 w=1 nf=1 m=1
M16 VX VB2 VSS VSS nch l=0.15 w=1 nf=1 m=1
M17 VX VX VDD VDD pch l=0.15 w=1 nf=1 m=1
M3 VX INN net2 VDD pch l=0.15 w=1 nf=1 m=1
M4 net1 INP net2 VDD pch l=0.15 w=1 nf=1 m=1
M5 VX VX VSS VSS nch l=0.15 w=1 nf=1 m=1
M6 net1 net1 VSS VSS nch l=0.15 w=1 nf=1 m=1
M7 net2 VB1 VDD VDD pch l=0.15 w=1 nf=1 m=1
M8 net0 net1 VSS VSS nch l=0.15 w=1 nf=1 m=1
M9 net0 net0 VDD VDD pch l=0.15 w=1 nf=1 m=1
R1 VDD VB2 1k
.ends opamp

.subckt dut VDD VSS vci phi1 phi2 vco
C1 net1 VSS 1p
C2 net0 vco 1p
M1 vci phi1 net1 VSS nch l=0.15 w=1 nf=1 m=1
M2 net1 phi2 net0 VSS nch l=0.15 w=1 nf=1 m=1
X1 VDD VSS net0 VSS vco opamp
.ends dut
