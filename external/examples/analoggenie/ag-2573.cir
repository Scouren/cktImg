* official Analog Canvas netlist; PDK X cards rewritten by convert.py
.model nch nmos
.model pch pmos

.subckt dut VDD VSS biasp biascas biasn Vout VB1 VB3 VB2 Vref VB4
C1 Vset VSS 1p
C2 n3 Vout 1p
M1 Vout n3 VDD VDD pch l=0.15 w=1 nf=1 m=1
M10 n3 VC net6 VSS nch l=0.15 w=1 nf=1 m=1
M11 Vset VC n1 VSS nch l=0.15 w=1 nf=1 m=1
M12 net6 n3 VSS VSS nch l=0.15 w=1 nf=1 m=1
M13 n1 n3 VSS VSS nch l=0.15 w=1 nf=1 m=1
M14 net1 fb net3 VSS nch l=0.15 w=1 nf=1 m=1
M15 net0 Vref net3 VSS nch l=0.15 w=1 nf=1 m=1
M16 net3 VB2 VSS VSS nch l=0.15 w=1 nf=1 m=1
M17 VB4 net2 VDD VDD pch l=0.15 w=1 nf=1 m=1
M18 VB4 VB4 VSS VSS nch l=0.15 w=1 nf=1 m=1
M19 net2 net2 VDD VDD pch l=0.15 w=1 nf=1 m=1
M2 n1 Vset Vout VDD pch l=0.15 w=1 nf=1 m=1
M20 net2 VB4 net5 VSS nch l=0.15 w=1 nf=1 m=1
M21 VC net2 VDD VDD pch l=0.15 w=1 nf=1 m=1
M22 VC VC net4 VSS nch l=0.15 w=1 nf=1 m=1
M23 net4 VC VSS VSS nch l=0.15 w=1 nf=1 m=1
M3 n1 biasn VSS VSS nch l=0.15 w=1 nf=1 m=1
M4 n3 biasp VDD VDD pch l=0.15 w=1 nf=1 m=1
M5 n3 biascas n1 VSS nch l=0.15 w=1 nf=1 m=1
M6 net1 VB1 VDD VDD pch l=0.15 w=1 nf=1 m=1
M7 net0 VB1 VDD VDD pch l=0.15 w=1 nf=1 m=1
M8 n3 VB3 net1 VDD pch l=0.15 w=1 nf=1 m=1
M9 Vset VB3 net0 VDD pch l=0.15 w=1 nf=1 m=1
R1 fb VSS 1k
R2 Vout fb 1k
R3 net5 VSS 1k
.ends dut
