* official Analog Canvas netlist; PDK X cards rewritten by convert.py
.model nch nmos

.subckt xfmr p_minus p_plus s_minus s_plus params: lp=1n ls=1n k=1
LP p_plus p_minus {lp}
LS s_plus s_minus {ls}
K1 LP LS {k}
.ends xfmr

.subckt dut VDD VSS VINP VINN
CD net0 net5 1p
L1 VDD net1 1n
L2 VDD net3 1n
L3 VDD VX 1n
L4 VDD VY 1n
L5 net0 net1 1n
L6 net5 net3 1n
M1 net1 VX VSS VSS nch l=0.15 w=1 nf=1 m=1
M2 net1 net3 VSS VSS nch l=0.15 w=1 nf=1 m=1
M3 net3 VY VSS VSS nch l=0.15 w=1 nf=1 m=1
M4 net3 net1 VSS VSS nch l=0.15 w=1 nf=1 m=1
M5 VX VINP VSS VSS nch l=0.15 w=1 nf=1 m=1
M6 VX VY VSS VSS nch l=0.15 w=1 nf=1 m=1
M7 VY VINN VSS VSS nch l=0.15 w=1 nf=1 m=1
M8 VY VX VSS VSS nch l=0.15 w=1 nf=1 m=1
RL net2 net4 1k
X1 net5 net0 net4 net2 xfmr lp=1n ls=1n k=1
.ends dut
