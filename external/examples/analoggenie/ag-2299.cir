* official Analog Canvas netlist; PDK X cards rewritten by convert.py
.model nch nmos
.model pch pmos

.subckt bias VDD VSS VB1
M22 net1 net1 VDD VDD pch l=0.15 w=1 nf=1 m=1
M23 net0 net1 VDD VDD pch l=0.15 w=1 nf=1 m=1
M24 net1 net0 VSS VSS nch l=0.15 w=1 nf=1 m=1
M25 net3 net0 VSS VSS nch l=0.15 w=1 nf=1 m=1
M26 VB1 net1 VDD VDD pch l=0.15 w=1 nf=1 m=1
M27 VB1 VB1 net2 VSS nch l=0.15 w=1 nf=1 m=1
M28 net2 VB1 VSS VSS nch l=0.15 w=1 nf=1 m=1
R4 net0 net3 1k
.ends bias

.subckt dut VDD VSS VREF VB5 VB4 IBUF VIN VOUT
CL VOUT net1 1p
M10 EAO VB2 net6 VDD pch l=0.15 w=1 nf=1 m=1
M11 net8 VB3 VDD VDD pch l=0.15 w=1 nf=1 m=1
M12 net6 VB3 VDD VDD pch l=0.15 w=1 nf=1 m=1
M13 net3 VB4 VDD VDD pch l=0.15 w=1 nf=1 m=1
M14 net2 EAO net3 VDD pch l=0.15 w=1 nf=1 m=1
M15 net2 net2 VSS VSS nch l=0.15 w=1 nf=1 m=1
M16 GATE net2 VSS VSS nch l=0.15 w=1 nf=1 m=1
M17 VDD net3 GATE VSS nch l=0.15 w=1 nf=1 m=1
M18 net4 EAO IBUF VSS nch l=0.15 w=1 nf=1 m=1
M19 net4 net4 VDD VDD pch l=0.15 w=1 nf=1 m=1
M2 net7 VB5 VSS VSS nch l=0.15 w=1 nf=1 m=1
M20 GATE net4 VDD VDD pch l=0.15 w=1 nf=1 m=1
M21 VSS IBUF GATE VDD pch l=0.15 w=1 nf=1 m=1
M3 net6 VREF net7 VSS nch l=0.15 w=1 nf=1 m=1
M4 net8 FB net7 VSS nch l=0.15 w=1 nf=1 m=1
M5 net9 net5 VSS VSS nch l=0.15 w=1 nf=1 m=1
M6 net0 net5 VSS VSS nch l=0.15 w=1 nf=1 m=1
M7 net5 VB1 net9 VSS nch l=0.15 w=1 nf=1 m=1
M8 EAO VB1 net0 VSS nch l=0.15 w=1 nf=1 m=1
M9 net5 VB2 net8 VDD pch l=0.15 w=1 nf=1 m=1
MNP VIN GATE VOUT VSS nch l=0.15 w=1 nf=1 m=1
R1 FB VSS 1k
R2 VOUT FB 1k
R3 net1 VSS 1k
RL VOUT VSS 1k
X1 VDD VSS VB1 bias
.ends dut
