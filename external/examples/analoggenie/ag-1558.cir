* official Analog Canvas netlist; PDK X cards rewritten by convert.py
.model nch nmos
.model pch pmos
.model qpnp pnp

.subckt opamp VDD VSS INP INN OUT VB1 VB2
M1 net8 net7 VDD VDD pch l=0.15 w=1 nf=1 m=1
M10 VX VB1 net9 VDD pch l=0.15 w=1 nf=1 m=1
M11 net7 VB1 net8 VDD pch l=0.15 w=1 nf=1 m=1
M12 net2 VB1 net1 VDD pch l=0.15 w=1 nf=1 m=1
M13 OUT VC net10 VSS nch l=0.15 w=1 nf=1 m=1
M14 VX VC net11 VSS nch l=0.15 w=1 nf=1 m=1
M15 net2 INN net4 VSS nch l=0.15 w=1 nf=1 m=1
M16 VC VC net3 VSS nch l=0.15 w=1 nf=1 m=1
M17 net3 VC VSS VSS nch l=0.15 w=1 nf=1 m=1
M19 VC VP VDD VDD pch l=0.15 w=1 nf=1 m=1
M2 net1 net2 VDD VDD pch l=0.15 w=1 nf=1 m=1
M20 net0 VP VDD VDD pch l=0.15 w=1 nf=1 m=1
M21 VP VP VDD VDD pch l=0.15 w=1 nf=1 m=1
M22 VB3 VP VDD VDD pch l=0.15 w=1 nf=1 m=1
M23 net0 net0 VSS VSS nch l=0.15 w=1 nf=1 m=1
M24 net5 net0 VSS VSS nch l=0.15 w=1 nf=1 m=1
M25 VP VB3 net5 VSS nch l=0.15 w=1 nf=1 m=1
M26 VB3 VB3 VSS VSS nch l=0.15 w=1 nf=1 m=1
M3 net7 INP net4 VSS nch l=0.15 w=1 nf=1 m=1
M4 net4 VB2 VSS VSS nch l=0.15 w=1 nf=1 m=1
M5 net6 net7 VDD VDD pch l=0.15 w=1 nf=1 m=1
M6 net9 net2 VDD VDD pch l=0.15 w=1 nf=1 m=1
M7 net10 VX VSS VSS nch l=0.15 w=1 nf=1 m=1
M8 net11 VX VSS VSS nch l=0.15 w=1 nf=1 m=1
M9 OUT VB1 net6 VDD pch l=0.15 w=1 nf=1 m=1
.ends opamp

.subckt dut VDD VSS Vout VB1 VB2
Q1 VSS VSS X qpnp m=1
Q2 VSS VSS net0 qpnp m=1
R1 Vout X 1k
R2 Vout Y 1k
R3 Y net0 1k
X1 VDD VSS X Y Vout VB1 VB2 opamp
.ends dut
