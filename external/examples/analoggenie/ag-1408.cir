* official Analog Canvas netlist; PDK X cards rewritten by convert.py
.model nch nmos
.model pch pmos

.subckt comparator VDD VSS INN OUT
M1 VX net0 VDD VDD pch l=0.15 w=1 nf=1 m=1
M10 VB1 net1 VDD VDD pch l=0.15 w=1 nf=1 m=1
M11 net1 net1 VDD VDD pch l=0.15 w=1 nf=1 m=1
M12 VB1 VB1 VSS VSS nch l=0.15 w=1 nf=1 m=1
M13 net1 VB1 VSS VSS nch l=0.15 w=1 nf=1 m=1
M14 VB2 net1 VDD VDD pch l=0.15 w=1 nf=1 m=1
M15 VB2 VB2 VSS VSS nch l=0.15 w=1 nf=1 m=1
M2 net0 net0 VDD VDD pch l=0.15 w=1 nf=1 m=1
M3 VX VX VSS VSS nch l=0.15 w=1 nf=1 m=1
M4 net0 INN net2 VSS nch l=0.15 w=1 nf=1 m=1
M5 net2 VB2 VSS VSS nch l=0.15 w=1 nf=1 m=1
M6 OUT OUT VDD VDD pch l=0.15 w=1 nf=1 m=1
M7 OUT OUT VDD VDD pch l=0.15 w=1 nf=1 m=1
M8 OUT OUT net2 VSS nch l=0.15 w=1 nf=1 m=1
M9 OUT VX VSS VSS nch l=0.15 w=1 nf=1 m=1
.ends comparator

.subckt dut VDD VSS VSTO VCONT1 VCONT2 VCONT3 VOUT
CL VOUT VSS 1p
CSTO VSTO VSS 1p
LRX net2 net1 1n
MN1 net2 VCONT2 VSS VSS nch l=0.15 w=1 nf=1 m=1
MN2 net1 VCONT3 VSS VSS nch l=0.15 w=1 nf=1 m=1
MP2 net1 net0 VOUT VDD pch l=0.15 w=1 nf=1 m=1
MP3 net2 VCONT1 VSTO VDD pch l=0.15 w=1 nf=1 m=1
X1 VDD VSS net1 net0 comparator
.ends dut
