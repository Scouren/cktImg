* official Analog Canvas netlist; PDK X cards rewritten by convert.py
.model nch nmos
.model pch pmos

.subckt dut VDD VSS GND vi2 vi1 VBIAS vout
Cc vout GND 1p
M1 net3 vi2 net4 VSS nch l=0.15 w=1 nf=1 m=1
M10 vout net6 net2 VDD pch l=0.15 w=1 nf=1 m=1
M11 vout net7 net1 VSS nch l=0.15 w=1 nf=1 m=1
M12 net6 VBIAS VSS VSS nch l=0.15 w=1 nf=1 m=1
M13 net6 net6 VDD VDD pch l=0.15 w=1 nf=1 m=1
M14 net7 net6 VDD VDD pch l=0.15 w=1 nf=1 m=1
M15 net7 net7 VSS VSS nch l=0.15 w=1 nf=1 m=1
M2 net0 vi1 net4 VSS nch l=0.15 w=1 nf=1 m=1
M3 net3 net3 VDD VDD pch l=0.15 w=1 nf=1 m=1
M4 net0 net0 VDD VDD pch l=0.15 w=1 nf=1 m=1
M5 net4 VBIAS VSS VSS nch l=0.15 w=1 nf=1 m=1
M6 net2 net0 VDD VDD pch l=0.15 w=1 nf=1 m=1
M7 net1 net5 VSS VSS nch l=0.15 w=1 nf=1 m=1
M8 net5 net3 VDD VDD pch l=0.15 w=1 nf=1 m=1
M9 net5 net5 VSS VSS nch l=0.15 w=1 nf=1 m=1
.ends dut
