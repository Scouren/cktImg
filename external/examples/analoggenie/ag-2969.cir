* official Analog Canvas netlist; PDK X cards rewritten by convert.py
.model nch nmos
.model pch pmos

.subckt opamp VDD VSS INN INP OUT
C3 net6 OUT 1p
M10 VP VP VDD VDD pch l=0.15 w=1 nf=1 m=1
M11 net1 VP VDD VDD pch l=0.15 w=1 nf=1 m=1
M12 net4 VP VDD VDD pch l=0.15 w=1 nf=1 m=1
M13 VB2 VP VDD VDD pch l=0.15 w=1 nf=1 m=1
M14 VB3 VP VDD VDD pch l=0.15 w=1 nf=1 m=1
M15 VB1 VB1 VDD VDD pch l=0.15 w=1 nf=1 m=1
M16 VP net2 VSS VSS nch l=0.15 w=1 nf=1 m=1
M17 net1 net1 net2 VSS nch l=0.15 w=1 nf=1 m=1
M18 net2 net1 net5 VSS nch l=0.15 w=1 nf=1 m=1
M19 net4 net4 net5 VSS nch l=0.15 w=1 nf=1 m=1
M20 VB2 net4 net5 VSS nch l=0.15 w=1 nf=1 m=1
M21 VB2 VB2 VSS VSS nch l=0.15 w=1 nf=1 m=1
M22 VB3 VB3 VSS VSS nch l=0.15 w=1 nf=1 m=1
M23 VB1 VB3 VSS VSS nch l=0.15 w=1 nf=1 m=1
M3 net0 net0 VDD VDD pch l=0.15 w=1 nf=1 m=1
M4 net6 net0 VDD VDD pch l=0.15 w=1 nf=1 m=1
M5 net0 INN net3 VSS nch l=0.15 w=1 nf=1 m=1
M6 net6 INP net3 VSS nch l=0.15 w=1 nf=1 m=1
M7 net3 VB3 VSS VSS nch l=0.15 w=1 nf=1 m=1
M8 OUT net6 VDD VDD pch l=0.15 w=1 nf=1 m=1
M9 OUT VB3 VSS VSS nch l=0.15 w=1 nf=1 m=1
.ends opamp

.subckt dut VDD VSS vci phi1 phi2 vco
C1 vcx VSS 1p
C2 net0 vco 1p
M1 vci phi1 vcx VSS nch l=0.15 w=1 nf=1 m=1
M2 vcx phi2 net0 VSS nch l=0.15 w=1 nf=1 m=1
X1 VDD VSS net0 VSS vco opamp
.ends dut
