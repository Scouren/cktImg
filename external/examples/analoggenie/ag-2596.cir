* official Analog Canvas netlist; PDK X cards rewritten by convert.py
.model nch nmos
.model pch pmos

.subckt AMP1 VDD VSS INN INP OUT
M10 net1 VB1 VSS VSS nch l=0.15 w=1 nf=1 m=1
M11 VBN VBN VSS VSS nch l=0.15 w=1 nf=1 m=1
M12 net0 net4 VDD VDD pch l=0.15 w=1 nf=1 m=1
M13 net4 net4 VDD VDD pch l=0.15 w=1 nf=1 m=1
M14 INN INN VDD VDD pch l=0.15 w=1 nf=1 m=1
M15 OUT INN VDD VDD pch l=0.15 w=1 nf=1 m=1
M16 net4 INN net2 VSS nch l=0.15 w=1 nf=1 m=1
M17 INN INP net2 VSS nch l=0.15 w=1 nf=1 m=1
M18 net2 VBN VSS VSS nch l=0.15 w=1 nf=1 m=1
M19 net0 net0 VSS VSS nch l=0.15 w=1 nf=1 m=1
M20 OUT net0 VSS VSS nch l=0.15 w=1 nf=1 m=1
M6 VB1 net1 VDD VDD pch l=0.15 w=1 nf=1 m=1
M7 net1 net1 VDD VDD pch l=0.15 w=1 nf=1 m=1
M8 VBN net1 VDD VDD pch l=0.15 w=1 nf=1 m=1
M9 net3 VB1 VSS VSS nch l=0.15 w=1 nf=1 m=1
R3 VB1 net3 1k
.ends AMP1

.subckt dut VDD VSS biasp biascas biasn Vref Vout
C1 Vset VSS 1p
C2 n3 Vout 1p
M1 Vout n3 VDD VDD pch l=0.15 w=1 nf=1 m=1
M2 n1 Vset Vout VDD pch l=0.15 w=1 nf=1 m=1
M3 n1 biasn VSS VSS nch l=0.15 w=1 nf=1 m=1
M4 n3 biasp VDD VDD pch l=0.15 w=1 nf=1 m=1
M5 n3 biascas n1 VSS nch l=0.15 w=1 nf=1 m=1
R1 fb VSS 1k
R2 Vout fb 1k
X1 VDD VSS fb Vref Vset AMP1
.ends dut
