* official Analog Canvas netlist; PDK X cards rewritten by convert.py
.model nch nmos
.model pch pmos

.subckt dut VDD VSS VSTO VCONT1 VCONT2 VCONT3 VOUT VB1
CL VOUT VSS 1p
CSTO VSTO VSS 1p
LRX net6 VX 1n
M1 VG net0 VSS VSS nch l=0.15 w=1 nf=1 m=1
M10 net3 net3 VDD VDD pch l=0.15 w=1 nf=1 m=1
M11 VBN net3 VDD VDD pch l=0.15 w=1 nf=1 m=1
M12 VB1 VB1 VDD VDD pch l=0.15 w=1 nf=1 m=1
M13 net3 VBN2 VSS VSS nch l=0.15 w=1 nf=1 m=1
M14 VBN VBN VSS VSS nch l=0.15 w=1 nf=1 m=1
M15 VB1 VBN VSS VSS nch l=0.15 w=1 nf=1 m=1
M16 VB2 VB2 VDD VDD pch l=0.15 w=1 nf=1 m=1
M17 VBN2 VB2 VDD VDD pch l=0.15 w=1 nf=1 m=1
M18 VB2 VY VSS VSS nch l=0.15 w=1 nf=1 m=1
M19 net5 VB2 VDD VDD pch l=0.15 w=1 nf=1 m=1
M2 net0 net0 VSS VSS nch l=0.15 w=1 nf=1 m=1
M20 net2 VB2 VDD VDD pch l=0.15 w=1 nf=1 m=1
M21 net5 net5 net1 VSS nch l=0.15 w=1 nf=1 m=1
M22 net1 net5 VBN2 VSS nch l=0.15 w=1 nf=1 m=1
M23 VBN2 VBN2 VSS VSS nch l=0.15 w=1 nf=1 m=1
M24 net2 net2 VY VSS nch l=0.15 w=1 nf=1 m=1
M25 VY net2 net1 VSS nch l=0.15 w=1 nf=1 m=1
M3 net0 net4 VDD VDD pch l=0.15 w=1 nf=1 m=1
M4 net4 net4 VDD VDD pch l=0.15 w=1 nf=1 m=1
M5 net4 VX net7 VSS nch l=0.15 w=1 nf=1 m=1
M6 VG VG VDD VDD pch l=0.15 w=1 nf=1 m=1
M7 VG VG VDD VDD pch l=0.15 w=1 nf=1 m=1
M8 VG VG net7 VSS nch l=0.15 w=1 nf=1 m=1
M9 net7 VBN VSS VSS nch l=0.15 w=1 nf=1 m=1
MN1 net6 VCONT2 VSS VSS nch l=0.15 w=1 nf=1 m=1
MN2 VX VCONT3 VSS VSS nch l=0.15 w=1 nf=1 m=1
MP2 VX VG VOUT VDD pch l=0.15 w=1 nf=1 m=1
MP3 net6 VCONT1 VSTO VDD pch l=0.15 w=1 nf=1 m=1
.ends dut
