* official Analog Canvas netlist; PDK X cards rewritten by convert.py
.model nch nmos
.model pch pmos
.model qpnp pnp

.subckt opamp VDD VSS INN INP VB2 OUT VX VB1
M1 net2 INN net4 VSS nch l=0.15 w=1 nf=1 m=1
M10 OUT VB1 net1 VDD pch l=0.15 w=1 nf=1 m=1
M11 net5 VB4 net6 VSS nch l=0.15 w=1 nf=1 m=1
M12 OUT VB4 VX VSS nch l=0.15 w=1 nf=1 m=1
M13 net6 net5 VSS VSS nch l=0.15 w=1 nf=1 m=1
M14 VX net5 VSS VSS nch l=0.15 w=1 nf=1 m=1
M15 net4 VB2 VSS VSS nch l=0.15 w=1 nf=1 m=1
M16 VB3 VB3 VSS VSS nch l=0.15 w=1 nf=1 m=1
M17 VB3 net0 VDD VDD pch l=0.15 w=1 nf=1 m=1
M18 net0 VB3 VSS VSS nch l=0.15 w=1 nf=1 m=1
M19 net0 net0 VDD VDD pch l=0.15 w=1 nf=1 m=1
M2 net7 INP net4 VSS nch l=0.15 w=1 nf=1 m=1
M20 VB4 net0 VDD VDD pch l=0.15 w=1 nf=1 m=1
M21 VB4 VB4 net9 VSS nch l=0.15 w=1 nf=1 m=1
M22 net9 VB4 VSS VSS nch l=0.15 w=1 nf=1 m=1
M3 net10 net2 VDD VDD pch l=0.15 w=1 nf=1 m=1
M4 net3 net7 VDD VDD pch l=0.15 w=1 nf=1 m=1
M5 net8 net2 VDD VDD pch l=0.15 w=1 nf=1 m=1
M6 net1 net7 VDD VDD pch l=0.15 w=1 nf=1 m=1
M7 net5 VB1 net8 VDD pch l=0.15 w=1 nf=1 m=1
M8 net2 VB1 net10 VDD pch l=0.15 w=1 nf=1 m=1
M9 net7 VB1 net3 VDD pch l=0.15 w=1 nf=1 m=1
.ends opamp

.subckt dut VDD VSS Vout VB1 VB2
Q1 VSS VSS net4 qpnp m=1
Q2 net4 net4 net1 qpnp m=1
Q3 VSS VSS net0 qpnp m=1
Q4 net0 net0 net2 qpnp m=1
R1 Vout net1 1k
R2 Vout net3 1k
R3 net3 net2 1k
X1 VDD VSS net3 net1 VB2 Vout net2 VB1 opamp
.ends dut
