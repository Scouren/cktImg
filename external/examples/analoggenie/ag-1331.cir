* official Analog Canvas netlist; PDK X cards rewritten by convert.py
.model nch nmos
.model pch pmos

.subckt dut VDD VSS VIN VCONT4 VCONT5 VP VREF VB3
.model DIODE D(IS=1e-14 N=1)
CFLY VX1 VX2 1p
CO VP VN 1p
COP VP VSS 1p
D1 VN VX2 DIODE
L1 VX1 net6 1n
M1 VX1 VCONT2 VIN VDD pch l=0.15 w=1 nf=1 m=1
M10 net4 VBP VDD VDD pch l=0.15 w=1 nf=1 m=1
M11 net2 VFP1 net4 VDD pch l=0.15 w=1 nf=1 m=1
M12 VX2 VREF net4 VDD pch l=0.15 w=1 nf=1 m=1
M13 net2 net2 VSS VSS nch l=0.15 w=1 nf=1 m=1
M14 VX2 VX2 VSS VSS nch l=0.15 w=1 nf=1 m=1
M15 net3 VCTRL VSR VDD pch l=0.15 w=1 nf=1 m=1
M16 net3 net3 VSS VSS nch l=0.15 w=1 nf=1 m=1
M17 net3 VB3 VSS VSS nch l=0.15 w=1 nf=1 m=1
M18 net1 net3 VSS VSS nch l=0.15 w=1 nf=1 m=1
M19 net1 net1 VSR VDD pch l=0.15 w=1 nf=1 m=1
M2 VX2 VCONT3 VIN VDD pch l=0.15 w=1 nf=1 m=1
M20 VX1 net1 VSR VDD pch l=0.15 w=1 nf=1 m=1
M21 VBP VBP VDD VDD pch l=0.15 w=1 nf=1 m=1
M22 VBP VB1 VSS VSS nch l=0.15 w=1 nf=1 m=1
M23 VB1 net5 VDD VDD pch l=0.15 w=1 nf=1 m=1
M24 VB1 VB1 VSS VSS nch l=0.15 w=1 nf=1 m=1
M25 net5 net5 VDD VDD pch l=0.15 w=1 nf=1 m=1
M26 net5 net7 VB2 VSS nch l=0.15 w=1 nf=1 m=1
M27 net7 net5 VDD VDD pch l=0.15 w=1 nf=1 m=1
M28 net7 VB2 VSS VSS nch l=0.15 w=1 nf=1 m=1
M3 net6 VCONT5 VP VDD pch l=0.15 w=1 nf=1 m=1
M4 net6 VCONT4 VSS VSS nch l=0.15 w=1 nf=1 m=1
M5 VSR VCONT1 VIN VDD pch l=0.15 w=1 nf=1 m=1
M6 net0 net0 VDD VDD pch l=0.15 w=1 nf=1 m=1
M7 VCTRL net0 VDD VDD pch l=0.15 w=1 nf=1 m=1
M8 net0 VX2 VSS VSS nch l=0.15 w=1 nf=1 m=1
M9 VCTRL net2 VSS VSS nch l=0.15 w=1 nf=1 m=1
R1 VP VFP1 1k
R2 VFP1 VSS 1k
RBIAS VB2 VSS 1k
.ends dut
