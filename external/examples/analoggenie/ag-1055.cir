* official Analog Canvas netlist; PDK X cards rewritten by convert.py
.model nch nmos
.model pch pmos

.subckt dut VDD VSS OUT+ OUT- CLK_bar Vinp Vinn CLK
Ctail Vcap VSS 1p
M1 Di- Vinp Vs VSS nch l=0.15 w=1 nf=1 m=1
M10 OUT+ OUT- VSS VSS nch l=0.15 w=1 nf=1 m=1
M11 OUT- OUT+ VSS VSS nch l=0.15 w=1 nf=1 m=1
M12 OUT+ CLK_bar VSS VSS nch l=0.15 w=1 nf=1 m=1
M13 OUT- CLK_bar VSS VSS nch l=0.15 w=1 nf=1 m=1
M2 Di+ Vinn Vs VSS nch l=0.15 w=1 nf=1 m=1
M3a Vs CLK Vcap VSS nch l=0.15 w=1 nf=1 m=1
M3b Vcap CLK_bar VSS VSS nch l=0.15 w=1 nf=1 m=1
M4 Di- CLK VDD VDD pch l=0.15 w=1 nf=1 m=1
M5 Di+ CLK VDD VDD pch l=0.15 w=1 nf=1 m=1
M6 OUT+ Di- net0 VDD pch l=0.15 w=1 nf=1 m=1
M7 OUT- Di+ net1 VDD pch l=0.15 w=1 nf=1 m=1
M8 net0 OUT- VDD VDD pch l=0.15 w=1 nf=1 m=1
M9 net1 OUT+ VDD VDD pch l=0.15 w=1 nf=1 m=1
.ends dut
