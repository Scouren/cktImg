* official Analog Canvas netlist; PDK X cards rewritten by convert.py
.model nch nmos
.model pch pmos

.subckt opamp VDD VSS INN INP OUT
M1 net5 INN net2 VDD pch l=0.15 w=1 nf=1 m=1
M10 net6 net6 VDD VDD pch l=0.15 w=1 nf=1 m=1
M11 net6 net4 VSS VSS nch l=0.15 w=1 nf=1 m=1
M12 net4 net3 VDD VDD pch l=0.15 w=1 nf=1 m=1
M13 net4 net4 VSS VSS nch l=0.15 w=1 nf=1 m=1
M14 net3 net3 VDD VDD pch l=0.15 w=1 nf=1 m=1
M15 net3 net8 VSS VSS nch l=0.15 w=1 nf=1 m=1
M16 net8 net8 net7 VSS nch l=0.15 w=1 nf=1 m=1
M2 net0 INP net2 VDD pch l=0.15 w=1 nf=1 m=1
M3 net2 net6 VDD VDD pch l=0.15 w=1 nf=1 m=1
M4 net5 net5 VSS VSS nch l=0.15 w=1 nf=1 m=1
M5 net0 net0 VSS VSS nch l=0.15 w=1 nf=1 m=1
M6 net1 net0 VSS VSS nch l=0.15 w=1 nf=1 m=1
M7 net1 net1 VDD VDD pch l=0.15 w=1 nf=1 m=1
M8 OUT net1 VDD VDD pch l=0.15 w=1 nf=1 m=1
M9 OUT net5 VSS VSS nch l=0.15 w=1 nf=1 m=1
R1 VDD net8 1k
R2 net7 VSS 1k
.ends opamp

.subckt dut VDD VSS vci phi1 phi2 vco
C1 vcx VSS 1p
C2 net0 vco 1p
M1 vci phi1 vcx VSS nch l=0.15 w=1 nf=1 m=1
M2 vcx phi2 net0 VSS nch l=0.15 w=1 nf=1 m=1
X1 VDD VSS net0 VSS vco opamp
.ends dut
