* official Analog Canvas netlist; PDK X cards rewritten by convert.py
.model nch nmos

.subckt opamp VDD VSS VIP VIN VOUT params: gain=1e6 vhigh=5 vlow=-5
Blin nlin 0 V={gain*(V(VIP)-V(VIN))}
Bcore VOUT 0 V={0.5*(vhigh+(0.5*(vlow+V(nlin)+sqrt((V(nlin)-vlow)*(V(nlin)-vlow)+(1e-4*(vhigh-vlow))*(1e-4*(vhigh-vlow))+1e-12)))-sqrt((vhigh-(0.5*(vlow+V(nlin)+sqrt((V(nlin)-vlow)*(V(nlin)-vlow)+(1e-4*(vhigh-vlow))*(1e-4*(vhigh-vlow))+1e-12))))*(vhigh-(0.5*(vlow+V(nlin)+sqrt((V(nlin)-vlow)*(V(nlin)-vlow)+(1e-4*(vhigh-vlow))*(1e-4*(vhigh-vlow))+1e-12))))+(1e-4*(vhigh-vlow))*(1e-4*(vhigh-vlow))+1e-12))}
.ends opamp

.subckt dut VSS vin vout phi2 phi1
C1 net3 net1 1p
C2 net2 net4 1p
C3 net1 net0 1p
M1 net3 phi2 vin VSS nch l=0.15 w=1 nf=1 m=1
M2 net3 phi1 VSS VSS nch l=0.15 w=1 nf=1 m=1
M3 net2 phi2 net1 VSS nch l=0.15 w=1 nf=1 m=1
M4 net1 phi1 VSS VSS nch l=0.15 w=1 nf=1 m=1
M5 net2 phi1 net0 VSS nch l=0.15 w=1 nf=1 m=1
M6 vout phi1 net4 VSS nch l=0.15 w=1 nf=1 m=1
X1 0 VSS VSS net0 net4 opamp gain=1e6
.ends dut
