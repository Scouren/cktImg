* official Analog Canvas netlist; PDK X cards rewritten by convert.py
.model nch nmos
.model pch pmos

.subckt comp VDD VSS INN IB OUT
M10 VX net0 VDD VDD pch l=0.15 w=1 nf=1 m=1
M11 net0 net0 VDD VDD pch l=0.15 w=1 nf=1 m=1
M12 OUT OUT VDD VDD pch l=0.15 w=1 nf=1 m=1
M13 OUT OUT VDD VDD pch l=0.15 w=1 nf=1 m=1
M14 VX VX VSS VSS nch l=0.15 w=1 nf=1 m=1
M15 net0 INN net1 VSS nch l=0.15 w=1 nf=1 m=1
M16 OUT OUT net1 VSS nch l=0.15 w=1 nf=1 m=1
M17 OUT VX VSS VSS nch l=0.15 w=1 nf=1 m=1
M18 net1 IB VSS VSS nch l=0.15 w=1 nf=1 m=1
.ends comp

.subckt dut VDD VSS VSTO VCONT1 VCONT2 VCONT3 VOUT
CL VOUT VSS 1p
CSTO VSTO VSS 1p
LRX net3 net2 1n
M19 VBN VB1 VDD VDD pch l=0.15 w=1 nf=1 m=1
M20 VB1 VB1 VDD VDD pch l=0.15 w=1 nf=1 m=1
M21 net1 VB2 VDD VDD pch l=0.15 w=1 nf=1 m=1
M22 VB2 VB2 VDD VDD pch l=0.15 w=1 nf=1 m=1
M23 VBN VBN VSS VSS nch l=0.15 w=1 nf=1 m=1
M24 VB1 net1 VSS VSS nch l=0.15 w=1 nf=1 m=1
M25 net0 net1 VSS VSS nch l=0.15 w=1 nf=1 m=1
M26 VB2 net1 VSS VSS nch l=0.15 w=1 nf=1 m=1
MN1 net3 VCONT2 VSS VSS nch l=0.15 w=1 nf=1 m=1
MN2 net2 VCONT3 VSS VSS nch l=0.15 w=1 nf=1 m=1
MP2 net2 net4 VOUT VOUT pch l=0.15 w=1 nf=1 m=1
MP3 net3 VCONT1 VSTO VSTO pch l=0.15 w=1 nf=1 m=1
R1 net1 net0 1k
X1 VDD VSS net2 VBN net4 comp
.ends dut
