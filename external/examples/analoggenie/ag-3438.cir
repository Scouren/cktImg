* official Analog Canvas netlist; PDK X cards rewritten by convert.py
.model nch nmos
.model pch pmos

.subckt opamp VDD VSS INP INN VB1 VB2 OUT
M1 VX1 INP net6 VSS nch l=0.15 w=1 nf=1 m=1
M10 OUT VB1 net1 VDD pch l=0.15 w=1 nf=1 m=1
M11 VX3 VB4 net7 VSS nch l=0.15 w=1 nf=1 m=1
M12 OUT VB4 net2 VSS nch l=0.15 w=1 nf=1 m=1
M13 net7 VX3 VSS VSS nch l=0.15 w=1 nf=1 m=1
M14 net2 VX3 VSS VSS nch l=0.15 w=1 nf=1 m=1
M15 net6 VB2 VSS VSS nch l=0.15 w=1 nf=1 m=1
M16 VB5 VB5 VDD VDD pch l=0.15 w=1 nf=1 m=1
M17 VX1 VB5 VDD VDD pch l=0.15 w=1 nf=1 m=1
M18 VB5 VX1 VB3 VSS nch l=0.15 w=1 nf=1 m=1
M19 VX1 VB3 VSS VSS nch l=0.15 w=1 nf=1 m=1
M2 VX2 INN net6 VSS nch l=0.15 w=1 nf=1 m=1
M20 VB4 VB5 VDD VDD pch l=0.15 w=1 nf=1 m=1
M21 VB4 VB4 net3 VSS nch l=0.15 w=1 nf=1 m=1
M22 net3 VB4 VSS VSS nch l=0.15 w=1 nf=1 m=1
M3 net0 VX1 VDD VDD pch l=0.15 w=1 nf=1 m=1
M4 net4 VX1 VDD VDD pch l=0.15 w=1 nf=1 m=1
M5 net5 VX2 VDD VDD pch l=0.15 w=1 nf=1 m=1
M6 net1 VX2 VDD VDD pch l=0.15 w=1 nf=1 m=1
M7 VX1 VB1 net4 VDD pch l=0.15 w=1 nf=1 m=1
M8 VX2 VB1 net5 VDD pch l=0.15 w=1 nf=1 m=1
M9 VX3 VB1 net0 VDD pch l=0.15 w=1 nf=1 m=1
R1 VB3 VSS 1k
.ends opamp

.subckt dut VDD VSS vin+ phi2 phi1 phi1a VB1 VB2 vout vin- phi2a
C1 net6 net4 1p
C2 net4 net3 1p
C3 net5 VSS 1p
C4 net1 vout 1p
C5 vout net2 1p
C6 net0 vout 1p
M1 vin+ phi2 net6 VSS nch l=0.15 w=1 nf=1 m=1
M10 VSS phi1a net0 VSS nch l=0.15 w=1 nf=1 m=1
M11 vout phi1 net2 VSS nch l=0.15 w=1 nf=1 m=1
M12 net2 phi2 VSS VSS nch l=0.15 w=1 nf=1 m=1
M2 VSS phi1 net6 VSS nch l=0.15 w=1 nf=1 m=1
M3 net5 phi2a net4 VSS nch l=0.15 w=1 nf=1 m=1
M4 VSS phi1a net5 VSS nch l=0.15 w=1 nf=1 m=1
M5 net3 phi2 VSS VSS nch l=0.15 w=1 nf=1 m=1
M6 net3 phi1 VSS VSS nch l=0.15 w=1 nf=1 m=1
M7 vin- phi2 net1 VSS nch l=0.15 w=1 nf=1 m=1
M8 net1 phi1 VSS VSS nch l=0.15 w=1 nf=1 m=1
M9 vout phi2a net0 VSS nch l=0.15 w=1 nf=1 m=1
X1 VDD VSS vout net4 VB1 VB2 vout opamp
.ends dut
