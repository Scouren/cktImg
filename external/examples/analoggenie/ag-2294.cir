* official Analog Canvas netlist; PDK X cards rewritten by convert.py
.model nch nmos
.model pch pmos

.subckt dut VDD VSS VREF VB4 IBUF VIN FB VOUT
CL VOUT net3 1p
M1 net7 net7 VSS VSS nch l=0.15 w=1 nf=1 m=1
M10 EAO VB2 net1 VDD pch l=0.15 w=1 nf=1 m=1
M11 net10 VB1 VDD VDD pch l=0.15 w=1 nf=1 m=1
M12 net1 VB1 VDD VDD pch l=0.15 w=1 nf=1 m=1
M13 net9 VB4 VDD VDD pch l=0.15 w=1 nf=1 m=1
M14 net2 EAO net9 VDD pch l=0.15 w=1 nf=1 m=1
M15 net2 net2 VSS VSS nch l=0.15 w=1 nf=1 m=1
M16 GATE net2 VSS VSS nch l=0.15 w=1 nf=1 m=1
M17 VDD net9 GATE VSS nch l=0.15 w=1 nf=1 m=1
M18 net6 EAO IBUF VSS nch l=0.15 w=1 nf=1 m=1
M19 net6 net6 VDD VDD pch l=0.15 w=1 nf=1 m=1
M2 net8 net7 VSS VSS nch l=0.15 w=1 nf=1 m=1
M20 GATE net6 VDD VDD pch l=0.15 w=1 nf=1 m=1
M21 VSS IBUF GATE VDD pch l=0.15 w=1 nf=1 m=1
M22 VB5 VB5 net7 VSS nch l=0.15 w=1 nf=1 m=1
M23 VB5 net0 VDD VDD pch l=0.15 w=1 nf=1 m=1
M24 net0 net0 VDD VDD pch l=0.15 w=1 nf=1 m=1
M25 VB3 net0 VDD VDD pch l=0.15 w=1 nf=1 m=1
M26 VB3 VB3 VSS VSS nch l=0.15 w=1 nf=1 m=1
M27 net0 VB3 net4 VSS nch l=0.15 w=1 nf=1 m=1
M3 net1 VREF net8 VSS nch l=0.15 w=1 nf=1 m=1
M4 net10 FB net8 VSS nch l=0.15 w=1 nf=1 m=1
M5 net12 net5 VSS VSS nch l=0.15 w=1 nf=1 m=1
M6 net11 net5 VSS VSS nch l=0.15 w=1 nf=1 m=1
M7 net5 VB5 net12 VSS nch l=0.15 w=1 nf=1 m=1
M8 EAO VB5 net11 VSS nch l=0.15 w=1 nf=1 m=1
M9 net5 VB2 net10 VDD pch l=0.15 w=1 nf=1 m=1
MNP VIN GATE VOUT VSS nch l=0.15 w=1 nf=1 m=1
R1 FB VSS 1k
R2 VOUT FB 1k
R3 net4 VSS 1k
R4 net3 VSS 1k
R5 VOUT VSS 1k
.ends dut
