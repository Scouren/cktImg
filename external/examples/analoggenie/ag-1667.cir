* official Analog Canvas netlist; PDK X cards rewritten by convert.py
.model nch nmos
.model pch pmos
.model qpnp pnp

.subckt opamp VDD VSS INP INN OUT VB5 VB6
M1 INP INP net3 VSS nch l=0.15 w=1 nf=1 m=1
M10 net1 VX VSS VSS nch l=0.15 w=1 nf=1 m=1
M11 net0 VX VSS VSS nch l=0.15 w=1 nf=1 m=1
M2 net2 INN net3 VSS nch l=0.15 w=1 nf=1 m=1
M3 net3 VB6 VSS VSS nch l=0.15 w=1 nf=1 m=1
M4 INP VB1 VDD VDD pch l=0.15 w=1 nf=1 m=1
M5 net2 VB1 VDD VDD pch l=0.15 w=1 nf=1 m=1
M6 VX VB2 INP VDD pch l=0.15 w=1 nf=1 m=1
M7 OUT VB2 net2 VDD pch l=0.15 w=1 nf=1 m=1
M8 VX VB5 net1 VSS nch l=0.15 w=1 nf=1 m=1
M9 OUT VB5 net0 VSS nch l=0.15 w=1 nf=1 m=1
.ends opamp

.subckt dut VDD VSS Vout
M12 VB5 VB7 VDD VDD pch l=0.15 w=1 nf=1 m=1
M13 VB5 VB5 VB6 VSS nch l=0.15 w=1 nf=1 m=1
M14 VB6 VB6 VSS VSS nch l=0.15 w=1 nf=1 m=1
M15 VB7 VB7 VDD VDD pch l=0.15 w=1 nf=1 m=1
M16 VB7 net0 net3 VSS nch l=0.15 w=1 nf=1 m=1
M17 net3 net1 VSS VSS nch l=0.15 w=1 nf=1 m=1
M18 net1 VB7 VDD VDD pch l=0.15 w=1 nf=1 m=1
M19 net1 net1 VSS VSS nch l=0.15 w=1 nf=1 m=1
M20 net0 VB7 VDD VDD pch l=0.15 w=1 nf=1 m=1
M21 net0 net3 VSS VSS nch l=0.15 w=1 nf=1 m=1
Q1 VSS VSS net4 qpnp m=1
Q2 net4 net4 net2 qpnp m=1
Q3 VSS VSS net5 qpnp m=1
Q4 net5 net5 Y qpnp m=1
R1 Vout X 1k
R2 Vout Y 1k
R3 X net2 1k
X1 VDD VSS X Y Vout VB5 VB6 opamp
.ends dut
