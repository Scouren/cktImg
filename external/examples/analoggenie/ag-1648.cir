* official Analog Canvas netlist; PDK X cards rewritten by convert.py
.model nch nmos
.model pch pmos
.model qpnp pnp

.subckt opamp VDD VSS INN INP OUT VE VB1 VB2 VB3
M1 net6 net2 VDD VDD pch l=0.15 w=1 nf=1 m=1
M10 net8 INP net10 VSS nch l=0.15 w=1 nf=1 m=1
M11 net10 VB2 VSS VSS nch l=0.15 w=1 nf=1 m=1
M12 net7 VB4 net11 VSS nch l=0.15 w=1 nf=1 m=1
M13 net11 net7 VSS VSS nch l=0.15 w=1 nf=1 m=1
M14 OUT VB4 VE VSS nch l=0.15 w=1 nf=1 m=1
M15 VE net7 VSS VSS nch l=0.15 w=1 nf=1 m=1
M16 net4 VB5 VDD VDD pch l=0.15 w=1 nf=1 m=1
M17 VB5 VB5 VDD VDD pch l=0.15 w=1 nf=1 m=1
M18 VB3 VB5 VDD VDD pch l=0.15 w=1 nf=1 m=1
M19 VB4 VB5 VDD VDD pch l=0.15 w=1 nf=1 m=1
M2 net0 net2 VDD VDD pch l=0.15 w=1 nf=1 m=1
M20 VB5 VB3 net5 VSS nch l=0.15 w=1 nf=1 m=1
M21 net5 net4 VSS VSS nch l=0.15 w=1 nf=1 m=1
M22 net4 net4 VSS VSS nch l=0.15 w=1 nf=1 m=1
M23 VB3 VB3 VSS VSS nch l=0.15 w=1 nf=1 m=1
M24 VB4 VB4 net1 VSS nch l=0.15 w=1 nf=1 m=1
M25 net1 VB4 VSS VSS nch l=0.15 w=1 nf=1 m=1
M3 net3 net8 VDD VDD pch l=0.15 w=1 nf=1 m=1
M4 net9 net8 VDD VDD pch l=0.15 w=1 nf=1 m=1
M5 net7 VB1 net6 VDD pch l=0.15 w=1 nf=1 m=1
M6 net2 VB1 net0 VDD pch l=0.15 w=1 nf=1 m=1
M7 net8 VB1 net3 VDD pch l=0.15 w=1 nf=1 m=1
M8 OUT VB1 net9 VDD pch l=0.15 w=1 nf=1 m=1
M9 net2 INN net10 VSS nch l=0.15 w=1 nf=1 m=1
.ends opamp

.subckt dut VDD VSS Vout VB1 VB2 VB3
Q1 VSS VSS net1 qpnp m=1
Q2 net1 net1 X qpnp m=1
Q3 VSS VSS net0 qpnp m=1
Q4 net0 net0 net2 qpnp m=1
R1 Vout X 1k
R2 Vout Y 1k
R3 Y net2 1k
X1 VDD VSS Y X Vout net2 VB1 VB2 VB3 opamp
.ends dut
