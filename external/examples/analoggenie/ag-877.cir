* official Analog Canvas netlist; PDK X cards rewritten by convert.py
.model nch nmos
.model pch pmos

.subckt dut VDD VSS GND BIAS Vi Vo
M1 VDD net1 Vo VSS nch l=0.15 w=1 nf=1 m=1
M2 VSS net2 Vo VDD pch l=0.15 w=1 nf=1 m=1
M3 net1 BIAS VDD VDD pch l=0.15 w=1 nf=1 m=1
M4 net1 net1 net0 VSS nch l=0.15 w=1 nf=1 m=1
M5 net2 net2 net0 VDD pch l=0.15 w=1 nf=1 m=1
M6 net2 Vi VSS VSS nch l=0.15 w=1 nf=1 m=1
RL Vo GND 1k
.ends dut
