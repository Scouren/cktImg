* official Analog Canvas netlist; PDK X cards rewritten by convert.py
.model pch pmos

.subckt dut VDD VSS Vb Vin Vout
M1 VSS Vin Vout Vout pch l=0.15 w=1 nf=1 m=1
M2 Vout Vb VDD VDD pch l=0.15 w=1 nf=1 m=1
.ends dut
