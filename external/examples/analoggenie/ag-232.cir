* official Analog Canvas netlist; PDK X cards rewritten by convert.py
.model nch nmos

.subckt dut VDD VSS Vin Vout
C1 Vout P 1p
C2 P VSS 1p
M1 Vout Vin net0 VSS nch l=0.15 w=1 nf=1 m=1
M2 net0 P VSS VSS nch l=0.15 w=1 nf=1 m=1
RD VDD Vout 1k
RS net0 VSS 1k
.ends dut
