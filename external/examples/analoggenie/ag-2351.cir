* official Analog Canvas netlist; PDK X cards rewritten by convert.py
.model nch nmos
.model pch pmos

.subckt dut VDD VSS VREF VB3 IBUF VIN VOUT VB2 VB1
CL VOUT net3 1p
M1 net5 net5 VDD VDD pch l=0.15 w=1 nf=1 m=1
M13 net7 VB3 VDD VDD pch l=0.15 w=1 nf=1 m=1
M14 VT EAO net7 VDD pch l=0.15 w=1 nf=1 m=1
M15 VT VT VSS VSS nch l=0.15 w=1 nf=1 m=1
M16 GATE VT VSS VSS nch l=0.15 w=1 nf=1 m=1
M17 VDD net7 GATE VSS nch l=0.15 w=1 nf=1 m=1
M18 net2 EAO IBUF VSS nch l=0.15 w=1 nf=1 m=1
M19 net2 net2 VDD VDD pch l=0.15 w=1 nf=1 m=1
M2 net6 net6 VDD VDD pch l=0.15 w=1 nf=1 m=1
M20 GATE net2 VDD VDD pch l=0.15 w=1 nf=1 m=1
M21 VSS IBUF GATE VDD pch l=0.15 w=1 nf=1 m=1
M22 VB2 VB2 VDD VDD pch l=0.15 w=1 nf=1 m=1
M23 VB2 net1 net8 VSS nch l=0.15 w=1 nf=1 m=1
M24 net1 VB2 VDD VDD pch l=0.15 w=1 nf=1 m=1
M25 net1 net1 VSS VSS nch l=0.15 w=1 nf=1 m=1
M26 net4 net4 VDD VDD pch l=0.15 w=1 nf=1 m=1
M27 net4 net1 VSS VSS nch l=0.15 w=1 nf=1 m=1
M28 VBN net4 VDD VDD pch l=0.15 w=1 nf=1 m=1
M29 VBN VBN VSS VSS nch l=0.15 w=1 nf=1 m=1
M3 net5 VREF VT VSS nch l=0.15 w=1 nf=1 m=1
M30 VB1 VB1 VDD VDD pch l=0.15 w=1 nf=1 m=1
M31 VB1 VBN VSS VSS nch l=0.15 w=1 nf=1 m=1
M4 net6 FB VT VSS nch l=0.15 w=1 nf=1 m=1
M5 net0 net6 VDD VDD pch l=0.15 w=1 nf=1 m=1
M6 EAO net5 VDD VDD pch l=0.15 w=1 nf=1 m=1
M7 VT VBN VSS VSS nch l=0.15 w=1 nf=1 m=1
M8 net0 net0 VSS VSS nch l=0.15 w=1 nf=1 m=1
M9 EAO net0 VSS VSS nch l=0.15 w=1 nf=1 m=1
MNP VIN GATE VOUT VSS nch l=0.15 w=1 nf=1 m=1
R1 FB VSS 1k
R2 VOUT FB 1k
R3 net8 VSS 1k
RESR net3 VSS 1k
RL VOUT VSS 1k
.ends dut
