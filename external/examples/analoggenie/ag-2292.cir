* official Analog Canvas netlist; PDK X cards rewritten by convert.py
.model nch nmos
.model pch pmos

.subckt dut VDD VSS VB3 VB2 VB4 IBUF VIN VOUT
CL VOUT net11 1p
M1 VX VX VSS VSS nch l=0.15 w=1 nf=1 m=1
M10 EAO VB2 net9 VDD pch l=0.15 w=1 nf=1 m=1
M11 net8 VB3 VDD VDD pch l=0.15 w=1 nf=1 m=1
M12 net9 VB3 VDD VDD pch l=0.15 w=1 nf=1 m=1
M13 net5 VB4 VDD VDD pch l=0.15 w=1 nf=1 m=1
M14 net1 EAO net5 VDD pch l=0.15 w=1 nf=1 m=1
M15 net1 net1 VSS VSS nch l=0.15 w=1 nf=1 m=1
M16 GATE net1 VSS VSS nch l=0.15 w=1 nf=1 m=1
M17 VDD net5 GATE VSS nch l=0.15 w=1 nf=1 m=1
M18 net0 EAO IBUF VSS nch l=0.15 w=1 nf=1 m=1
M19 net0 net0 VDD VDD pch l=0.15 w=1 nf=1 m=1
M2 net7 VX VSS VSS nch l=0.15 w=1 nf=1 m=1
M20 GATE net0 VDD VDD pch l=0.15 w=1 nf=1 m=1
M21 VSS IBUF GATE VDD pch l=0.15 w=1 nf=1 m=1
M22 VB1 VB1 VX VSS nch l=0.15 w=1 nf=1 m=1
M23 VB1 net3 VDD VDD pch l=0.15 w=1 nf=1 m=1
M24 net3 net3 net2 VDD pch l=0.15 w=1 nf=1 m=1
M3 net9 VREF net7 VSS nch l=0.15 w=1 nf=1 m=1
M4 net8 FB net7 VSS nch l=0.15 w=1 nf=1 m=1
M5 net10 net4 VSS VSS nch l=0.15 w=1 nf=1 m=1
M6 net6 net4 VSS VSS nch l=0.15 w=1 nf=1 m=1
M7 net4 VB1 net10 VSS nch l=0.15 w=1 nf=1 m=1
M8 EAO VB1 net6 VSS nch l=0.15 w=1 nf=1 m=1
M9 net4 VB2 net8 VDD pch l=0.15 w=1 nf=1 m=1
MNP VIN GATE VOUT VSS nch l=0.15 w=1 nf=1 m=1
R1 FB VSS 1k
R2 VOUT FB 1k
R3 VDD net2 1k
R4 net3 VSS 1k
R5 net11 VSS 1k
RL VOUT VSS 1k
.ends dut
