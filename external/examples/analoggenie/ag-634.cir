* official Analog Canvas netlist; PDK X cards rewritten by convert.py
.model nch nmos
.model pch pmos

.subckt dut Vcc VSS In Ref Out
Ibias net8 net1 DC 20uA
M1 net7 In net5 VSS nch l=0.15 w=1 nf=1 m=1
M10 net3 net0 VSS VSS nch l=0.15 w=1 nf=1 m=2
M11 net7 net4 VSS VSS nch l=0.15 w=1 nf=1 m=2
M12 net4 net4 VSS VSS nch l=0.15 w=1 nf=1 m=2
M13 net2 net3 Vcc Vcc pch l=0.15 w=1 nf=1 m=2
M14 net2 net1 VSS VSS nch l=0.15 w=1 nf=1 m=1
M15 Out net2 Vcc Vcc pch l=0.15 w=1 nf=1 m=1
M16 Out net2 VSS VSS nch l=0.15 w=1 nf=1 m=1
M17 net8 net8 Vcc Vcc pch l=0.15 w=1 nf=1 m=1
M18 net1 net1 VSS VSS nch l=0.15 w=1 nf=1 m=1
M19 net5 net1 VSS VSS nch l=0.15 w=1 nf=1 m=1
M2 net3 Ref net5 VSS nch l=0.15 w=1 nf=1 m=1
M20 net6 net8 Vcc Vcc pch l=0.15 w=1 nf=1 m=1
M3 net0 In net6 net6 pch l=0.15 w=1 nf=1 m=1
M4 net4 Ref net6 net6 pch l=0.15 w=1 nf=1 m=1
M5 net7 net7 Vcc Vcc pch l=0.15 w=1 nf=1 m=2
M6 net3 net7 Vcc Vcc pch l=0.15 w=1 nf=1 m=2
M7 net7 net3 Vcc Vcc pch l=0.15 w=1 nf=1 m=2
M8 net3 net3 Vcc Vcc pch l=0.15 w=1 nf=1 m=2
M9 net0 net0 VSS VSS nch l=0.15 w=1 nf=1 m=2
.ends dut
