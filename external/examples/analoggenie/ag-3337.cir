* official Analog Canvas netlist; PDK X cards rewritten by convert.py
.model nch nmos
.model pch pmos

.subckt dut VDD VSS vci phi1 phi2 vco
C1 net6 net4 1p
C2 net2 vco 1p
M1 vci phi1 net6 VSS nch l=0.15 w=1 nf=1 m=1
M10 net3 net0 VSS VSS nch l=0.15 w=1 nf=1 m=1
M11 net0 net0 VSS VSS nch l=0.15 w=1 nf=1 m=1
M12 net1 net0 VSS VSS nch l=0.15 w=1 nf=1 m=1
M13 net1 net1 VDD VDD pch l=0.15 w=1 nf=1 m=1
M14 VB1 net1 VDD VDD pch l=0.15 w=1 nf=1 m=1
M15 VB1 VB1 VSS VSS nch l=0.15 w=1 nf=1 m=1
M16 VX VX VDD VDD pch l=0.15 w=1 nf=1 m=1
M17 VX VB1 VSS VSS nch l=0.15 w=1 nf=1 m=1
M2 net6 phi2 VSS VSS nch l=0.15 w=1 nf=1 m=1
M3 net4 phi1 VSS VSS nch l=0.15 w=1 nf=1 m=1
M4 net4 phi2 net2 VSS nch l=0.15 w=1 nf=1 m=1
M5 VX net2 net5 VSS nch l=0.15 w=1 nf=1 m=1
M6 vco VSS net5 VSS nch l=0.15 w=1 nf=1 m=1
M7 net5 VB1 VSS VSS nch l=0.15 w=1 nf=1 m=1
M8 VX VX VDD VDD pch l=0.15 w=1 nf=1 m=1
M9 vco VX VDD VDD pch l=0.15 w=1 nf=1 m=1
R1 VDD net3 1k
R2 VDD net0 1k
R3 net3 net0 1k
.ends dut
