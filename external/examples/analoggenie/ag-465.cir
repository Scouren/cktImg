* official Analog Canvas netlist; PDK X cards rewritten by convert.py
.model nch nmos
.model pch pmos

.subckt dut VDD VSS Vb Vout
C1 net2 net0 1p
M1 Vout net0 VSS VSS nch l=0.15 w=1 nf=1 m=1
M2 Vout Vb VDD VDD pch l=0.15 w=1 nf=1 m=1
RF net0 Vout 1k
RS net1 net2 1k
Vin net1 VSS DC 1
.ends dut
