* official Analog Canvas netlist; PDK X cards rewritten by convert.py
.model nch nmos
.model pch pmos

.subckt dut VDD VSS VSTO VCONT1 VCONT2 VCONT3 VOUT VB1 VB2
CL VOUT VSS 1p
CSTO VSTO VSS 1p
LRX VX VY 1n
M1 net1 VB1 VDD VDD pch l=0.15 w=1 nf=1 m=1
M10 net4 VC VX VSS nch l=0.15 w=1 nf=1 m=1
M11 VX VBN VSS VSS nch l=0.15 w=1 nf=1 m=1
M12 net3 VP VDD VDD pch l=0.15 w=1 nf=1 m=1
M13 VP VP VDD VDD pch l=0.15 w=1 nf=1 m=1
M14 net7 VP VDD VDD pch l=0.15 w=1 nf=1 m=1
M15 VCN VP VDD VDD pch l=0.15 w=1 nf=1 m=1
M16 VP net7 net5 VSS nch l=0.15 w=1 nf=1 m=1
M17 net5 net3 VSS VSS nch l=0.15 w=1 nf=1 m=1
M18 net3 net3 VSS VSS nch l=0.15 w=1 nf=1 m=1
M19 net7 net5 VSS VSS nch l=0.15 w=1 nf=1 m=1
M2 net4 VB1 VDD VDD pch l=0.15 w=1 nf=1 m=1
M20 VCN VCN VBN VSS nch l=0.15 w=1 nf=1 m=1
M21 VBN VBN VSS VSS nch l=0.15 w=1 nf=1 m=1
M3 net0 VB2 net1 VDD pch l=0.15 w=1 nf=1 m=1
M4 VC VB2 net4 VDD pch l=0.15 w=1 nf=1 m=1
M5 net0 VCN net6 VSS nch l=0.15 w=1 nf=1 m=1
M6 VC VCN net2 VSS nch l=0.15 w=1 nf=1 m=1
M7 net6 net0 VSS VSS nch l=0.15 w=1 nf=1 m=1
M8 net2 net0 VSS VSS nch l=0.15 w=1 nf=1 m=1
M9 net1 VY VX VSS nch l=0.15 w=1 nf=1 m=1
MN1 VX VCONT2 VSS VSS nch l=0.15 w=1 nf=1 m=1
MN2 VY VCONT3 VSS VSS nch l=0.15 w=1 nf=1 m=1
MP2 VY VC VOUT VOUT pch l=0.15 w=1 nf=1 m=1
MP3 VX VCONT1 VSTO VSTO pch l=0.15 w=1 nf=1 m=1
.ends dut
