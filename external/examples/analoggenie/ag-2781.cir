* official Analog Canvas netlist; PDK X cards rewritten by convert.py
.model nch nmos
.model pch pmos

.subckt opamp VDD VSS INN INP OUT
M10 VX VX VSS VSS nch l=0.15 w=1 nf=1 m=1
M11 net3 VX VSS VSS nch l=0.15 w=1 nf=1 m=1
M12 net4 VB4 VDD VDD pch l=0.15 w=1 nf=1 m=1
M13 net4 net4 VSS VSS nch l=0.15 w=1 nf=1 m=1
M14 VB3 VB3 VDD VDD pch l=0.15 w=1 nf=1 m=1
M15 VB3 net4 VSS VSS nch l=0.15 w=1 nf=1 m=1
M16 VB1 VB3 VDD VDD pch l=0.15 w=1 nf=1 m=1
M17 VB1 VB1 VSS VSS nch l=0.15 w=1 nf=1 m=1
M18 net0 VB4 VDD VDD pch l=0.15 w=1 nf=1 m=1
M19 net0 net0 VSS VSS nch l=0.15 w=1 nf=1 m=1
M20 VB4 VB4 VDD VDD pch l=0.15 w=1 nf=1 m=1
M21 VB4 VB2 VX VSS nch l=0.15 w=1 nf=1 m=1
M22 VX net0 VSS VSS nch l=0.15 w=1 nf=1 m=1
M23 VB2 VB4 VDD VDD pch l=0.15 w=1 nf=1 m=1
M24 VB2 VB2 VSS VSS nch l=0.15 w=1 nf=1 m=1
M3 OUT net3 VDD VDD pch l=0.15 w=1 nf=1 m=1
M4 net3 net3 VDD VDD pch l=0.15 w=1 nf=1 m=1
M5 net2 VB3 VDD VDD pch l=0.15 w=1 nf=1 m=1
M6 net1 INN net2 VDD pch l=0.15 w=1 nf=1 m=1
M7 VX INP net2 VDD pch l=0.15 w=1 nf=1 m=1
M8 OUT net1 VSS VSS nch l=0.15 w=1 nf=1 m=1
M9 net1 net1 VSS VSS nch l=0.15 w=1 nf=1 m=1
.ends opamp

.subckt dut VDD VSS vci phi1 phi2 vco
C1 vcx VSS 1p
C2 net0 vco 1p
M1 vci phi1 vcx VSS nch l=0.15 w=1 nf=1 m=1
M2 vcx phi2 net0 VSS nch l=0.15 w=1 nf=1 m=1
X1 VDD VSS net0 VSS vco opamp
.ends dut
