* official Analog Canvas netlist; PDK X cards rewritten by convert.py
.model nch nmos
.model pch pmos

.subckt AMP1 VDD VSS VB1 INP INN VB2 OUT n3
M10 net0 VX VDD VDD pch l=0.15 w=1 nf=1 m=1
M11 VX VB2 net4 VDD pch l=0.15 w=1 nf=1 m=1
M12 OUT VB2 net0 VDD pch l=0.15 w=1 nf=1 m=1
M13 VX VY net3 VSS nch l=0.15 w=1 nf=1 m=1
M14 OUT VY net2 VSS nch l=0.15 w=1 nf=1 m=1
M15 net3 VZ VSS VSS nch l=0.15 w=1 nf=1 m=1
M16 net2 VZ VSS VSS nch l=0.15 w=1 nf=1 m=1
M17 VY VP VDD VDD pch l=0.15 w=1 nf=1 m=1
M18 VY VY VZ VSS nch l=0.15 w=1 nf=1 m=1
M19 VZ VZ VSS VSS nch l=0.15 w=1 nf=1 m=1
M20 VP VP VDD VDD pch l=0.15 w=1 nf=1 m=1
M21 VP VB4 VB3 VSS nch l=0.15 w=1 nf=1 m=1
M22 VB3 net1 VSS VSS nch l=0.15 w=1 nf=1 m=1
M23 net1 VP VDD VDD pch l=0.15 w=1 nf=1 m=1
M24 net1 net1 VSS VSS nch l=0.15 w=1 nf=1 m=1
M25 VB4 VP VDD VDD pch l=0.15 w=1 nf=1 m=1
M26 VB4 VB3 VSS VSS nch l=0.15 w=1 nf=1 m=1
M6 n3 VB1 VDD VDD pch l=0.15 w=1 nf=1 m=1
M7 net3 INP n3 VDD pch l=0.15 w=1 nf=1 m=1
M8 net2 INN n3 VDD pch l=0.15 w=1 nf=1 m=1
M9 net4 VX VDD VDD pch l=0.15 w=1 nf=1 m=1
.ends AMP1

.subckt dut VDD VSS biasp biascas biasn Vref Vout VB1 VB2
C1 Vset VSS 1p
C2 n3 Vout 1p
M1 Vout n3 VDD VDD pch l=0.15 w=1 nf=1 m=1
M2 n1 Vset Vout VDD pch l=0.15 w=1 nf=1 m=1
M3 n1 biasn VSS VSS nch l=0.15 w=1 nf=1 m=1
M4 n3 biasp VDD VDD pch l=0.15 w=1 nf=1 m=1
M5 n3 biascas n1 VSS nch l=0.15 w=1 nf=1 m=1
R1 fb VSS 1k
R2 Vout fb 1k
X1 VDD VSS VB1 Vref fb VB2 Vset n3 AMP1
.ends dut
