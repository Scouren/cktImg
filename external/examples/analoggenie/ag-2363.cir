* official Analog Canvas netlist; PDK X cards rewritten by convert.py
.model nch nmos
.model pch pmos

.subckt Error_Amplifier VDD VSS VREF VB2 VB1 OUT VC
M10 net7 VB1 net8 VDD pch l=0.15 w=1 nf=1 m=1
M11 OUT VB1 net5 VDD pch l=0.15 w=1 nf=1 m=1
M12 VA VBN net4 VSS nch l=0.15 w=1 nf=1 m=1
M13 VC OUT net6 VSS nch l=0.15 w=1 nf=1 m=1
M14 net7 VREF net6 VSS nch l=0.15 w=1 nf=1 m=1
M15 OUT VBN net2 VSS nch l=0.15 w=1 nf=1 m=1
M16 net4 VA VSS VSS nch l=0.15 w=1 nf=1 m=1
M17 net2 VA VSS VSS nch l=0.15 w=1 nf=1 m=1
M18 net6 VB2 VSS VSS nch l=0.15 w=1 nf=1 m=1
M19 VBN net3 VDD VDD pch l=0.15 w=1 nf=1 m=1
M20 VBN VBN OUT VSS nch l=0.15 w=1 nf=1 m=1
M21 OUT VBN VSS VSS nch l=0.15 w=1 nf=1 m=1
M22 net3 net3 VDD VDD pch l=0.15 w=1 nf=1 m=1
M4 net0 VC VDD VDD pch l=0.15 w=1 nf=1 m=1
M5 net1 VC VDD VDD pch l=0.15 w=1 nf=1 m=1
M6 net8 net7 VDD VDD pch l=0.15 w=1 nf=1 m=1
M7 net5 net7 VDD VDD pch l=0.15 w=1 nf=1 m=1
M8 VA VB1 net0 VDD pch l=0.15 w=1 nf=1 m=1
M9 VC VB1 net1 VDD pch l=0.15 w=1 nf=1 m=1
R1 net3 VSS 1k
.ends Error_Amplifier

.subckt dut VDD VSS VIN VOUT VERR pb VREF VB1 VB2
M1 net1 net3 VIN VDD pch l=0.15 w=1 nf=1 m=1
M2 net2 net2 net1 VDD pch l=0.15 w=1 nf=1 m=1
M3 net2 nb VSS VSS nch l=0.15 w=1 nf=1 m=1
MBIAS VERR nb VSS VSS nch l=0.15 w=1 nf=1 m=1
MCHG net4 pb VIN VDD pch l=0.15 w=1 nf=1 m=1
MCTRL VERR net2 VOUT VDD pch l=0.15 w=1 nf=1 m=1
MGEN net0 net0 VSS VSS nch l=0.15 w=1 nf=1 m=1
MINJ VERR net0 VSS VSS nch l=0.15 w=1 nf=1 m=1
MRES VOUT VERR VIN VDD pch l=0.15 w=1 nf=1 m=1
MSEN net0 net3 net4 VDD pch l=0.15 w=1 nf=1 m=1
X1 VDD VSS VREF VB2 VB1 net3 net2 Error_Amplifier
.ends dut
