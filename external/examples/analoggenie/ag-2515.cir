* official Analog Canvas netlist; PDK X cards rewritten by convert.py
.model nch nmos
.model pch pmos

.subckt bias VDD VSS VIN VBN
MB1 net0 net1 VSS VSS nch l=0.15 w=1 nf=1 m=1
MB2 net1 net0 VIN VDD pch l=0.15 w=1 nf=1 m=1
MB3 net1 net1 VSS VSS nch l=0.15 w=1 nf=1 m=1
MB4 VB1 VB1 VIN VDD pch l=0.15 w=1 nf=1 m=1
MB5 VB1 net1 VSS VSS nch l=0.15 w=1 nf=1 m=1
MB6 VBN VB1 VIN VDD pch l=0.15 w=1 nf=1 m=1
MB7 VBN VBN VSS VSS nch l=0.15 w=1 nf=1 m=1
RB1 VIN net0 1k
RB2 VIN net1 1k
.ends bias

.subckt dut VDD VSS VREF VB4 VB3 VB2 VOUT VIN
CF1 VOUT VFB 1p
Cm1 net6 VOUT 1p
Cm2 net6 net4 1p
M11 net2 VBN VSS VSS nch l=0.15 w=1 nf=1 m=1
M12 VX VFB net2 VSS nch l=0.15 w=1 nf=1 m=1
M13 VY VREF net2 VSS nch l=0.15 w=1 nf=1 m=1
M14 net0 net0 VSS VSS nch l=0.15 w=1 nf=1 m=1
M15 net6 net0 VSS VSS nch l=0.15 w=1 nf=1 m=1
M16 VY VB4 VIN VDD pch l=0.15 w=1 nf=1 m=1
M17 VY net6 VSS VSS nch l=0.15 w=1 nf=1 m=1
M18 VY VY VSS VSS nch l=0.15 w=1 nf=1 m=1
M19 VX VX VIN VDD pch l=0.15 w=1 nf=1 m=1
M20 VY VY VIN VDD pch l=0.15 w=1 nf=1 m=1
M21 net5 net6 VSS VSS nch l=0.15 w=1 nf=1 m=1
M22 net3 VY VSS VSS nch l=0.15 w=1 nf=1 m=1
M23 net5 net5 VIN VDD pch l=0.15 w=1 nf=1 m=1
M24 net3 net5 VIN VDD pch l=0.15 w=1 nf=1 m=1
M25 net6 VX VIN VDD pch l=0.15 w=1 nf=1 m=1
M26 net0 VY VIN VDD pch l=0.15 w=1 nf=1 m=1
MD1 net4 net6 VSS VSS nch l=0.15 w=1 nf=1 m=1
MD2 net7 VB2 VSS VSS nch l=0.15 w=1 nf=1 m=1
MD3 net1 net4 net7 VSS nch l=0.15 w=1 nf=1 m=1
MD4 VX VB3 net7 VSS nch l=0.15 w=1 nf=1 m=1
MD5 net4 VX VIN VDD pch l=0.15 w=1 nf=1 m=1
MD6 VX VX VIN VDD pch l=0.15 w=1 nf=1 m=1
MD7 net1 net1 VIN VDD pch l=0.15 w=1 nf=1 m=1
MPT VOUT net3 VIN VDD pch l=0.15 w=1 nf=1 m=1
RF1 VOUT VFB 1k
RF2 VFB VSS 1k
X1 VDD VSS VIN VBN bias
.ends dut
