* official Analog Canvas netlist; PDK X cards rewritten by convert.py
.model nch nmos
.model pch pmos

.subckt dut VDD VSS iin iout
VB1 net1 VSS DC 1
I1 VDD iin DC 1m
I2 VDD iout DC 1m
I3 net0 VSS DC 1m
M1 iin net0 VSS VSS nch l=0.15 w=1 nf=1 m=1
M2 iout net0 VSS VSS nch l=0.15 w=1 nf=1 m=1
M3 net0 net1 iin VDD pch l=0.15 w=1 nf=1 m=1
.ends dut
