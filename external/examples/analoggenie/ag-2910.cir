* official Analog Canvas netlist; PDK X cards rewritten by convert.py
.model nch nmos
.model pch pmos

.subckt opamp VDD VSS VX INP INN OUT
M10 VB1 VB1 VDD VDD pch l=0.15 w=1 nf=1 m=1
M11 VB1 net1 VSS VSS nch l=0.15 w=1 nf=1 m=1
M12 net2 VB1 VDD VDD pch l=0.15 w=1 nf=1 m=1
M13 net2 net2 net1 VSS nch l=0.15 w=1 nf=1 m=1
M14 net1 net2 net7 VSS nch l=0.15 w=1 nf=1 m=1
M15 net6 VB1 VDD VDD pch l=0.15 w=1 nf=1 m=1
M16 net6 net6 net7 VSS nch l=0.15 w=1 nf=1 m=1
M17 net7 net6 net3 VSS nch l=0.15 w=1 nf=1 m=1
M18 net3 VB1 VDD VDD pch l=0.15 w=1 nf=1 m=1
M19 net3 net3 VSS VSS nch l=0.15 w=1 nf=1 m=1
M20 VB2 VB2 VDD VDD pch l=0.15 w=1 nf=1 m=1
M21 VB2 net3 VSS VSS nch l=0.15 w=1 nf=1 m=1
M3 VX VB2 VDD VDD pch l=0.15 w=1 nf=1 m=1
M4 net4 INP VX VDD pch l=0.15 w=1 nf=1 m=1
M5 OUT INN VX VDD pch l=0.15 w=1 nf=1 m=1
M6 net4 VC net5 VSS nch l=0.15 w=1 nf=1 m=1
M7 OUT VC net0 VSS nch l=0.15 w=1 nf=1 m=1
M8 net5 net4 VSS VSS nch l=0.15 w=1 nf=1 m=1
M9 net0 net4 VSS VSS nch l=0.15 w=1 nf=1 m=1
.ends opamp

.subckt dut VDD VSS vci phi1 phi2 vco
C1 vcx VSS 1p
C2 net0 vco 1p
M1 vci phi1 vcx VSS nch l=0.15 w=1 nf=1 m=1
M2 vcx phi2 net0 VSS nch l=0.15 w=1 nf=1 m=1
X1 VDD VSS vcx VSS net0 vco opamp
.ends dut
