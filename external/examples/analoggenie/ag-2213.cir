* official Analog Canvas netlist; PDK X cards rewritten by convert.py
.model nch nmos
.model pch pmos

.subckt opamp VDD VSS INP INN OUT
M1 net5 VB1 VDD VDD pch l=0.15 w=1 nf=1 m=1
M10 net7 net0 VSS VSS nch l=0.15 w=1 nf=1 m=1
M11 OUT VB2 VSS VSS nch l=0.15 w=1 nf=1 m=1
M12 VBN net3 VDD VDD pch l=0.15 w=1 nf=1 m=1
M13 VBN VBN net6 VSS nch l=0.15 w=1 nf=1 m=1
M14 net6 VBN VSS VSS nch l=0.15 w=1 nf=1 m=1
M15 net3 net3 VDD VDD pch l=0.15 w=1 nf=1 m=1
M16 net3 net2 net1 VSS nch l=0.15 w=1 nf=1 m=1
M17 net2 net3 VDD VDD pch l=0.15 w=1 nf=1 m=1
M18 net2 net2 VSS VSS nch l=0.15 w=1 nf=1 m=1
M2 net4 VB1 VDD VDD pch l=0.15 w=1 nf=1 m=1
M3 net5 INP OUT VSS nch l=0.15 w=1 nf=1 m=1
M4 net4 INN OUT VSS nch l=0.15 w=1 nf=1 m=1
M5 OUT VB3 net5 VDD pch l=0.15 w=1 nf=1 m=1
M6 net0 VB3 net4 VDD pch l=0.15 w=1 nf=1 m=1
M7 OUT VBN net8 VSS nch l=0.15 w=1 nf=1 m=1
M8 net0 VBN net7 VSS nch l=0.15 w=1 nf=1 m=1
M9 net8 net0 VSS VSS nch l=0.15 w=1 nf=1 m=1
R1 net1 VSS 1k
.ends opamp

.subckt dut VDD VSS Vref VIN VOUT
CL VOUT net0 1p
MNP VIN net1 VOUT VSS nch l=0.15 w=1 nf=1 m=1
R1 VOUT FB 1k
R2 FB VSS 1k
R3 net0 VSS 1k
X1 VDD VSS Vref FB net1 opamp
.ends dut
