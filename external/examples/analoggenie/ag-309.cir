* official Analog Canvas netlist; PDK X cards rewritten by convert.py
.model nch nmos
.model pch pmos

.subckt dut VDD VSS Vin1 Vin2 Vb Vb1 Vb2 Vb3 Vb4 Vout1 Vout2
M1 net3 Vin1 net0 VSS nch l=0.15 w=1 nf=1 m=1
M10 net1 Vb4 VSS VSS nch l=0.15 w=1 nf=1 m=1
M11 net5 Vb4 VSS VSS nch l=0.15 w=1 nf=1 m=1
M12 Vout1 Vb3 net1 VSS nch l=0.15 w=1 nf=1 m=1
M13 Vout2 Vb3 net5 VSS nch l=0.15 w=1 nf=1 m=1
M2 net2 Vin2 net0 VSS nch l=0.15 w=1 nf=1 m=1
M3 net3 Vb1 VDD VDD pch l=0.15 w=1 nf=1 m=1
M4 net2 Vb1 VDD VDD pch l=0.15 w=1 nf=1 m=1
M5 Vout1 Vb2 net3 VDD pch l=0.15 w=1 nf=1 m=1
M6 Vout2 Vb2 net2 VDD pch l=0.15 w=1 nf=1 m=1
M7 net4 Vout2 VSS VSS nch l=0.15 w=1 nf=1 m=1
M8 net4 Vout1 VSS VSS nch l=0.15 w=1 nf=1 m=1
M9 net0 Vb net4 VSS nch l=0.15 w=1 nf=1 m=1
.ends dut
