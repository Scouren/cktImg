* official Analog Canvas netlist; PDK X cards rewritten by convert.py
.model nch nmos
.model pch pmos

.subckt dut VIN VSS VB1 VREF VB5 VB3 VB2 VB4 VOUT
CF1 VOUT VFB 1p
Cm1 net0 VOUT 1p
Cm2 net0 net11 1p
M11 net1 VB1 VIN VIN pch l=0.15 w=1 nf=1 m=1
M12 net5 VFB net1 net10 pch l=0.15 w=1 nf=1 m=1
M13 net3 VREF net1 net10 pch l=0.15 w=1 nf=1 m=1
M14 net5 VB6 VSS VSS nch l=0.15 w=1 nf=1 m=1
M15 net3 VB6 VSS VSS nch l=0.15 w=1 nf=1 m=1
M16 net13 VB3 VIN VIN pch l=0.15 w=1 nf=1 m=1
M17 net13 net0 VSS VSS nch l=0.15 w=1 nf=1 m=1
M18 net13 net13 VSS VSS nch l=0.15 w=1 nf=1 m=1
M21 net4 net0 VSS VSS nch l=0.15 w=1 nf=1 m=1
M22 net7 net13 VSS VSS nch l=0.15 w=1 nf=1 m=1
M23 net4 net4 VIN VIN pch l=0.15 w=1 nf=1 m=1
M24 net7 net4 VIN VIN pch l=0.15 w=1 nf=1 m=1
M25 net2 VB7 net5 VSS nch l=0.15 w=1 nf=1 m=1
M26 net0 VB7 net3 VSS nch l=0.15 w=1 nf=1 m=1
M27 net2 VB5 VT VIN pch l=0.15 w=1 nf=1 m=1
M28 net0 VB5 net14 VIN pch l=0.15 w=1 nf=1 m=1
M29 VT net2 VIN VIN pch l=0.15 w=1 nf=1 m=1
M30 net14 net2 VIN VIN pch l=0.15 w=1 nf=1 m=1
M31 VB7 VB7 VB6 VSS nch l=0.15 w=1 nf=1 m=1
M32 VB6 VB6 VSS VSS nch l=0.15 w=1 nf=1 m=1
M33 VB7 net6 VIN VIN pch l=0.15 w=1 nf=1 m=1
M34 net6 net6 net9 VIN pch l=0.15 w=1 nf=1 m=1
MD1 net11 net0 VSS VSS nch l=0.15 w=1 nf=1 m=1
MD2 VT VB2 VSS VSS nch l=0.15 w=1 nf=1 m=1
MD3 net8 net11 VT VSS nch l=0.15 w=1 nf=1 m=1
MD4 net12 VB4 VT VSS nch l=0.15 w=1 nf=1 m=1
MD5 net11 net12 VIN VIN pch l=0.15 w=1 nf=1 m=1
MD6 net8 net8 VIN VIN pch l=0.15 w=1 nf=1 m=1
MD7 net12 net12 VIN VIN pch l=0.15 w=1 nf=1 m=1
MPT VOUT net7 VIN VIN pch l=0.15 w=1 nf=1 m=1
R1 VIN net9 1k
R2 net6 VSS 1k
RF1 VOUT VFB 1k
RF2 VFB VSS 1k
.ends dut
