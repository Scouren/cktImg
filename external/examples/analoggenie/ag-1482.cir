* official Analog Canvas netlist; PDK X cards rewritten by convert.py
.model nch nmos
.model pch pmos
.model qnpn npn

.subckt opamp VDD VSS INN INP OUT VB1 VB2
M10 net5 VX VSS VSS nch l=0.15 w=1 nf=1 m=1
M11 net4 INN net3 VSS nch l=0.15 w=1 nf=1 m=1
M12 net6 INP net3 VSS nch l=0.15 w=1 nf=1 m=1
M13 net3 VB4 VSS VSS nch l=0.15 w=1 nf=1 m=1
M14 net0 net0 net2 VDD pch l=0.15 w=1 nf=1 m=1
M15 VB3 net0 VDD VDD pch l=0.15 w=1 nf=1 m=1
M16 VB3 VB3 VB4 VSS nch l=0.15 w=1 nf=1 m=1
M17 VB4 VB4 VSS VSS nch l=0.15 w=1 nf=1 m=1
M3 net6 VB1 VDD VDD pch l=0.15 w=1 nf=1 m=1
M4 net4 VB1 VDD VDD pch l=0.15 w=1 nf=1 m=1
M5 OUT VB2 net6 VDD pch l=0.15 w=1 nf=1 m=1
M6 VX VB2 net4 VDD pch l=0.15 w=1 nf=1 m=1
M7 OUT VB3 net1 VSS nch l=0.15 w=1 nf=1 m=1
M8 VX VB3 net5 VSS nch l=0.15 w=1 nf=1 m=1
M9 net1 VX VSS VSS nch l=0.15 w=1 nf=1 m=1
R1 VDD net2 1k
R2 net0 VSS 1k
.ends opamp

.subckt dut VDD VSS Vout VB1 VB2
Q1 net0 net0 VSS VSS qnpn m=1
Q2 net2 net2 VSS VSS qnpn m=1
R1 Vout net0 1k
R2 Vout net1 1k
R3 net1 net2 1k
X1 VDD VSS net1 net0 Vout VB1 VB2 opamp
.ends dut
