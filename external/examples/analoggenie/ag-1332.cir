* official Analog Canvas netlist; PDK X cards rewritten by convert.py
.model nch nmos
.model pch pmos

.subckt EA1 VDD VSS VREF VFP1 OUT VX2
M12 net2 net2 VDD VDD pch l=0.15 w=1 nf=1 m=1
M13 net3 VBP VDD VDD pch l=0.15 w=1 nf=1 m=1
M14 OUT net2 VDD VDD pch l=0.15 w=1 nf=1 m=1
M15 VX2 VREF net3 VDD pch l=0.15 w=1 nf=1 m=1
M16 net0 VFP1 net3 VDD pch l=0.15 w=1 nf=1 m=1
M17 net2 VX2 VSS VSS nch l=0.15 w=1 nf=1 m=1
M18 VX2 VX2 VSS VSS nch l=0.15 w=1 nf=1 m=1
M19 net0 net0 VSS VSS nch l=0.15 w=1 nf=1 m=1
M20 OUT net0 VSS VSS nch l=0.15 w=1 nf=1 m=1
M21 VBP VBP VDD VDD pch l=0.15 w=1 nf=1 m=1
M22 VBP VB1 VSS VSS nch l=0.15 w=1 nf=1 m=1
M23 VB1 net1 VDD VDD pch l=0.15 w=1 nf=1 m=1
M24 VB1 VB1 VSS VSS nch l=0.15 w=1 nf=1 m=1
M25 net1 net1 VDD VDD pch l=0.15 w=1 nf=1 m=1
M26 net1 VB2 VX2 VSS nch l=0.15 w=1 nf=1 m=1
M27 VB2 net1 VDD VDD pch l=0.15 w=1 nf=1 m=1
M28 VB2 VB2 VSS VSS nch l=0.15 w=1 nf=1 m=1
RBIAS VX2 VSS 1k
.ends EA1

.subckt ISR VDD VSS TOP CTRL OUT
M10 net1 net1 VSS VSS nch l=0.15 w=1 nf=1 m=1
M11 net1 VB3 VSS VSS nch l=0.15 w=1 nf=1 m=1
M6 OUT net0 TOP VDD pch l=0.15 w=1 nf=1 m=1
M7 net0 net0 TOP VDD pch l=0.15 w=1 nf=1 m=1
M8 net1 CTRL TOP VDD pch l=0.15 w=1 nf=1 m=1
M9 net0 net1 VSS VSS nch l=0.15 w=1 nf=1 m=1
.ends ISR

.subckt dut VDD VSS VIN VC5 VC1 VC2 VC3 VC4 VP VREF
.model DIODE D(IS=1e-14 N=1)
CFLY VX1 VX2 1p
CO VP VN 1p
COP VP VSS 1p
D1 VN VX2 DIODE
L1 VX1 VX3 1n
M1 VX1 VC1 VIN VDD pch l=0.15 w=1 nf=1 m=1
M2 VX2 VC2 VIN VDD pch l=0.15 w=1 nf=1 m=1
M3 VP VC3 VX3 VDD pch l=0.15 w=1 nf=1 m=1
M4 VX3 VC4 VSS VSS nch l=0.15 w=1 nf=1 m=1
M5 net0 VC5 VIN VDD pch l=0.15 w=1 nf=1 m=1
R1 VP VFP1 1k
R2 VFP1 VSS 1k
X1 VDD VSS VREF VFP1 net1 VX2 EA1
X2 VDD VSS net0 net1 VX1 ISR
.ends dut
