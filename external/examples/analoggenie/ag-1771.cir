* official Analog Canvas netlist; PDK X cards rewritten by convert.py
.model nch nmos
.model pch pmos
.model qpnp pnp

.subckt opamp VDD VSS INP INN OUT N2 N1
M10 OUT VB4 net1 VSS nch l=0.15 w=1 nf=1 m=1
M11 net4 VB5 VSS VSS nch l=0.15 w=1 nf=1 m=1
M12 net1 VB5 VSS VSS nch l=0.15 w=1 nf=1 m=1
M13 N1 VB1 VDD VDD pch l=0.15 w=1 nf=1 m=1
M14 net4 INP N1 VDD pch l=0.15 w=1 nf=1 m=1
M15 net1 INN N1 VDD pch l=0.15 w=1 nf=1 m=1
M16 N1 net0 VDD VDD pch l=0.15 w=1 nf=1 m=1
M17 net0 net0 VDD VDD pch l=0.15 w=1 nf=1 m=1
M18 VB4 net0 VDD VDD pch l=0.15 w=1 nf=1 m=1
M19 net0 N1 VB3 VSS nch l=0.15 w=1 nf=1 m=1
M20 N1 VB3 VSS VSS nch l=0.15 w=1 nf=1 m=1
M21 VB4 VB4 VB5 VSS nch l=0.15 w=1 nf=1 m=1
M22 VB5 VB5 VSS VSS nch l=0.15 w=1 nf=1 m=1
M5 net3 N2 VDD VDD pch l=0.15 w=1 nf=1 m=1
M6 net2 N2 VDD VDD pch l=0.15 w=1 nf=1 m=1
M7 N2 VB2 net3 VDD pch l=0.15 w=1 nf=1 m=1
M8 OUT VB2 net2 VDD pch l=0.15 w=1 nf=1 m=1
M9 N2 VB4 net4 VSS nch l=0.15 w=1 nf=1 m=1
R3 VB3 VSS 1k
.ends opamp

.subckt dut VDD VSS Vout
M1 X net1 VDD VDD pch l=0.15 w=1 nf=1 m=1
M2 Vout net1 VDD VDD pch l=0.15 w=1 nf=1 m=1
M3 net0 net1 VDD VDD pch l=0.15 w=1 nf=1 m=1
M4 N1 net1 VDD VDD pch l=0.15 w=1 nf=1 m=1
Q1 VSS VSS net0 qpnp m=1
Q2 VSS net0 X qpnp m=1
Q3 VSS VSS N1 qpnp m=1
Q4 VSS N1 net2 qpnp m=1
R1 Y net2 1k
R2 Vout Y 1k
X1 VDD VSS Y X net1 net2 N1 opamp
.ends dut
