* official Analog Canvas netlist; PDK X cards rewritten by convert.py
.model nch nmos
.model pch pmos
.model qpnp pnp

.subckt opamp VDD VSS INP INN VB2 VB1 OUT VB3
M10 net3 VC net7 VSS nch l=0.15 w=1 nf=1 m=1
M11 net7 net3 VSS VSS nch l=0.15 w=1 nf=1 m=1
M12 net0 VC net6 VSS nch l=0.15 w=1 nf=1 m=1
M13 net6 net0 VSS VSS nch l=0.15 w=1 nf=1 m=1
M14 VZ VX VDD VDD pch l=0.15 w=1 nf=1 m=1
M15 OUT VB1 VZ VDD pch l=0.15 w=1 nf=1 m=1
M16 OUT VC net5 VSS nch l=0.15 w=1 nf=1 m=1
M17 net5 net0 VSS VSS nch l=0.15 w=1 nf=1 m=1
M18 VC VP VDD VDD pch l=0.15 w=1 nf=1 m=1
M19 VC VC net9 VSS nch l=0.15 w=1 nf=1 m=1
M20 net9 VC VSS VSS nch l=0.15 w=1 nf=1 m=1
M21 VP VP VDD VDD pch l=0.15 w=1 nf=1 m=1
M22 VP VZ VSS VSS nch l=0.15 w=1 nf=1 m=1
M23 net8 VP VDD VDD pch l=0.15 w=1 nf=1 m=1
M24 net8 net8 VZ VSS nch l=0.15 w=1 nf=1 m=1
M25 VZ net8 net4 VSS nch l=0.15 w=1 nf=1 m=1
M26 VY VP VDD VDD pch l=0.15 w=1 nf=1 m=1
M27 VY VY net4 VSS nch l=0.15 w=1 nf=1 m=1
M28 net4 VY VB3 VSS nch l=0.15 w=1 nf=1 m=1
M29 VB3 VP VDD VDD pch l=0.15 w=1 nf=1 m=1
M3 VY VX VDD VDD pch l=0.15 w=1 nf=1 m=1
M30 VB3 VB3 VSS VSS nch l=0.15 w=1 nf=1 m=1
M4 VX VB1 VY VDD pch l=0.15 w=1 nf=1 m=1
M5 VX VC net1 VSS nch l=0.15 w=1 nf=1 m=1
M6 net1 net3 VSS VSS nch l=0.15 w=1 nf=1 m=1
M7 net2 VB2 VDD VDD pch l=0.15 w=1 nf=1 m=1
M8 net3 INP net2 VDD pch l=0.15 w=1 nf=1 m=1
M9 net0 INN net2 VDD pch l=0.15 w=1 nf=1 m=1
.ends opamp

.subckt dut VDD VSS Vout VB1 VB2 VB3
Q1 VSS VSS X qpnp m=1
Q2 VSS VSS net0 qpnp m=1
R1 Vout X 1k
R2 Vout Y 1k
R3 Y net0 1k
X1 VDD VSS X Y VB2 VB1 Vout VB3 opamp
.ends dut
