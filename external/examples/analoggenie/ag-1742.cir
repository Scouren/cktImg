* official Analog Canvas netlist; PDK X cards rewritten by convert.py
.model nch nmos
.model pch pmos
.model qpnp pnp

.subckt dut VDD VSS Vout VB1 VB2
M1 X VG VDD VDD pch l=0.15 w=1 nf=1 m=1
M10 net7 X net2 VDD pch l=0.15 w=1 nf=1 m=1
M11 Z Y net2 VDD pch l=0.15 w=1 nf=1 m=1
M12 VG VB3 net9 VSS nch l=0.15 w=1 nf=1 m=1
M13 net7 VB3 net12 VSS nch l=0.15 w=1 nf=1 m=1
M14 Z VB3 net4 VSS nch l=0.15 w=1 nf=1 m=1
M15 net1 VB3 net5 VSS nch l=0.15 w=1 nf=1 m=1
M16 net9 net7 VSS VSS nch l=0.15 w=1 nf=1 m=1
M17 net12 net7 VSS VSS nch l=0.15 w=1 nf=1 m=1
M18 net4 Z VSS VSS nch l=0.15 w=1 nf=1 m=1
M19 net5 Z VSS VSS nch l=0.15 w=1 nf=1 m=1
M2 Vout VG VDD VDD pch l=0.15 w=1 nf=1 m=1
M20 net3 net3 VDD VDD pch l=0.15 w=1 nf=1 m=1
M21 VB3 net3 VDD VDD pch l=0.15 w=1 nf=1 m=1
M22 VB3 VB3 net10 VSS nch l=0.15 w=1 nf=1 m=1
M23 net10 VB3 VSS VSS nch l=0.15 w=1 nf=1 m=1
M3 net8 VG VDD VDD pch l=0.15 w=1 nf=1 m=1
M4 net0 VG VDD VDD pch l=0.15 w=1 nf=1 m=1
M5 net11 net1 VDD VDD pch l=0.15 w=1 nf=1 m=1
M6 net6 net1 VDD VDD pch l=0.15 w=1 nf=1 m=1
M7 VG VB1 net11 VDD pch l=0.15 w=1 nf=1 m=1
M8 net1 VB1 net6 VDD pch l=0.15 w=1 nf=1 m=1
M9 net2 VB2 VDD VDD pch l=0.15 w=1 nf=1 m=1
Q1 VSS VSS net8 qpnp m=1
Q2 VSS net8 X qpnp m=1
Q3 VSS VSS net0 qpnp m=1
Q4 VSS net0 Z qpnp m=1
R1 Y Z 1k
R2 Vout Y 1k
R3 net3 VSS 1k
.ends dut
