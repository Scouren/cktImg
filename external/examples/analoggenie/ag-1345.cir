* official Analog Canvas netlist; PDK X cards rewritten by convert.py
.model nch nmos
.model pch pmos

.subckt dut VDD VSS VC1 VC2 VC3 VIN VC4 VC5 VP VB3 VREF
.model DIODE D(IS=1e-14 N=1)
CFLY net3 net9 1p
CO VP net8 1p
COP VP VSS 1p
D1 net8 net9 DIODE
L1 net3 net7 1n
M1 net3 VC2 VIN VDD pch l=0.15 w=1 nf=1 m=1
M2 net9 VC3 VIN VDD pch l=0.15 w=1 nf=1 m=1
M3 VP VC5 net7 VDD pch l=0.15 w=1 nf=1 m=1
M4 net7 VC4 VSS VSS nch l=0.15 w=1 nf=1 m=1
M5 net6 VC1 VIN VDD pch l=0.15 w=1 nf=1 m=1
MN1 net0 VREF net11 VSS nch l=0.15 w=1 nf=1 m=1
MN2 net10 VFP1 net11 VSS nch l=0.15 w=1 nf=1 m=1
MN3 VBN VBN VSS VSS nch l=0.15 w=1 nf=1 m=1
MN4 net11 VBN VSS VSS nch l=0.15 w=1 nf=1 m=1
MN5 net1 net2 VSS VSS nch l=0.15 w=1 nf=1 m=1
MN6 net2 net2 VSS VSS nch l=0.15 w=1 nf=1 m=1
MN7 net4 net4 VSS VSS nch l=0.15 w=1 nf=1 m=1
MN8 net5 net4 VSS VSS nch l=0.15 w=1 nf=1 m=1
MN9 net4 VB3 VSS VSS nch l=0.15 w=1 nf=1 m=1
MP1 net0 net10 VDD VDD pch l=0.15 w=1 nf=1 m=1
MP2 net10 net10 VDD VDD pch l=0.15 w=1 nf=1 m=1
MP3 VBN net1 VDD VDD pch l=0.15 w=1 nf=1 m=1
MP4 net1 net1 VDD VDD pch l=0.15 w=1 nf=1 m=1
MP5 net2 net1 VDD VDD pch l=0.15 w=1 nf=1 m=1
MP6 net4 net0 net6 VDD pch l=0.15 w=1 nf=1 m=1
MP7 net5 net5 net6 VDD pch l=0.15 w=1 nf=1 m=1
MP8 net3 net5 net6 VDD pch l=0.15 w=1 nf=1 m=1
R1 VP VFP1 1k
R2 VFP1 VSS 1k
.ends dut
