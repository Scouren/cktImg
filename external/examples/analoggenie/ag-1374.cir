* official Analog Canvas netlist; PDK X cards rewritten by convert.py
.model nch nmos
.model pch pmos

.subckt dut VDD VSS VSTO VCONT1 VCONT2 VCONT3 VOUT VB2
CL VOUT VSS 1p
CSTO VSTO VSS 1p
LRX VX1 VX2 1n
M1 net0 VX2 VX1 VSS nch l=0.15 w=1 nf=1 m=1
M10 net4 net5 VSS VSS nch l=0.15 w=1 nf=1 m=1
M11 net6 net5 VSS VSS nch l=0.15 w=1 nf=1 m=1
M12 net3 net3 VDD VDD pch l=0.15 w=1 nf=1 m=1
M13 VB3 net3 VDD VDD pch l=0.15 w=1 nf=1 m=1
M14 VB3 VB3 VB4 VSS nch l=0.15 w=1 nf=1 m=1
M15 VB4 VB4 VSS VSS nch l=0.15 w=1 nf=1 m=1
M2 net1 net2 VX1 VSS nch l=0.15 w=1 nf=1 m=1
M3 VX1 VB4 VSS VSS nch l=0.15 w=1 nf=1 m=1
M4 net0 VB1 VDD VDD pch l=0.15 w=1 nf=1 m=1
M5 net1 VB1 VDD VDD pch l=0.15 w=1 nf=1 m=1
M6 net5 VB2 net0 VDD pch l=0.15 w=1 nf=1 m=1
M7 net2 VB2 net1 VDD pch l=0.15 w=1 nf=1 m=1
M8 net5 VB3 net4 VSS nch l=0.15 w=1 nf=1 m=1
M9 net2 VB3 net6 VSS nch l=0.15 w=1 nf=1 m=1
MN1 VX1 VCONT2 VSS VSS nch l=0.15 w=1 nf=1 m=1
MN2 VX2 VCONT3 VSS VSS nch l=0.15 w=1 nf=1 m=1
MP2 VX2 net2 VOUT VDD pch l=0.15 w=1 nf=1 m=1
MP3 VX1 VCONT1 VSTO VDD pch l=0.15 w=1 nf=1 m=1
R1 net3 VSS 1k
.ends dut
