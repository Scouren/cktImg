* official Analog Canvas netlist; PDK X cards rewritten by convert.py
.model nch nmos
.model pch pmos
.model qpnp pnp

.global VDD

.subckt opamp VSS INN INP OUT VE
M10 OUT VB1 net7 VDD pch l=0.15 w=1 nf=1 m=1
M11 OUT VB4 net10 VSS nch l=0.15 w=1 nf=1 m=1
M12 net10 net3 VSS VSS nch l=0.15 w=1 nf=1 m=1
M13 net6 VB2 VDD VDD pch l=0.15 w=1 nf=1 m=1
M14 net3 INN net6 VDD pch l=0.15 w=1 nf=1 m=1
M15 VE INP net6 VDD pch l=0.15 w=1 nf=1 m=1
M16 net3 VB4 net2 VSS nch l=0.15 w=1 nf=1 m=1
M17 VE VB4 net9 VSS nch l=0.15 w=1 nf=1 m=1
M18 net2 net3 VSS VSS nch l=0.15 w=1 nf=1 m=1
M19 net9 VE VSS VSS nch l=0.15 w=1 nf=1 m=1
M20 VB3 net0 VDD VDD pch l=0.15 w=1 nf=1 m=1
M21 net0 net0 VDD VDD pch l=0.15 w=1 nf=1 m=1
M22 VB3 VB3 VSS VSS nch l=0.15 w=1 nf=1 m=1
M23 net0 VB3 VSS VSS nch l=0.15 w=1 nf=1 m=1
M24 VB4 net0 VDD VDD pch l=0.15 w=1 nf=1 m=1
M25 VB4 VB4 net4 VSS nch l=0.15 w=1 nf=1 m=1
M26 net4 VB4 VSS VSS nch l=0.15 w=1 nf=1 m=1
M5 net5 net8 VDD VDD pch l=0.15 w=1 nf=1 m=1
M6 net8 VB1 net5 VDD pch l=0.15 w=1 nf=1 m=1
M7 net8 VB4 net1 VSS nch l=0.15 w=1 nf=1 m=1
M8 net1 VE VSS VSS nch l=0.15 w=1 nf=1 m=1
M9 net7 net8 VDD VDD pch l=0.15 w=1 nf=1 m=1
.ends opamp

.subckt dut VDD VSS Vout
M1 X net2 VDD VDD pch l=0.15 w=1 nf=1 m=1
M2 Vout net2 VDD VDD pch l=0.15 w=1 nf=1 m=1
M3 net1 net2 VDD VDD pch l=0.15 w=1 nf=1 m=1
M4 net3 net2 VDD VDD pch l=0.15 w=1 nf=1 m=1
Q1 VSS VSS net1 qpnp m=1
Q2 VSS net1 X qpnp m=1
Q3 VSS VSS net3 qpnp m=1
Q4 VSS net3 net0 qpnp m=1
R1 Y net0 1k
R2 Vout Y 1k
X1 VSS X Y net2 net0 opamp
.ends dut
