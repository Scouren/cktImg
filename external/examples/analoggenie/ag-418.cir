* official Analog Canvas netlist; PDK X cards rewritten by convert.py
.model nch nmos

.subckt dut VDD VSS Vb Vout
C2 Vout net0 1p
CP VDD Vout 1p
Ib net0 VSS DC 1m
Iin VSS net0 DC 1m
LP VDD Vout 1n
M1 Vout Vb net0 VSS nch l=0.15 w=1 nf=1 m=1
RP VDD Vout 1k
.ends dut
