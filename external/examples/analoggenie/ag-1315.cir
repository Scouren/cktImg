* official Analog Canvas netlist; PDK X cards rewritten by convert.py
.model nch nmos
.model pch pmos

.subckt EA VDD VSS IN+ IN- VX2 VCTRL
MN1 net2 VX2 VSS VSS nch l=0.15 w=1 nf=1 m=1
MN2 VX2 VX2 VSS VSS nch l=0.15 w=1 nf=1 m=1
MN3 net3 net3 VSS VSS nch l=0.15 w=1 nf=1 m=1
MN4 VCTRL net3 VSS VSS nch l=0.15 w=1 nf=1 m=1
MN5 net1 net1 net0 VSS nch l=0.15 w=1 nf=1 m=1
MN6 net5 net1 VSS VSS nch l=0.15 w=1 nf=1 m=1
MN7 VB1 VB1 VSS VSS nch l=0.15 w=1 nf=1 m=1
MN8 VB3 VB1 VSS VSS nch l=0.15 w=1 nf=1 m=1
MP1 net2 net2 VDD VDD pch l=0.15 w=1 nf=1 m=1
MP2 net4 VB3 VDD VDD pch l=0.15 w=1 nf=1 m=1
MP3 VCTRL net2 VDD VDD pch l=0.15 w=1 nf=1 m=1
MP4 VX2 IN+ net4 VDD pch l=0.15 w=1 nf=1 m=1
MP5 net3 IN- net4 VDD pch l=0.15 w=1 nf=1 m=1
MP6 net5 net5 VDD VDD pch l=0.15 w=1 nf=1 m=1
MP7 VB1 net5 VDD VDD pch l=0.15 w=1 nf=1 m=1
MP8 VB3 VB3 VDD VDD pch l=0.15 w=1 nf=1 m=1
R1 net0 VSS 1k
RBIAS VDD net1 1k
.ends EA

.subckt ISR VDD VSS VS VCTRL VB2 IOUT
MN1 net0 VB2 VSS VSS nch l=0.15 w=1 nf=1 m=1
MN2 net0 net0 VSS VSS nch l=0.15 w=1 nf=1 m=1
MN3 net1 net0 VSS VSS nch l=0.15 w=1 nf=1 m=1
MP1 net0 VCTRL VS VDD pch l=0.15 w=1 nf=1 m=1
MP2 net1 net1 VS VDD pch l=0.15 w=1 nf=1 m=1
MP3 IOUT net1 VS VDD pch l=0.15 w=1 nf=1 m=1
.ends ISR

.subckt dut VDD VSS VCONT1 VCONT2 VCONT3 VCONT4 VCONT5 VIN VP VREF VB2
.model DIODE D(IS=1e-14 N=1)
CFLY VX1 VX2 1p
CO VP VN 1p
COP VP VSS 1p
D1 VN VX2 DIODE
L1 VX1 VX3 1n
M1 VX1 VCONT2 VIN VDD pch l=0.15 w=1 nf=1 m=1
M2 VX2 VCONT3 VIN VDD pch l=0.15 w=1 nf=1 m=1
M3 VX3 VCONT5 VP VDD pch l=0.15 w=1 nf=1 m=1
M4 VX3 VCONT4 VSS VSS nch l=0.15 w=1 nf=1 m=1
M5 net1 VCONT1 VIN VDD pch l=0.15 w=1 nf=1 m=1
R1 VP VFP1 1k
R2 VFP1 VSS 1k
X1 VDD VSS net1 net0 VB2 VX1 ISR
X2 VDD VSS VREF VFP1 VX2 net0 EA
.ends dut
