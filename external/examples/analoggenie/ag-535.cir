* official Analog Canvas netlist; PDK X cards rewritten by convert.py
.model nch nmos
.model pch pmos

.subckt dut VDD VSS Vcont
I1 VDD net1 DC 1m
L1 net0 VSS 1n
L2 net2 VSS 1n
M3 net0 net2 net1 VDD pch l=0.15 w=1 nf=1 m=1
M4 net2 net0 net1 VDD pch l=0.15 w=1 nf=1 m=1
Mv1 Vcont net0 Vcont VSS nch l=0.15 w=1 nf=1 m=1
Mv2 Vcont net2 Vcont VSS nch l=0.15 w=1 nf=1 m=1
.ends dut
