* official Analog Canvas netlist; PDK X cards rewritten by convert.py
.model nch nmos
.model pch pmos

.subckt Opamp VDD VSS INN INP OUT VX
M1 net0 VX VDD VDD pch l=0.15 w=1 nf=1 m=1
M10 VBP VBP VDD VDD pch l=0.15 w=1 nf=1 m=1
M11 net3 VBP VDD VDD pch l=0.15 w=1 nf=1 m=1
M12 VBN VBP VDD VDD pch l=0.15 w=1 nf=1 m=1
M13 VB1 VB1 VDD VDD pch l=0.15 w=1 nf=1 m=1
M14 VBP net3 VB2 VSS nch l=0.15 w=1 nf=1 m=1
M15 net3 VB2 VSS VSS nch l=0.15 w=1 nf=1 m=1
M16 VBN VBN VSS VSS nch l=0.15 w=1 nf=1 m=1
M17 VB1 VBN VSS VSS nch l=0.15 w=1 nf=1 m=1
M2 VX VX VDD VDD pch l=0.15 w=1 nf=1 m=1
M3 net1 net1 VDD VDD pch l=0.15 w=1 nf=1 m=1
M4 OUT net1 VDD VDD pch l=0.15 w=1 nf=1 m=1
M5 VX INN net2 VSS nch l=0.15 w=1 nf=1 m=1
M6 net1 INP net2 VSS nch l=0.15 w=1 nf=1 m=1
M7 net2 VBN VSS VSS nch l=0.15 w=1 nf=1 m=1
M8 net0 net0 VSS VSS nch l=0.15 w=1 nf=1 m=1
M9 OUT net0 VSS VSS nch l=0.15 w=1 nf=1 m=1
R3 VB2 VSS 1k
.ends Opamp

.subckt dut VDD VSS VIN Vref VOUT
CL VOUT VX 1p
MNP VIN net1 VOUT VSS nch l=0.15 w=1 nf=1 m=1
R1 VOUT net0 1k
R2 net0 VSS 1k
R3 VX VSS 1k
X1 VDD VSS net0 Vref net1 VX Opamp
.ends dut
