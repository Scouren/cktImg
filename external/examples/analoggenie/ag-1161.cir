* official Analog Canvas netlist; PDK X cards rewritten by convert.py
.model nch nmos
.model pch pmos

.subckt dut VDD VSS
C net1 net0 1p
L net1 net0 1n
M1 net1 net0 VDD VDD pch l=0.15 w=1 nf=1 m=1
M2 net0 net1 VSS VSS nch l=0.15 w=1 nf=1 m=1
.ends dut
