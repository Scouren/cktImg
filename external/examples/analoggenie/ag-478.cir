* official Analog Canvas netlist; PDK X cards rewritten by convert.py
.model nch nmos

.subckt dut VDD VSS Vb1 Y N
M1 Y net1 X VSS nch l=0.15 w=1 nf=1 m=1
M2 N X VSS VSS nch l=0.15 w=1 nf=1 m=1
R1 VDD Y 1k
R2 VDD N 1k
RS net0 X 1k
Vin net0 VSS DC 1
Vn1 net1 Vb1 DC 1
.ends dut
