* official Analog Canvas netlist; PDK X cards rewritten by convert.py
.model nch nmos
.model pch pmos
.model qpnp pnp

.subckt dut VDD VSS Vout VB1 VB3 VB2 VB4
M1 X VG VDD VDD pch l=0.15 w=1 nf=1 m=1
M10 VG VB3 net1 VDD pch l=0.15 w=1 nf=1 m=1
M11 VF VB3 net3 VDD pch l=0.15 w=1 nf=1 m=1
M12 VG VC net5 VSS nch l=0.15 w=1 nf=1 m=1
M13 VF VC net6 VSS nch l=0.15 w=1 nf=1 m=1
M14 net5 VB2 VSS VSS nch l=0.15 w=1 nf=1 m=1
M15 net6 VB2 VSS VSS nch l=0.15 w=1 nf=1 m=1
M16 VC net2 VDD VDD pch l=0.15 w=1 nf=1 m=1
M17 net2 net2 VDD VDD pch l=0.15 w=1 nf=1 m=1
M18 VB4 net2 VDD VDD pch l=0.15 w=1 nf=1 m=1
M19 VC VC net4 VSS nch l=0.15 w=1 nf=1 m=1
M2 Vout VG VDD VDD pch l=0.15 w=1 nf=1 m=1
M20 net4 VC VSS VSS nch l=0.15 w=1 nf=1 m=1
M21 net2 VB4 VSS VSS nch l=0.15 w=1 nf=1 m=1
M22 net0 VB4 VSS VSS nch l=0.15 w=1 nf=1 m=1
M3 net7 VG VDD VDD pch l=0.15 w=1 nf=1 m=1
M4 VT VG VDD VDD pch l=0.15 w=1 nf=1 m=1
M5 VT VB1 VDD VDD pch l=0.15 w=1 nf=1 m=1
M6 net5 X VT VDD pch l=0.15 w=1 nf=1 m=1
M7 net6 Y VT VDD pch l=0.15 w=1 nf=1 m=1
M8 net1 VF VDD VDD pch l=0.15 w=1 nf=1 m=1
M9 net3 VF VDD VDD pch l=0.15 w=1 nf=1 m=1
Q1 VSS VSS net7 qpnp m=1
Q2 VSS net7 X qpnp m=1
Q3 VSS VSS VT qpnp m=1
Q4 VSS VT VF qpnp m=1
R1 Y VF 1k
R2 Vout Y 1k
R3 VB4 net0 1k
.ends dut
