* official Analog Canvas netlist; PDK X cards rewritten by convert.py
.model nch nmos
.model pch pmos

.subckt dut VDD VSS vci phi1 phi2 vco
C1 vcx VSS 1p
C2 net4 vco 1p
C3 net5 vco 1p
M1 vci phi1 vcx VSS nch l=0.15 w=1 nf=1 m=1
M10 VB2 VB2 VDD VDD pch l=0.15 w=1 nf=1 m=1
M11 net0 VB2 VDD VDD pch l=0.15 w=1 nf=1 m=1
M12 VB2 net0 net3 VSS nch l=0.15 w=1 nf=1 m=1
M13 net0 net0 VSS VSS nch l=0.15 w=1 nf=1 m=1
M14 VB1 VB1 VDD VDD pch l=0.15 w=1 nf=1 m=1
M15 VB3 VB1 VDD VDD pch l=0.15 w=1 nf=1 m=1
M16 VB1 net0 VSS VSS nch l=0.15 w=1 nf=1 m=1
M17 VB3 VB3 VSS VSS nch l=0.15 w=1 nf=1 m=1
M2 vcx phi2 net4 VSS nch l=0.15 w=1 nf=1 m=1
M3 net1 net4 net2 VSS nch l=0.15 w=1 nf=1 m=1
M4 net5 VSS net2 VSS nch l=0.15 w=1 nf=1 m=1
M5 net2 VB3 VSS VSS nch l=0.15 w=1 nf=1 m=1
M6 net1 net1 VDD VDD pch l=0.15 w=1 nf=1 m=1
M7 net5 net1 VDD VDD pch l=0.15 w=1 nf=1 m=1
M8 vco net5 VDD VDD pch l=0.15 w=1 nf=1 m=1
M9 vco VB3 VSS VSS nch l=0.15 w=1 nf=1 m=1
R1 net3 VSS 1k
.ends dut
