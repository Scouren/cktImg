* official Analog Canvas netlist; PDK X cards rewritten by convert.py
.model nch nmos

.subckt dut VDD VSS VOUT1 VIN1 VB1
CB VIN1 X 1p
IB VDD net0 DC 1m
M1 VOUT1 X VSS VSS nch l=0.15 w=1 nf=1 m=1
MB net0 net0 VSS VSS nch l=0.15 w=1 nf=1 m=1
MR net0 VB1 X VSS nch l=0.15 w=1 nf=1 m=1
RD VDD VOUT1 1k
.ends dut
