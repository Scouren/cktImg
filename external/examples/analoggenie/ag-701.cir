* official Analog Canvas netlist; PDK X cards rewritten by convert.py
.model nch nmos

.subckt dut VDD VSS vout- vout+ Vb vin+ vin-
Ibias1 net3 VSS DC 1m
Ibias2 net2 VSS DC 1m
M1 vout- net0 net3 VSS nch l=0.15 w=1 nf=1 m=1
M2 vout+ Vb net3 VSS nch l=0.15 w=1 nf=1 m=1
M3 vout- Vb net2 VSS nch l=0.15 w=1 nf=1 m=1
M4 vout+ net1 net2 VSS nch l=0.15 w=1 nf=1 m=1
RD1 VDD vout- 1k
RD2 VDD vout+ 1k
RS1 vin+ net0 1k
RS2 vin- net1 1k
.ends dut
