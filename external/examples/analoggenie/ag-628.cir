* official Analog Canvas netlist; PDK X cards rewritten by convert.py
.model nch nmos
.model pch pmos

.subckt dut V+ V- In+ In- Out
C1 net8 Out 1pF
I1 net0 V- DC 20uA
M1 net4 net0 V+ V+ pch l=0.15 w=1 nf=1 m=1
M10 net9 net5 V- V- nch l=0.15 w=1 nf=1 m=1
M11 net2 net0 V+ V+ pch l=0.15 w=1 nf=1 m=1
M12 net7 net0 net2 V+ pch l=0.15 w=1 nf=1 m=1
M13 net1 net0 V+ V+ pch l=0.15 w=1 nf=1 m=1
M14 net8 net0 net1 V+ pch l=0.15 w=1 nf=1 m=1
M15 net7 net7 V- V- nch l=0.15 w=1 nf=1 m=1
M16 net8 net7 V- V- nch l=0.15 w=1 nf=1 m=1
M17 Out net0 V+ V+ pch l=0.15 w=1 nf=1 m=1
M18 Out net8 V- V- nch l=0.15 w=1 nf=1 m=1
M2 net0 net0 net4 V+ pch l=0.15 w=1 nf=1 m=1
M3 net6 net0 V+ V+ pch l=0.15 w=1 nf=1 m=1
M4 net5 net0 net6 V+ pch l=0.15 w=1 nf=1 m=1
M5 net1 In+ net3 V- nch l=0.15 w=1 nf=1 m=1
M6 net2 In- net3 V- nch l=0.15 w=1 nf=1 m=1
M7 net5 net5 net10 V- nch l=0.15 w=1 nf=1 m=1
M8 net10 net5 V- V- nch l=0.15 w=1 nf=1 m=1
M9 net3 net5 net9 V- nch l=0.15 w=1 nf=1 m=1
.ends dut
