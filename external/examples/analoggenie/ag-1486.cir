* official Analog Canvas netlist; PDK X cards rewritten by convert.py
.model nch nmos
.model pch pmos
.model qnpn npn

.subckt A1 VDD VSS VB1 VB2 INN INP OUT
M1 net4 INN net0 VSS nch l=0.15 w=1 nf=1 m=1
M10 net5 net2 VSS VSS nch l=0.15 w=1 nf=1 m=1
M11 net6 net2 VSS VSS nch l=0.15 w=1 nf=1 m=1
M12 VB4 VBP VDD VDD pch l=0.15 w=1 nf=1 m=1
M13 VB4 VB4 VB5 VSS nch l=0.15 w=1 nf=1 m=1
M14 VB5 VB5 VSS VSS nch l=0.15 w=1 nf=1 m=1
M15 net1 VBP VDD VDD pch l=0.15 w=1 nf=1 m=1
M16 VBP VBP VDD VDD pch l=0.15 w=1 nf=1 m=1
M17 VB3 VBP VDD VDD pch l=0.15 w=1 nf=1 m=1
M18 net1 net1 VSS VSS nch l=0.15 w=1 nf=1 m=1
M19 VBP VB3 net3 VSS nch l=0.15 w=1 nf=1 m=1
M2 net7 INP net0 VSS nch l=0.15 w=1 nf=1 m=1
M20 VB3 VB3 VSS VSS nch l=0.15 w=1 nf=1 m=1
M21 net3 net1 VSS VSS nch l=0.15 w=1 nf=1 m=1
M3 net0 VB5 VSS VSS nch l=0.15 w=1 nf=1 m=1
M4 net4 VB1 VDD VDD pch l=0.15 w=1 nf=1 m=1
M5 net7 VB1 VDD VDD pch l=0.15 w=1 nf=1 m=1
M6 net2 VB2 net4 VDD pch l=0.15 w=1 nf=1 m=1
M7 OUT VB2 net7 VDD pch l=0.15 w=1 nf=1 m=1
M8 net2 VB4 net5 VSS nch l=0.15 w=1 nf=1 m=1
M9 OUT VB4 net6 VSS nch l=0.15 w=1 nf=1 m=1
.ends A1

.subckt dut VDD VSS Vout VB1 VB2
Q1 X X VSS VSS qnpn m=1
Q2 net0 net0 VSS VSS qnpn m=1
R1 Vout X 1k
R2 Vout Y 1k
R3 Y net0 1k
X1 VDD VSS VB1 VB2 Y X Vout A1
.ends dut
