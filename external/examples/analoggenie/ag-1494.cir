* official Analog Canvas netlist; PDK X cards rewritten by convert.py
.model nch nmos
.model pch pmos
.model qnpn npn

.subckt A1 VDD VSS INN INP OUT VE
M1 net3 VB1 VDD VDD pch l=0.15 w=1 nf=1 m=1
M10 net5 INP net9 VSS nch l=0.15 w=1 nf=1 m=1
M11 net9 VB2 VSS VSS nch l=0.15 w=1 nf=1 m=1
M12 VP VP VDD VDD pch l=0.15 w=1 nf=1 m=1
M13 net8 VP VDD VDD pch l=0.15 w=1 nf=1 m=1
M14 net0 VP VDD VDD pch l=0.15 w=1 nf=1 m=1
M15 VB4 VP VDD VDD pch l=0.15 w=1 nf=1 m=1
M16 VC VP VDD VDD pch l=0.15 w=1 nf=1 m=1
M17 VP net7 VSS VSS nch l=0.15 w=1 nf=1 m=1
M18 net8 net8 net7 VSS nch l=0.15 w=1 nf=1 m=1
M19 net7 net8 net6 VSS nch l=0.15 w=1 nf=1 m=1
M2 net5 VB1 VDD VDD pch l=0.15 w=1 nf=1 m=1
M20 net0 net0 net6 VSS nch l=0.15 w=1 nf=1 m=1
M21 net6 net0 VB4 VSS nch l=0.15 w=1 nf=1 m=1
M22 VB4 VB4 VSS VSS nch l=0.15 w=1 nf=1 m=1
M23 VC VC VE VSS nch l=0.15 w=1 nf=1 m=1
M24 VE VC VSS VSS nch l=0.15 w=1 nf=1 m=1
M3 net2 VB3 net3 VDD pch l=0.15 w=1 nf=1 m=1
M4 OUT VB3 net5 VDD pch l=0.15 w=1 nf=1 m=1
M5 net2 VC net4 VSS nch l=0.15 w=1 nf=1 m=1
M6 OUT VC net1 VSS nch l=0.15 w=1 nf=1 m=1
M7 net4 net2 VSS VSS nch l=0.15 w=1 nf=1 m=1
M8 net1 net2 VSS VSS nch l=0.15 w=1 nf=1 m=1
M9 net3 INN net9 VSS nch l=0.15 w=1 nf=1 m=1
.ends A1

.subckt dut VDD VSS Vout
Q1 X X VSS VSS qnpn m=1
Q2 net0 net0 VSS VSS qnpn m=1
R1 Vout X 1k
R2 Vout Y 1k
R3 Y net0 1k
X1 VDD VSS Y X Vout net0 A1
.ends dut
