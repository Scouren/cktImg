* official Analog Canvas netlist; PDK X cards rewritten by convert.py
.model nch nmos

.subckt dut VDD VSS
I1 net6 VSS DC 1m
I2 net7 VSS DC 1m
I3 net5 VSS DC 1m
I4 net3 VSS DC 1m
L1 VDD net2 1n
L2 VDD net0 1n
L3 VDD net1 1n
L4 VDD net4 1n
M1 net2 net4 net7 VSS nch l=0.15 w=1 nf=1 m=1
M2 net2 net0 net6 VSS nch l=0.15 w=1 nf=1 m=1
M3 net0 net2 net6 VSS nch l=0.15 w=1 nf=1 m=1
M4 net0 net1 net7 VSS nch l=0.15 w=1 nf=1 m=1
M5 net1 net2 net3 VSS nch l=0.15 w=1 nf=1 m=1
M6 net1 net4 net5 VSS nch l=0.15 w=1 nf=1 m=1
M7 net4 net1 net5 VSS nch l=0.15 w=1 nf=1 m=1
M8 net4 net0 net3 VSS nch l=0.15 w=1 nf=1 m=1
.ends dut
