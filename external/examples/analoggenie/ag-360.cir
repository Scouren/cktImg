* official Analog Canvas netlist; PDK X cards rewritten by convert.py
.model nch nmos

.subckt dut VDD VSS VIN1 VIN2 X Y
Ib VDD Vb1 DC 1m
ISS P VSS DC 1m
M1 net2 VIN1 P VSS nch l=0.15 w=1 nf=1 m=1
M15 Vb1 Vb1 net1 VSS nch l=0.15 w=1 nf=1 m=1
M16 net1 Vb1 P VSS nch l=0.15 w=1 nf=1 m=1
M2 net0 VIN2 P VSS nch l=0.15 w=1 nf=1 m=1
M3 X Vb1 net2 VSS nch l=0.15 w=1 nf=1 m=1
M4 Y Vb1 net0 VSS nch l=0.15 w=1 nf=1 m=1
.ends dut
