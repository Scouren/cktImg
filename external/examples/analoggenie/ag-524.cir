* official Analog Canvas netlist; PDK X cards rewritten by convert.py
.model nch nmos

.subckt dut VDD VSS
C1 VDD X 1p
C2 VDD Y 1p
L1 VDD X 1n
L2 VDD Y 1n
M1 X Y VSS VSS nch l=0.15 w=1 nf=1 m=1
M2 Y X VSS VSS nch l=0.15 w=1 nf=1 m=1
Rp VDD X 1k
Rp2 VDD Y 1k
.ends dut
