* official Analog Canvas netlist; PDK X cards rewritten by convert.py
.model nch nmos
.model pch pmos

.subckt dut VDD VSS VIN VCONT1 VB4 VCONT2 VCONT3 VCONT4 VCONT5 VP VB2 VREF
.model DIODE D(IS=1e-14 N=1)
CFLY VX1 VX2 1p
CO VP VN 1p
COP VP VSS 1p
D1 VN VX2 DIODE
L1 VX1 VX3 1n
M1 net4 VCONT1 VIN VDD pch l=0.15 w=1 nf=1 m=1
M2 VX1 VCONT2 VIN VDD pch l=0.15 w=1 nf=1 m=1
M3 VX2 VCONT3 VIN VDD pch l=0.15 w=1 nf=1 m=1
M4 VX3 VCONT5 VP VDD pch l=0.15 w=1 nf=1 m=1
M5 VX3 VCONT4 VSS VSS nch l=0.15 w=1 nf=1 m=1
MN1 net8 VB6 VSS VSS nch l=0.15 w=1 nf=1 m=1
MN10 net3 net0 VSS VSS nch l=0.15 w=1 nf=1 m=1
MN11 net0 VB4 VSS VSS nch l=0.15 w=1 nf=1 m=1
MN2 net5 VB6 VSS VSS nch l=0.15 w=1 nf=1 m=1
MN3 net2 VB5 net8 VSS nch l=0.15 w=1 nf=1 m=1
MN4 VCTRL VB5 net5 VSS nch l=0.15 w=1 nf=1 m=1
MN5 VB5 VB5 VB6 VSS nch l=0.15 w=1 nf=1 m=1
MN6 VB6 VB6 VSS VSS nch l=0.15 w=1 nf=1 m=1
MN7 net1 VB3 VX2 VSS nch l=0.15 w=1 nf=1 m=1
MN8 VB3 VB3 VSS VSS nch l=0.15 w=1 nf=1 m=1
MN9 net0 net0 VSS VSS nch l=0.15 w=1 nf=1 m=1
MP1 net6 VB1 VDD VDD pch l=0.15 w=1 nf=1 m=1
MP10 VB3 net1 VDD VDD pch l=0.15 w=1 nf=1 m=1
MP11 VX1 net3 net4 VDD pch l=0.15 w=1 nf=1 m=1
MP12 net3 net3 net4 VDD pch l=0.15 w=1 nf=1 m=1
MP13 net0 VCTRL net4 VDD pch l=0.15 w=1 nf=1 m=1
MP2 net8 VREF net6 VDD pch l=0.15 w=1 nf=1 m=1
MP3 net5 VFP1 net6 VDD pch l=0.15 w=1 nf=1 m=1
MP4 net9 net2 VDD VDD pch l=0.15 w=1 nf=1 m=1
MP5 net7 net2 VDD VDD pch l=0.15 w=1 nf=1 m=1
MP6 net2 VB2 net9 VDD pch l=0.15 w=1 nf=1 m=1
MP7 VCTRL VB2 net7 VDD pch l=0.15 w=1 nf=1 m=1
MP8 VB5 net1 VDD VDD pch l=0.15 w=1 nf=1 m=1
MP9 net1 net1 VDD VDD pch l=0.15 w=1 nf=1 m=1
R1 VP VFP1 1k
R2 VFP1 VSS 1k
RBIAS VX2 VSS 1k
.ends dut
