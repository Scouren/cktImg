* official Analog Canvas netlist; PDK X cards rewritten by convert.py
.model nch nmos

.subckt dut VDD VSS Vin Vout
C1 P VSS 1p
L1 VDD Vout 1n
M1 Q Vin VSS VSS nch l=0.15 w=1 nf=1 m=1
M2 Vout P Q VSS nch l=0.15 w=1 nf=1 m=1
M3 net0 net0 P VSS nch l=0.15 w=1 nf=1 m=1
R1 P Vout 1k
R2 net0 Vout 1k
.ends dut
