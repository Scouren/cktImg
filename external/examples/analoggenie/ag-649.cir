* official Analog Canvas netlist; PDK X cards rewritten by convert.py
.model nch nmos
.model pch pmos

.subckt dut VDD VSS 1V Vin Vout1 Vout2
C1 net14 VSS 2pF
I1 VDD net5 DC 10uA
M1 net7 Vin net12 VSS nch l=0.15 w=1 nf=1 m=1
M10 net4 net2 VDD VDD pch l=0.15 w=1 nf=1 m=2
M11 net3 net2 net4 VDD pch l=0.15 w=1 nf=1 m=4
M12 net17 net2 VDD VDD pch l=0.15 w=1 nf=1 m=1
M13 net14 net2 net17 VDD pch l=0.15 w=1 nf=1 m=2
M14 net3 net3 net9 VSS nch l=0.15 w=1 nf=1 m=2
M15 net9 net3 VSS VSS nch l=0.15 w=1 nf=1 m=1
M16 net15 net3 net18 VSS nch l=0.15 w=1 nf=1 m=2
M17 net18 net3 VSS VSS nch l=0.15 w=1 nf=1 m=1
M18 net14 1.5V net15 VSS nch l=0.15 w=1 nf=1 m=1
M19 VDD Vout1 net15 VSS nch l=0.15 w=1 nf=1 m=1
M2 net16 net11 net12 VSS nch l=0.15 w=1 nf=1 m=1
M20 net10 net14 net6 VSS nch l=0.15 w=1 nf=1 m=1
M21 net8 net0 net6 VSS nch l=0.15 w=1 nf=1 m=1
M22 net10 net10 VDD VDD pch l=0.15 w=1 nf=1 m=1
M23 net8 net10 VDD VDD pch l=0.15 w=1 nf=1 m=1
M24 net6 net5 VSS VSS nch l=0.15 w=1 nf=1 m=1
M25 net13 net8 VDD VDD pch l=0.15 w=1 nf=1 m=1
M26 Vout1 net8 VDD VDD pch l=0.15 w=1 nf=1 m=1
M27 Vout1 net5 VSS VSS nch l=0.15 w=1 nf=1 m=1
M28 Vout2 Vout1 VDD VDD pch l=0.15 w=1 nf=1 m=1
M29 Vout2 Vout1 VSS VSS nch l=0.15 w=1 nf=1 m=1
M3 net7 net7 VDD VDD pch l=0.15 w=1 nf=1 m=1
M4 net16 net7 VDD VDD pch l=0.15 w=1 nf=1 m=1
M5 net2 net16 net11 VSS nch l=0.15 w=1 nf=1 m=1
M6 net5 net5 VSS VSS nch l=0.15 w=1 nf=1 m=1
M7 net12 net5 VSS VSS nch l=0.15 w=1 nf=1 m=1
M8 net1 net2 VDD VDD pch l=0.15 w=1 nf=1 m=2
M9 net2 net2 net1 VDD pch l=0.15 w=1 nf=1 m=4
R1 VDD 1.5V 15kΩ
R2 1.5V 1V 5kΩ
R3 net11 VSS 10kΩ
R4 net13 net0 40kΩ
R5 VDD net0 20kΩ
R6 net0 VSS 20kΩ
R7 1V VSS 10kΩ
.ends dut
