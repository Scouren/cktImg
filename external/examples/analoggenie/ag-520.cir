* official Analog Canvas netlist; PDK X cards rewritten by convert.py
.model nch nmos

.subckt dut VDD VSS VIF VRF VLO
M1 net0 VLO VSS VSS nch l=0.15 w=1 nf=1 m=1
M2 VIF VRF net0 VSS nch l=0.15 w=1 nf=1 m=1
RD VDD VIF 1k
.ends dut
