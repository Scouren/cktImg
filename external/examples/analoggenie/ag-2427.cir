* official Analog Canvas netlist; PDK X cards rewritten by convert.py
.model nch nmos
.model pch pmos

.global VDD

.subckt Error_Amplifier VSS VREF VEA
M10 VEA VEA VSS VSS nch l=0.15 w=1 nf=1 m=1
M11 net3 VEA net6 VSS nch l=0.15 w=1 nf=1 m=1
M12 net6 VBN VSS VSS nch l=0.15 w=1 nf=1 m=1
M13 VBN net2 VDD VDD pch l=0.15 w=1 nf=1 m=1
M14 net2 net2 VDD VDD pch l=0.15 w=1 nf=1 m=1
M15 net0 net0 VDD VDD pch l=0.15 w=1 nf=1 m=1
M16 net5 net0 VDD VDD pch l=0.15 w=1 nf=1 m=1
M17 VBN VBN VSS VSS nch l=0.15 w=1 nf=1 m=1
M18 net2 net5 VSS VSS nch l=0.15 w=1 nf=1 m=1
M19 net0 net5 VSS VSS nch l=0.15 w=1 nf=1 m=1
M20 net4 net5 VSS VSS nch l=0.15 w=1 nf=1 m=1
M4 net1 net1 VDD VDD pch l=0.15 w=1 nf=1 m=1
M5 VEA net1 VDD VDD pch l=0.15 w=1 nf=1 m=1
M6 VEA net3 VDD VDD pch l=0.15 w=1 nf=1 m=1
M7 net3 net3 VDD VDD pch l=0.15 w=1 nf=1 m=1
M8 net1 VREF net6 VSS nch l=0.15 w=1 nf=1 m=1
M9 VEA VEA VSS VSS nch l=0.15 w=1 nf=1 m=1
R1 net5 net4 1k
.ends Error_Amplifier

.subckt dut VDD VSS VIN VOUT
M1 net1 VEA VIN VDD pch l=0.15 w=1 nf=1 m=1
M2 net2 net2 net1 VDD pch l=0.15 w=1 nf=1 m=1
M3 net2 nb VSS VSS nch l=0.15 w=1 nf=1 m=1
MBIAS VERR nb VSS VSS nch l=0.15 w=1 nf=1 m=1
MCHG net3 pb VIN VDD pch l=0.15 w=1 nf=1 m=1
MCTRL VERR net2 VOUT VDD pch l=0.15 w=1 nf=1 m=1
MGEN net0 net0 VSS VSS nch l=0.15 w=1 nf=1 m=1
MINJ VERR net0 VSS VSS nch l=0.15 w=1 nf=1 m=1
MRES VOUT VERR VIN VDD pch l=0.15 w=1 nf=1 m=1
MSEN net0 VEA net3 VDD pch l=0.15 w=1 nf=1 m=1
X1 VSS VREF VEA Error_Amplifier
.ends dut
