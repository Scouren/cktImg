* official Analog Canvas netlist; PDK X cards rewritten by convert.py
.model nch nmos
.model pch pmos

.subckt dut VDD VEE VSS Vin- Vin+ VB1 VB2 Vout
CL Vout VSS 1p
Ibias1 net0 VEE DC 1m
Ibias2 net2 VSS DC 1m
M1 VX Vin- net2 VSS nch l=0.15 w=1 nf=1 m=1
M10 net4 net1 VSS VSS nch l=0.15 w=1 nf=1 m=1
M11 net0 net0 VDD VDD pch l=0.15 w=1 nf=1 m=1
M12 net0 net0 VX VSS nch l=0.15 w=1 nf=1 m=1
M13 net0 net0 net5 VSS nch l=0.15 w=1 nf=1 m=1
M2 net5 Vin+ net2 VSS nch l=0.15 w=1 nf=1 m=1
M3 VX net0 VDD VDD pch l=0.15 w=1 nf=1 m=1
M4 net5 net0 VDD VDD pch l=0.15 w=1 nf=1 m=1
M5 net1 VB1 net5 VDD pch l=0.15 w=1 nf=1 m=1
M6 Vout VB1 VX VDD pch l=0.15 w=1 nf=1 m=1
M7 net1 VB2 net3 VSS nch l=0.15 w=1 nf=1 m=1
M8 Vout VB2 net4 VSS nch l=0.15 w=1 nf=1 m=1
M9 net3 net1 VSS VSS nch l=0.15 w=1 nf=1 m=1
.ends dut
