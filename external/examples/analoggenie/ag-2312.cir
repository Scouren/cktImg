* official Analog Canvas netlist; PDK X cards rewritten by convert.py
.model nch nmos
.model pch pmos

.subckt bias VDD VSS VB1 VB6
M22 VB1 net0 VDD VDD pch l=0.15 w=1 nf=1 m=1
M23 VB1 VB1 VB6 VSS nch l=0.15 w=1 nf=1 m=1
M24 VB6 VB6 VSS VSS nch l=0.15 w=1 nf=1 m=1
M25 net0 net0 VDD VDD pch l=0.15 w=1 nf=1 m=1
M26 net0 VB3 net1 VSS nch l=0.15 w=1 nf=1 m=1
M27 VB3 net0 VDD VDD pch l=0.15 w=1 nf=1 m=1
M28 VB3 VB3 VSS VSS nch l=0.15 w=1 nf=1 m=1
R4 net1 VSS 1k
.ends bias

.subckt dut VDD VSS VB5 VREF VB4 IBUF VIN FB VOUT
CL VOUT net5 1p
M10 EAO VB2 VX VDD pch l=0.15 w=1 nf=1 m=1
M11 net3 VY VDD VDD pch l=0.15 w=1 nf=1 m=1
M12 VX VY VDD VDD pch l=0.15 w=1 nf=1 m=1
M13 net0 VB4 VDD VDD pch l=0.15 w=1 nf=1 m=1
M14 VY EAO net0 VDD pch l=0.15 w=1 nf=1 m=1
M15 VY VY VSS VSS nch l=0.15 w=1 nf=1 m=1
M16 GATE VY VSS VSS nch l=0.15 w=1 nf=1 m=1
M17 VDD net0 GATE VSS nch l=0.15 w=1 nf=1 m=1
M18 VX EAO IBUF VSS nch l=0.15 w=1 nf=1 m=1
M19 VX VX VDD VDD pch l=0.15 w=1 nf=1 m=1
M2 net1 VB5 VDD VDD pch l=0.15 w=1 nf=1 m=1
M20 GATE VX VDD VDD pch l=0.15 w=1 nf=1 m=1
M21 VSS IBUF GATE VDD pch l=0.15 w=1 nf=1 m=1
M3 net2 VREF net1 VDD pch l=0.15 w=1 nf=1 m=1
M4 net4 FB net1 VDD pch l=0.15 w=1 nf=1 m=1
M5 net2 VB6 VSS VSS nch l=0.15 w=1 nf=1 m=1
M6 net4 VB6 VSS VSS nch l=0.15 w=1 nf=1 m=1
M7 VY VB1 net2 VSS nch l=0.15 w=1 nf=1 m=1
M8 EAO VB1 net4 VSS nch l=0.15 w=1 nf=1 m=1
M9 VY VB2 net3 VDD pch l=0.15 w=1 nf=1 m=1
MNP VIN GATE VOUT VSS nch l=0.15 w=1 nf=1 m=1
R1 FB VSS 1k
R2 VOUT FB 1k
R3 net5 VSS 1k
RL VOUT VSS 1k
X1 VDD VSS VB1 VB6 bias
.ends dut
