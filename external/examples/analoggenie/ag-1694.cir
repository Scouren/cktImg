* official Analog Canvas netlist; PDK X cards rewritten by convert.py
.model nch nmos
.model pch pmos
.model qpnp pnp

.subckt dut VDD VSS Vout VB3 VB2 VB1
M1 net0 net3 VDD VDD pch l=0.15 w=1 nf=1 m=1
M10 VP X net4 VDD pch l=0.15 w=1 nf=1 m=1
M11 net6 Y net4 VDD pch l=0.15 w=1 nf=1 m=1
M12 net1 VB7 VDD VDD pch l=0.15 w=1 nf=1 m=1
M13 net1 net1 VSS VSS nch l=0.15 w=1 nf=1 m=1
M14 VB7 VB7 VDD VDD pch l=0.15 w=1 nf=1 m=1
M15 VB7 VB5 VB4 VSS nch l=0.15 w=1 nf=1 m=1
M16 VB4 net1 VSS VSS nch l=0.15 w=1 nf=1 m=1
M17 VB5 VB7 VDD VDD pch l=0.15 w=1 nf=1 m=1
M18 VB5 VB4 VSS VSS nch l=0.15 w=1 nf=1 m=1
M19 VB6 VB7 VDD VDD pch l=0.15 w=1 nf=1 m=1
M2 net3 VB3 net0 VDD pch l=0.15 w=1 nf=1 m=1
M20 VB6 VB6 net2 VSS nch l=0.15 w=1 nf=1 m=1
M21 net2 VB6 VSS VSS nch l=0.15 w=1 nf=1 m=1
M3 net3 VB6 VP VSS nch l=0.15 w=1 nf=1 m=1
M4 VP VB2 VSS VSS nch l=0.15 w=1 nf=1 m=1
M5 X net3 VDD VDD pch l=0.15 w=1 nf=1 m=1
M6 Vout VB3 X VDD pch l=0.15 w=1 nf=1 m=1
M7 Vout VB6 net6 VSS nch l=0.15 w=1 nf=1 m=1
M8 net6 VB2 VSS VSS nch l=0.15 w=1 nf=1 m=1
M9 net4 VB1 VDD VDD pch l=0.15 w=1 nf=1 m=1
Q1 VSS VSS VP qpnp m=1
Q2 VP VP X qpnp m=1
Q3 VSS VSS net7 qpnp m=1
Q4 net7 net7 net5 qpnp m=1
R1 Vout X 1k
R2 Vout Y 1k
R3 Y net5 1k
.ends dut
