* official Analog Canvas netlist; PDK X cards rewritten by convert.py
.model nch nmos
.model pch pmos

.subckt dut VDD VSS vci phi1 phi2 vco VB1
C1 vcx VSS 1p
C2 VX vco 1p
M1 vci phi1 vcx VSS nch l=0.15 w=1 nf=1 m=1
M10 VY VX VDD VDD pch l=0.15 w=1 nf=1 m=1
M11 VY VY VSS VSS nch l=0.15 w=1 nf=1 m=1
M12 VB1 VB3 VDD VDD pch l=0.15 w=1 nf=1 m=1
M13 VB1 VB1 VSS VSS nch l=0.15 w=1 nf=1 m=1
M14 VB3 VB3 VDD VDD pch l=0.15 w=1 nf=1 m=1
M15 VB3 VB1 VZ VSS nch l=0.15 w=1 nf=1 m=1
M16 VZ net1 VSS VSS nch l=0.15 w=1 nf=1 m=1
M17 net1 VB3 VDD VDD pch l=0.15 w=1 nf=1 m=1
M18 net1 net1 VSS VSS nch l=0.15 w=1 nf=1 m=1
M19 VB2 VB3 VDD VDD pch l=0.15 w=1 nf=1 m=1
M2 vcx phi2 VX VSS nch l=0.15 w=1 nf=1 m=1
M20 VB2 VB2 VSS VSS nch l=0.15 w=1 nf=1 m=1
M3 VX VX VZ VSS nch l=0.15 w=1 nf=1 m=1
M4 net0 VSS VZ VSS nch l=0.15 w=1 nf=1 m=1
M5 VZ VB2 VSS VSS nch l=0.15 w=1 nf=1 m=1
M6 VX net2 VDD VDD pch l=0.15 w=1 nf=1 m=1
M7 net0 net2 VDD VDD pch l=0.15 w=1 nf=1 m=1
M8 vco net0 VDD VDD pch l=0.15 w=1 nf=1 m=1
M9 vco VY VSS VSS nch l=0.15 w=1 nf=1 m=1
.ends dut
