* official Analog Canvas netlist; PDK X cards rewritten by convert.py
.model nch nmos
.model pch pmos

.subckt AEA VDD VSS VREF OUT VBN
M10 net2 VREF net0 VSS nch l=0.15 w=1 nf=1 m=1
M11 net1 OUT net0 VSS nch l=0.15 w=1 nf=1 m=1
M12 net0 VBN VSS VSS nch l=0.15 w=1 nf=1 m=1
M4 net2 net2 VDD VDD pch l=0.15 w=1 nf=1 m=1
M5 OUT net2 VDD VDD pch l=0.15 w=1 nf=1 m=1
M6 OUT net1 VDD VDD pch l=0.15 w=1 nf=1 m=1
M7 net1 net1 VDD VDD pch l=0.15 w=1 nf=1 m=1
M8 OUT OUT VSS VSS nch l=0.15 w=1 nf=1 m=1
M9 OUT OUT VSS VSS nch l=0.15 w=1 nf=1 m=1
.ends AEA

.subckt Bias VDD VSS VB2 VB1 VBN
M13 VB2 VB2 VDD VDD pch l=0.15 w=1 nf=1 m=1
M14 net1 VB2 VDD VDD pch l=0.15 w=1 nf=1 m=1
M15 net2 net2 VDD VDD pch l=0.15 w=1 nf=1 m=1
M16 VBN net2 VDD VDD pch l=0.15 w=1 nf=1 m=1
M17 VB1 VB1 VDD VDD pch l=0.15 w=1 nf=1 m=1
M18 VB2 net1 net0 VSS nch l=0.15 w=1 nf=1 m=1
M19 net1 net1 VSS VSS nch l=0.15 w=1 nf=1 m=1
M20 net2 net1 VSS VSS nch l=0.15 w=1 nf=1 m=1
M21 VBN VBN VSS VSS nch l=0.15 w=1 nf=1 m=1
M22 VB1 VBN VSS VSS nch l=0.15 w=1 nf=1 m=1
R1 net0 VSS 1k
.ends Bias

.subckt dut VDD VSS VIN VOUT VERR pb nb VREF VB1 VB2
M1 net5 net2 VIN VDD pch l=0.15 w=1 nf=1 m=1
M2 net1 net1 net5 VDD pch l=0.15 w=1 nf=1 m=1
M3 net1 nb VSS VSS nch l=0.15 w=1 nf=1 m=1
MBIAS VERR nb VSS VSS nch l=0.15 w=1 nf=1 m=1
MCHG net4 pb VIN VDD pch l=0.15 w=1 nf=1 m=1
MCTRL VERR net1 VOUT VDD pch l=0.15 w=1 nf=1 m=1
MGEN net3 net3 VSS VSS nch l=0.15 w=1 nf=1 m=1
MINJ VERR net3 VSS VSS nch l=0.15 w=1 nf=1 m=1
MRES VOUT VERR VIN VDD pch l=0.15 w=1 nf=1 m=1
MSEN net3 net2 net4 VDD pch l=0.15 w=1 nf=1 m=1
X1 VDD VSS VREF net2 net0 AEA
X2 VDD VSS VB2 VB1 net0 Bias
.ends dut
