* official Analog Canvas netlist; PDK X cards rewritten by convert.py
.model nch nmos
.model pch pmos

.subckt dut VDD VSS vci phi1 phi2 vco
C1 net6 net3 1p
C2 net2 vco 1p
M1 vci phi1 net6 VSS nch l=0.15 w=1 nf=1 m=1
M10 VB2 net4 VDD VDD pch l=0.15 w=1 nf=1 m=1
M11 net4 net4 VDD VDD pch l=0.15 w=1 nf=1 m=1
M12 VB3 net4 VDD VDD pch l=0.15 w=1 nf=1 m=1
M13 net0 VB2 VSS VSS nch l=0.15 w=1 nf=1 m=1
M14 net4 VB2 VSS VSS nch l=0.15 w=1 nf=1 m=1
M15 VB3 VB3 VSS VSS nch l=0.15 w=1 nf=1 m=1
M2 net6 phi2 VSS VSS nch l=0.15 w=1 nf=1 m=1
M3 net3 phi1 VSS VSS nch l=0.15 w=1 nf=1 m=1
M4 net3 phi2 net2 VSS nch l=0.15 w=1 nf=1 m=1
M5 net1 net2 net5 VSS nch l=0.15 w=1 nf=1 m=1
M6 vco VSS net5 VSS nch l=0.15 w=1 nf=1 m=1
M7 net5 VB3 VSS VSS nch l=0.15 w=1 nf=1 m=1
M8 net1 net1 VDD VDD pch l=0.15 w=1 nf=1 m=1
M9 vco net1 VDD VDD pch l=0.15 w=1 nf=1 m=1
R1 VB2 net0 1k
.ends dut
