* official Analog Canvas netlist; PDK X cards rewritten by convert.py
.model nch nmos
.model pch pmos
.model qpnp pnp

.global VDD

.subckt opamp VSS VB1 INN INP VB2 OUT
M1 net2 VB1 VDD VDD pch l=0.15 w=1 nf=1 m=1
M10 net3 VB5 VSS VSS nch l=0.15 w=1 nf=1 m=1
M11 net1 VB5 VSS VSS nch l=0.15 w=1 nf=1 m=1
M12 VB3 net4 VDD VDD pch l=0.15 w=1 nf=1 m=1
M13 VB3 VB3 VSS VSS nch l=0.15 w=1 nf=1 m=1
M14 net4 net4 VDD VDD pch l=0.15 w=1 nf=1 m=1
M15 net4 VB3 net6 VSS nch l=0.15 w=1 nf=1 m=1
M16 VB4 net4 VDD VDD pch l=0.15 w=1 nf=1 m=1
M17 VB4 VB4 VB5 VSS nch l=0.15 w=1 nf=1 m=1
M18 VB5 VB5 VSS VSS nch l=0.15 w=1 nf=1 m=1
M2 net1 INN net2 VDD pch l=0.15 w=1 nf=1 m=1
M3 net3 INP net2 VDD pch l=0.15 w=1 nf=1 m=1
M4 net7 net0 VDD VDD pch l=0.15 w=1 nf=1 m=1
M5 net5 net0 VDD VDD pch l=0.15 w=1 nf=1 m=1
M6 net0 VB2 net7 VDD pch l=0.15 w=1 nf=1 m=1
M7 OUT VB2 net5 VDD pch l=0.15 w=1 nf=1 m=1
M8 net0 VB4 net3 VSS nch l=0.15 w=1 nf=1 m=1
M9 OUT VB4 net1 VSS nch l=0.15 w=1 nf=1 m=1
R1 net6 VSS 1k
.ends opamp

.subckt dut VSS Vout VB1 VB2
Q1 VSS VSS X qpnp m=1
Q2 VSS VSS net0 qpnp m=1
R1 Vout X 1k
R2 Vout Y 1k
R3 Y net0 1k
X1 VSS VB1 Y X VB2 Vout opamp
.ends dut
