* official Analog Canvas netlist; PDK X cards rewritten by convert.py
.model nch nmos
.model pch pmos

.subckt dut VDD VSS vip vim Vo VB
C1 net1 Vo 5pF
I1 net3 VSS DC 20uA
M1 net0 vip net2 VDD pch l=0.15 w=1 nf=1 m=1
M2 net4 vim net2 VDD pch l=0.15 w=1 nf=1 m=1
M3 net0 net0 VSS VSS nch l=0.15 w=1 nf=1 m=1
M4 net4 net0 VSS VSS nch l=0.15 w=1 nf=1 m=1
M5 net2 net3 VDD VDD pch l=0.15 w=1 nf=1 m=1
M6 Vo net4 VSS VSS nch l=0.15 w=1 nf=1 m=1
M7 Vo net3 VDD VDD pch l=0.15 w=1 nf=1 m=1
M8 net3 net3 VDD VDD pch l=0.15 w=1 nf=1 m=1
M9 net1 VB net4 VSS nch l=0.15 w=1 nf=1 m=1
.ends dut
