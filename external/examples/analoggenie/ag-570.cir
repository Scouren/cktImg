* official Analog Canvas netlist; PDK X cards rewritten by convert.py
.model nch nmos

.subckt dut VDD VSS Vinp Vinn Voutp Voutn
C1 Voutp net1 1p
C2 Voutn net4 1p
I1 VDD net0 DC 1m
M1 net3 net1 VSS VSS nch l=0.15 w=1 nf=1 m=1
M2 net2 net4 VSS VSS nch l=0.15 w=1 nf=1 m=1
M3 Voutp Vinp net2 VSS nch l=0.15 w=1 nf=1 m=1
M4 Voutn Vinn net2 VSS nch l=0.15 w=1 nf=1 m=1
M5 Voutn Vinp net3 VSS nch l=0.15 w=1 nf=1 m=1
M6 Voutp Vinn net3 VSS nch l=0.15 w=1 nf=1 m=1
M7 net0 net0 VSS VSS nch l=0.15 w=1 nf=1 m=1
RB1 net4 net0 1k
RB2 net1 net0 1k
RD1 VDD Voutp 1k
RD2 VDD Voutn 1k
.ends dut
