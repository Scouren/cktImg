* official Analog Canvas netlist; PDK X cards rewritten by convert.py
.model nch nmos
.model pch pmos

.subckt opamp VDD VSS INN INP OUT
M10 net1 VBN VSS VSS nch l=0.15 w=1 nf=1 m=1
M11 OUT VX VSS VSS nch l=0.15 w=1 nf=1 m=1
M12 VA VA VDD VDD pch l=0.15 w=1 nf=1 m=1
M13 VB3 VA VDD VDD pch l=0.15 w=1 nf=1 m=1
M14 VBN VA VDD VDD pch l=0.15 w=1 nf=1 m=1
M15 net2 VA VDD VDD pch l=0.15 w=1 nf=1 m=1
M16 VBP VBP VDD VDD pch l=0.15 w=1 nf=1 m=1
M17 VB1 VBP VDD VDD pch l=0.15 w=1 nf=1 m=1
M18 VA VB3 VB2 VSS nch l=0.15 w=1 nf=1 m=1
M19 VB2 VBN VSS VSS nch l=0.15 w=1 nf=1 m=1
M20 VB3 VB2 VSS VSS nch l=0.15 w=1 nf=1 m=1
M21 VBN VBN VSS VSS nch l=0.15 w=1 nf=1 m=1
M22 net2 net2 VSS VSS nch l=0.15 w=1 nf=1 m=1
M23 VBP net2 VSS VSS nch l=0.15 w=1 nf=1 m=1
M24 VB1 VB1 VSS VSS nch l=0.15 w=1 nf=1 m=1
M3 net0 VBP VDD VDD pch l=0.15 w=1 nf=1 m=1
M4 VX INN net0 VDD pch l=0.15 w=1 nf=1 m=1
M5 VBN INP net0 VDD pch l=0.15 w=1 nf=1 m=1
M6 VX VX VSS VSS nch l=0.15 w=1 nf=1 m=1
M7 VBN VBN VSS VSS nch l=0.15 w=1 nf=1 m=1
M8 net1 net1 VDD VDD pch l=0.15 w=1 nf=1 m=1
M9 OUT net1 VDD VDD pch l=0.15 w=1 nf=1 m=1
.ends opamp

.subckt dut VDD VSS vci phi1 phi2 vco
C1 vcx VSS 1p
C2 net0 vco 1p
M1 vci phi1 vcx VSS nch l=0.15 w=1 nf=1 m=1
M2 vcx phi2 net0 VSS nch l=0.15 w=1 nf=1 m=1
X1 VDD VSS net0 VSS vco opamp
.ends dut
