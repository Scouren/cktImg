* official Analog Canvas netlist; PDK X cards rewritten by convert.py
.model nch nmos
.model pch pmos
.model qpnp pnp

.subckt dut VDD VSS
M1 net2 net9 VDD VDD pch l=0.15 w=1 nf=1 m=1
M2 net10 net9 VDD VDD pch l=0.15 w=1 nf=1 m=1
M3 net9 net0 net2 VDD pch l=0.15 w=1 nf=1 m=1
M4 net4 net0 net10 VDD pch l=0.15 w=1 nf=1 m=1
M5 net0 net4 net1 VSS nch l=0.15 w=1 nf=1 m=1
M6 net5 net4 net8 VSS nch l=0.15 w=1 nf=1 m=1
M7 net1 net5 net3 VSS nch l=0.15 w=1 nf=1 m=1
M8 net8 net5 net6 VSS nch l=0.15 w=1 nf=1 m=1
Q1 VSS VSS net7 qpnp m=1
Q2 VSS VSS net6 qpnp m=1
R1 net3 net7 1k
R2 net9 net0 1k
R3 net4 net5 1k
.ends dut
