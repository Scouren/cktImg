* official Analog Canvas netlist; PDK X cards rewritten by convert.py
.model nch nmos
.model pch pmos

.subckt dut VDD VSS VIN VP VS5 VS1 VS2 VS4 VS3 VB2 VREF
.model DIODE D(IS=1e-14 N=1)
CFLY VX1 VX2 1p
CO VP VN 1p
COP VP VSS 1p
D1 VN VX2 DIODE
L1 VX1 VX3 1n
M1 VX1 net2 net4 net4 pch l=0.15 w=1 nf=1 m=1
M10 VX2 VX2 VSS VSS nch l=0.15 w=1 nf=1 m=1
M11 net3 net3 VSS VSS nch l=0.15 w=1 nf=1 m=1
M12 net8 VX2 VSS VSS nch l=0.15 w=1 nf=1 m=1
M13 VCTRL net3 VSS VSS nch l=0.15 w=1 nf=1 m=1
M14 net8 net8 VDD VDD pch l=0.15 w=1 nf=1 m=1
M15 VCTRL net8 VDD VDD pch l=0.15 w=1 nf=1 m=1
M16 net7 net7 VDD VDD pch l=0.15 w=1 nf=1 m=1
M17 net0 net7 VDD VDD pch l=0.15 w=1 nf=1 m=1
M18 net0 net0 VSS VSS nch l=0.15 w=1 nf=1 m=1
M19 VBP net0 VSS VSS nch l=0.15 w=1 nf=1 m=1
M2 net2 net2 net4 net4 pch l=0.15 w=1 nf=1 m=1
M20 VBP VBP VDD VDD pch l=0.15 w=1 nf=1 m=1
M21 VIN VS5 net4 VIN pch l=0.15 w=1 nf=1 m=1
M22 VX1 VS1 VIN VIN pch l=0.15 w=1 nf=1 m=1
M23 VX2 VS2 VIN VIN pch l=0.15 w=1 nf=1 m=1
M24 VX3 VS4 VSS VSS nch l=0.15 w=1 nf=1 m=1
M25 VP VS3 VX3 VP pch l=0.15 w=1 nf=1 m=1
M3 net5 VCTRL net4 net4 pch l=0.15 w=1 nf=1 m=1
M4 net5 net5 VSS VSS nch l=0.15 w=1 nf=1 m=1
M5 net2 net5 VSS VSS nch l=0.15 w=1 nf=1 m=1
M6 net5 VB2 VSS VSS nch l=0.15 w=1 nf=1 m=1
M7 net6 VBP VDD VDD pch l=0.15 w=1 nf=1 m=1
M8 VX2 VREF net6 net1 pch l=0.15 w=1 nf=1 m=1
M9 net3 VFP1 net6 net1 pch l=0.15 w=1 nf=1 m=1
R1 VP VFP1 1k
R2 VFP1 VSS 1k
RBIAS net7 VSS 1k
.ends dut
