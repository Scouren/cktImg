* official Analog Canvas netlist; PDK X cards rewritten by convert.py
.model nch nmos
.model pch pmos

.subckt dut VDD VSS VB1 VREF VB5 VB2 VB4 VOUT VIN
CF1 VOUT VFB 1p
Cm1 VOUT VO1 1p
Cm2 VO1 net5 1p
M11 net0 VB1 VIN VDD pch l=0.15 w=1 nf=1 m=1
M12 net4 VFB net0 VDD pch l=0.15 w=1 nf=1 m=1
M13 net8 VREF net0 VDD pch l=0.15 w=1 nf=1 m=1
M14 net4 VN1 VSS VSS nch l=0.15 w=1 nf=1 m=1
M15 net8 VN1 VSS VSS nch l=0.15 w=1 nf=1 m=1
M16 VG VB5 VIN VDD pch l=0.15 w=1 nf=1 m=1
M17 VG VO1 VSS VSS nch l=0.15 w=1 nf=1 m=1
M18 VG VG VSS VSS nch l=0.15 w=1 nf=1 m=1
M21 net10 VO1 VSS VSS nch l=0.15 w=1 nf=1 m=1
M22 net1 VG VSS VSS nch l=0.15 w=1 nf=1 m=1
M23 net10 net10 VIN VDD pch l=0.15 w=1 nf=1 m=1
M24 net1 net10 VIN VDD pch l=0.15 w=1 nf=1 m=1
M25 VX VC1 net4 VSS nch l=0.15 w=1 nf=1 m=1
M26 VO1 VC1 net8 VSS nch l=0.15 w=1 nf=1 m=1
M27 VX VB6 VY VDD pch l=0.15 w=1 nf=1 m=1
M28 VO1 VB6 net3 VDD pch l=0.15 w=1 nf=1 m=1
M29 VY VX VIN VDD pch l=0.15 w=1 nf=1 m=1
M30 net3 VX VIN VDD pch l=0.15 w=1 nf=1 m=1
MB1 VC1 VP1 VIN VDD pch l=0.15 w=1 nf=1 m=1
MB10 net2 net2 VSS VSS nch l=0.15 w=1 nf=1 m=1
MB2 VC1 VC1 VN1 VSS nch l=0.15 w=1 nf=1 m=1
MB3 VN1 VN1 VSS VSS nch l=0.15 w=1 nf=1 m=1
MB4 net11 VP1 VIN VDD pch l=0.15 w=1 nf=1 m=1
MB5 net11 net11 VSS VSS nch l=0.15 w=1 nf=1 m=1
MB6 VP1 VP1 VIN VDD pch l=0.15 w=1 nf=1 m=1
MB7 VP1 net2 net6 VSS nch l=0.15 w=1 nf=1 m=1
MB8 net6 net11 VSS VSS nch l=0.15 w=1 nf=1 m=1
MB9 net2 VP1 VIN VDD pch l=0.15 w=1 nf=1 m=1
MD1 net5 VO1 VSS VSS nch l=0.15 w=1 nf=1 m=1
MD2 VY VB2 VSS VSS nch l=0.15 w=1 nf=1 m=1
MD3 net7 net5 VY VSS nch l=0.15 w=1 nf=1 m=1
MD4 net9 VB4 VY VSS nch l=0.15 w=1 nf=1 m=1
MD5 net5 net9 VIN VDD pch l=0.15 w=1 nf=1 m=1
MD6 net9 net9 VIN VDD pch l=0.15 w=1 nf=1 m=1
MD7 net7 net7 VIN VDD pch l=0.15 w=1 nf=1 m=1
MPT VOUT net1 VIN VDD pch l=0.15 w=1 nf=1 m=1
RF1 VOUT VFB 1k
RF2 VFB VSS 1k
.ends dut
