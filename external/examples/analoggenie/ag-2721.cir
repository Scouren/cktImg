* official Analog Canvas netlist; PDK X cards rewritten by convert.py
.model nch nmos
.model pch pmos

.subckt dut VDD VSS vci phi1 phi2 vco
C1 vcx VSS 1p
C2 net4 vco 1p
M1 vci phi1 vcx VSS nch l=0.15 w=1 nf=1 m=1
M10 VB5 VB5 VSS VSS nch l=0.15 w=1 nf=1 m=1
M11 vco VB5 VSS VSS nch l=0.15 w=1 nf=1 m=1
M12 net1 VB4 VDD VDD pch l=0.15 w=1 nf=1 m=1
M13 net1 net1 VSS VSS nch l=0.15 w=1 nf=1 m=1
M14 VB4 VB4 VDD VDD pch l=0.15 w=1 nf=1 m=1
M15 VB4 VB2 net0 VSS nch l=0.15 w=1 nf=1 m=1
M16 net0 net1 VSS VSS nch l=0.15 w=1 nf=1 m=1
M17 VB2 VB4 VDD VDD pch l=0.15 w=1 nf=1 m=1
M18 VB2 VB2 VSS VSS nch l=0.15 w=1 nf=1 m=1
M19 VB3 VB4 VDD VDD pch l=0.15 w=1 nf=1 m=1
M2 vcx phi2 net4 VSS nch l=0.15 w=1 nf=1 m=1
M20 VB3 VB3 VSS VSS nch l=0.15 w=1 nf=1 m=1
M21 VB1 VB1 VDD VDD pch l=0.15 w=1 nf=1 m=1
M22 VB1 VB3 VSS VSS nch l=0.15 w=1 nf=1 m=1
M3 vcx net4 net3 VSS nch l=0.15 w=1 nf=1 m=1
M4 net2 VSS net3 VSS nch l=0.15 w=1 nf=1 m=1
M5 net3 VB3 VSS VSS nch l=0.15 w=1 nf=1 m=1
M6 vcx vcx VDD VDD pch l=0.15 w=1 nf=1 m=1
M7 net2 net2 VDD VDD pch l=0.15 w=1 nf=1 m=1
M8 vco net2 VDD VDD pch l=0.15 w=1 nf=1 m=1
M9 VB5 vcx VDD VDD pch l=0.15 w=1 nf=1 m=1
.ends dut
