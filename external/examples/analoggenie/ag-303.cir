* official Analog Canvas netlist; PDK X cards rewritten by convert.py
.model nch nmos
.model pch pmos

.subckt dut VDD VSS Vb Vin Vout
I1 net0 VSS DC 1m
I2 VDD Vout DC 1m
I3 VDD G DC 1m
M1 P Vin VSS VSS nch l=0.15 w=1 nf=1 m=1
M2 Vout G P VSS nch l=0.15 w=1 nf=1 m=1
M3 net0 P VDD VDD pch l=0.15 w=1 nf=1 m=1
M4 G Vb net0 VSS nch l=0.15 w=1 nf=1 m=1
.ends dut
