* official Analog Canvas netlist; PDK X cards rewritten by convert.py
.model nch nmos

.subckt dut VDD VSS VOUT1 VB1 VIN1
LLOAD VDD VOUT1 1n
M1 net1 VIN1 VSS VSS nch l=0.15 w=1 nf=1 m=1
M2 VDD VOUT1 net0 VSS nch l=0.15 w=1 nf=1 m=1
M3 VOUT1 VDD net1 VSS nch l=0.15 w=1 nf=1 m=1
M4 net0 VB1 VSS VSS nch l=0.15 w=1 nf=1 m=1
RF net0 VIN1 1k
.ends dut
