* official Analog Canvas netlist; PDK X cards rewritten by convert.py
.model qnpn npn

.subckt dut VCC VSS vi+ Iout1 vi- Iout2
I1 VCC net1 DC 1m
I2 net3 VSS DC 1m
I3 VCC net0 DC 1m
I4 net4 VSS DC 1m
Q1 net1 vi+ net2 VSS qnpn m=1
Q2 net0 vi- net5 VSS qnpn m=1
Q3 net2 net3 VSS VSS qnpn m=1
Q4 net5 net4 VSS VSS qnpn m=1
Q5 VCC net1 net3 VSS qnpn m=1
Q6 VCC net0 net4 VSS qnpn m=1
Q7 Iout1 net3 VSS VSS qnpn m=1
Q8 Iout2 net4 VSS VSS qnpn m=1
RS net2 net5 1k
.ends dut
