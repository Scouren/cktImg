* official Analog Canvas netlist; PDK X cards rewritten by convert.py
.model nch nmos
.model pch pmos

.subckt dut VDD VSS Vin+ Vin- Latch_bar Vout+ Vout-
I1 net0 VSS DC 1m
I2 VDD Vout- DC 1m
I3 VDD Vout+ DC 1m
I4 net1 VSS DC 1m
M1 net2 Vin+ net0 VSS nch l=0.15 w=1 nf=1 m=1
M10 VY VX VSS VSS nch l=0.15 w=1 nf=1 m=1
M11 VY Latch_bar VSS VSS nch l=0.15 w=1 nf=1 m=1
M12 VX Latch_bar VSS VSS nch l=0.15 w=1 nf=1 m=1
M13 Vout- VY VSS VSS nch l=0.15 w=1 nf=1 m=1
M14 Vout+ VX VSS VSS nch l=0.15 w=1 nf=1 m=1
M15 Vout+ net1 VDD VDD pch l=0.15 w=1 nf=1 m=1
M16 Vout- net1 VDD VDD pch l=0.15 w=1 nf=1 m=1
M17 net1 Latch_bar VDD VDD pch l=0.15 w=1 nf=1 m=1
M18 net1 net1 VDD VDD pch l=0.15 w=1 nf=1 m=1
M2 net3 Vin- net0 VSS nch l=0.15 w=1 nf=1 m=1
M3 net2 net2 VDD VDD pch l=0.15 w=1 nf=1 m=1
M4 VY net2 VDD VDD pch l=0.15 w=1 nf=1 m=1
M5 net3 net3 VDD VDD pch l=0.15 w=1 nf=1 m=1
M6 VX net3 VDD VDD pch l=0.15 w=1 nf=1 m=1
M7 VX VX VSS VSS nch l=0.15 w=1 nf=1 m=1
M8 VY VY VSS VSS nch l=0.15 w=1 nf=1 m=1
M9 VX VY VSS VSS nch l=0.15 w=1 nf=1 m=1
.ends dut
