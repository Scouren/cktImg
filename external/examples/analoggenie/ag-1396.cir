* official Analog Canvas netlist; PDK X cards rewritten by convert.py
.model nch nmos
.model pch pmos

.subckt comp VDD VSS INN OUT VB4 VB5
M1 net0 VB1 VDD VDD pch l=0.15 w=1 nf=1 m=1
M10 net3 VB5 VSS VSS nch l=0.15 w=1 nf=1 m=1
M11 net1 VB5 VSS VSS nch l=0.15 w=1 nf=1 m=1
M2 net3 INN net0 VDD pch l=0.15 w=1 nf=1 m=1
M3 net1 OUT net0 VDD pch l=0.15 w=1 nf=1 m=1
M4 net5 net4 VDD VDD pch l=0.15 w=1 nf=1 m=1
M5 net2 net4 VDD VDD pch l=0.15 w=1 nf=1 m=1
M6 OUT VB2 net5 VDD pch l=0.15 w=1 nf=1 m=1
M7 net4 VB2 net2 VDD pch l=0.15 w=1 nf=1 m=1
M8 OUT VB4 net3 VSS nch l=0.15 w=1 nf=1 m=1
M9 net4 VB4 net1 VSS nch l=0.15 w=1 nf=1 m=1
.ends comp

.subckt bias VDD VSS VB4 VB5
M12 VB3 VP VDD VDD pch l=0.15 w=1 nf=1 m=1
M13 VP VP VDD VDD pch l=0.15 w=1 nf=1 m=1
M14 VP net3 VSS VSS nch l=0.15 w=1 nf=1 m=1
M15 net0 VP VDD VDD pch l=0.15 w=1 nf=1 m=1
M16 net0 net0 net3 VSS nch l=0.15 w=1 nf=1 m=1
M17 net3 net0 net2 VSS nch l=0.15 w=1 nf=1 m=1
M18 net2 net1 VB3 VSS nch l=0.15 w=1 nf=1 m=1
M19 VB3 VB3 VSS VSS nch l=0.15 w=1 nf=1 m=1
M20 net1 VP VDD VDD pch l=0.15 w=1 nf=1 m=1
M21 net1 net1 net2 VSS nch l=0.15 w=1 nf=1 m=1
M22 VB4 VP VDD VDD pch l=0.15 w=1 nf=1 m=1
M23 VB4 VB4 VB5 VSS nch l=0.15 w=1 nf=1 m=1
M24 VB5 VB5 VSS VSS nch l=0.15 w=1 nf=1 m=1
.ends bias

.subckt dut VDD VSS VSTO VCONT1 VCONT2 VCONT3 VOUT
CL VOUT VSS 1p
CSTO VSTO VSS 1p
LRX net3 net1 1n
MN1 net3 VCONT2 VSS VSS nch l=0.15 w=1 nf=1 m=1
MN2 net1 VCONT3 VSS VSS nch l=0.15 w=1 nf=1 m=1
MP2 net1 net2 VOUT VDD pch l=0.15 w=1 nf=1 m=1
MP3 net3 VCONT1 VSTO VDD pch l=0.15 w=1 nf=1 m=1
X1 VDD VSS net1 net2 net0 net4 comp
X2 VDD VSS net0 net4 bias
.ends dut
