* official Analog Canvas netlist; PDK X cards rewritten by convert.py
.model nch nmos
.model pch pmos

.subckt opamp VDD VSS INP INN OUT
M10 VX VB2 net0 VDD pch l=0.15 w=1 nf=1 m=1
M11 OUT VB2 net1 VDD pch l=0.15 w=1 nf=1 m=1
M12 VX VB4 net3 VSS nch l=0.15 w=1 nf=1 m=1
M13 OUT VB4 net4 VSS nch l=0.15 w=1 nf=1 m=1
M14 net3 VB5 VSS VSS nch l=0.15 w=1 nf=1 m=1
M15 net4 VB5 VSS VSS nch l=0.15 w=1 nf=1 m=1
M16 VT net2 VDD VDD pch l=0.15 w=1 nf=1 m=1
M17 net2 net2 VDD VDD pch l=0.15 w=1 nf=1 m=1
M18 VT VB3 VSS VSS nch l=0.15 w=1 nf=1 m=1
M19 net2 VT VB3 VSS nch l=0.15 w=1 nf=1 m=1
M20 VB4 net2 VDD VDD pch l=0.15 w=1 nf=1 m=1
M21 VB4 VB4 VB5 VSS nch l=0.15 w=1 nf=1 m=1
M22 VB5 VB5 VSS VSS nch l=0.15 w=1 nf=1 m=1
M5 VT VB1 VDD VDD pch l=0.15 w=1 nf=1 m=1
M6 net3 INP VT VDD pch l=0.15 w=1 nf=1 m=1
M7 net4 INN VT VDD pch l=0.15 w=1 nf=1 m=1
M8 net0 VX VDD VDD pch l=0.15 w=1 nf=1 m=1
M9 net1 VX VDD VDD pch l=0.15 w=1 nf=1 m=1
R1 VB3 VSS 1k
.ends opamp

.subckt dut VDD VSS vci phi1 phi2 vco
C1 net2 net0 1p
C2 net1 vco 1p
M1 vci phi1 net2 VSS nch l=0.15 w=1 nf=1 m=1
M2 net2 phi2 VSS VSS nch l=0.15 w=1 nf=1 m=1
M3 net0 phi1 VSS VSS nch l=0.15 w=1 nf=1 m=1
M4 net0 phi2 net1 VSS nch l=0.15 w=1 nf=1 m=1
X1 VDD VSS VSS net1 vco opamp
.ends dut
