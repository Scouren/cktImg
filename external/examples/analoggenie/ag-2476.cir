* official Analog Canvas netlist; PDK X cards rewritten by convert.py
.model nch nmos
.model pch pmos

.subckt dut VDD VSS VB1 VB2 VREF VB6 VB5 VIN VB3 VB4 VOUT
CF1 VOUT VFB 1p
Cm1 V1 VOUT 1p
Cm2 V1 net9 1p
M1 VX VB1 VIN VDD pch l=0.15 w=1 nf=1 m=1
M10 VP VP VIN VDD pch l=0.15 w=1 nf=1 m=1
M11 net10 VT1 VSS VSS nch l=0.15 w=1 nf=1 m=1
M12 net1 VFB net10 VSS nch l=0.15 w=1 nf=1 m=1
M13 VX VREF net10 VSS nch l=0.15 w=1 nf=1 m=1
M14 net11 net5 VSS VSS nch l=0.15 w=1 nf=1 m=1
M15 net3 net5 VSS VSS nch l=0.15 w=1 nf=1 m=1
M16 VA VB4 VIN VDD pch l=0.15 w=1 nf=1 m=1
M17 VA V1 VSS VSS nch l=0.15 w=1 nf=1 m=1
M18 VA VA VSS VSS nch l=0.15 w=1 nf=1 m=1
M19 net4 VP VIN VDD pch l=0.15 w=1 nf=1 m=1
M2 net1 VB1 VIN VDD pch l=0.15 w=1 nf=1 m=1
M20 VP VB3 net6 VSS nch l=0.15 w=1 nf=1 m=1
M21 net7 V1 VSS VSS nch l=0.15 w=1 nf=1 m=1
M22 net0 VA VSS VSS nch l=0.15 w=1 nf=1 m=1
M23 net7 net7 VIN VDD pch l=0.15 w=1 nf=1 m=1
M24 net0 net7 VIN VDD pch l=0.15 w=1 nf=1 m=1
M25 net6 net4 VSS VSS nch l=0.15 w=1 nf=1 m=1
M26 net4 net4 VSS VSS nch l=0.15 w=1 nf=1 m=1
M27 VB3 VP VIN VDD pch l=0.15 w=1 nf=1 m=1
M28 VB3 VB3 VSS VSS nch l=0.15 w=1 nf=1 m=1
M3 net5 VB2 VX VDD pch l=0.15 w=1 nf=1 m=1
M4 V1 VB2 net1 VDD pch l=0.15 w=1 nf=1 m=1
M5 net5 VC1 net11 VSS nch l=0.15 w=1 nf=1 m=1
M6 V1 VC1 net3 VSS nch l=0.15 w=1 nf=1 m=1
M7 VT1 VT1 VSS VSS nch l=0.15 w=1 nf=1 m=1
M8 VC1 VC1 VT1 VSS nch l=0.15 w=1 nf=1 m=1
M9 VC1 VP VIN VDD pch l=0.15 w=1 nf=1 m=1
MD1 net9 V1 VSS VSS nch l=0.15 w=1 nf=1 m=1
MD2 net2 VB5 VSS VSS nch l=0.15 w=1 nf=1 m=1
MD3 VX net9 net2 VSS nch l=0.15 w=1 nf=1 m=1
MD4 net8 VB6 net2 VSS nch l=0.15 w=1 nf=1 m=1
MD5 net9 net8 VIN VDD pch l=0.15 w=1 nf=1 m=1
MD6 net8 net8 VIN VDD pch l=0.15 w=1 nf=1 m=1
MD7 VX VX VIN VDD pch l=0.15 w=1 nf=1 m=1
MPT VOUT net0 VIN VDD pch l=0.15 w=1 nf=1 m=1
RF1 VOUT VFB 1k
RF2 VFB VSS 1k
.ends dut
