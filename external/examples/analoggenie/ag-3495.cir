* official Analog Canvas netlist; PDK X cards rewritten by convert.py
.model nch nmos
.model pch pmos

.global VDD

.subckt Comparator VSS vn vp vo phi3
M28 net2 phi3 VDD VDD pch l=0.15 w=1 nf=1 m=1
M29 net3 phi3 VDD VDD pch l=0.15 w=1 nf=1 m=1
M30 net0 phi3 VDD VDD pch l=0.15 w=1 nf=1 m=1
M31 net0 vo VDD VDD pch l=0.15 w=1 nf=1 m=1
M32 vo net0 VDD VDD pch l=0.15 w=1 nf=1 m=1
M33 vo phi3 VDD VDD pch l=0.15 w=1 nf=1 m=1
M34 net0 vo net2 VSS nch l=0.15 w=1 nf=1 m=1
M35 vo net0 net3 VSS nch l=0.15 w=1 nf=1 m=1
M36 net2 vp net1 VSS nch l=0.15 w=1 nf=1 m=1
M37 net3 vn net1 VSS nch l=0.15 w=1 nf=1 m=1
M38 net1 phi3 VSS VSS nch l=0.15 w=1 nf=1 m=1
.ends Comparator

.subckt Opamp VSS vp vn vo
M10 vo net6 VSS VSS nch l=0.15 w=1 nf=1 m=1
M11 net8 net0 VSS VSS nch l=0.15 w=1 nf=1 m=1
M12 net8 net8 VDD VDD pch l=0.15 w=1 nf=1 m=1
M13 vo net8 VDD VDD pch l=0.15 w=1 nf=1 m=1
M14 net2 VB2 VDD VDD pch l=0.15 w=1 nf=1 m=1
M15 net2 net2 net4 VSS nch l=0.15 w=1 nf=1 m=1
M16 net4 net2 net1 VSS nch l=0.15 w=1 nf=1 m=1
M17 net5 VB2 VDD VDD pch l=0.15 w=1 nf=1 m=1
M18 net5 net5 net3 VSS nch l=0.15 w=1 nf=1 m=1
M19 net3 net5 net4 VSS nch l=0.15 w=1 nf=1 m=1
M20 VB2 VB2 VDD VDD pch l=0.15 w=1 nf=1 m=1
M21 VB2 net3 VSS VSS nch l=0.15 w=1 nf=1 m=1
M22 net1 VB2 VDD VDD pch l=0.15 w=1 nf=1 m=1
M23 net1 net1 VSS VSS nch l=0.15 w=1 nf=1 m=1
M24 VB3 VB3 VDD VDD pch l=0.15 w=1 nf=1 m=1
M25 VB3 net1 VSS VSS nch l=0.15 w=1 nf=1 m=1
M26 VB1 VB3 VDD VDD pch l=0.15 w=1 nf=1 m=1
M27 VB1 VB1 VSS VSS nch l=0.15 w=1 nf=1 m=1
M5 net7 VB3 VDD VDD pch l=0.15 w=1 nf=1 m=1
M6 net6 vn net7 net9 pch l=0.15 w=1 nf=1 m=1
M7 net0 vp net7 net9 pch l=0.15 w=1 nf=1 m=1
M8 net6 net6 VSS VSS nch l=0.15 w=1 nf=1 m=1
M9 net0 net0 VSS VSS nch l=0.15 w=1 nf=1 m=1
.ends Opamp

.subckt dut VSS phi2 phi1 vout phi3
C1 net1 net2 1p
C2 net0 vout 1p
C3 net0 vx 1p
M1 net0 phi2 net1 VSS nch l=0.15 w=1 nf=1 m=1
M2 net1 phi1 VSS VSS nch l=0.15 w=1 nf=1 m=1
M3 net2 phi2 VSS VSS nch l=0.15 w=1 nf=1 m=1
M4 net2 phi1 vout VSS nch l=0.15 w=1 nf=1 m=1
X1 VSS VSS net0 vx Opamp
X2 VSS vx VSS vout phi3 Comparator
.ends dut
