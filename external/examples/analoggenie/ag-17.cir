* official Analog Canvas netlist; PDK X cards rewritten by convert.py
.model nch nmos

.subckt dut VDD VSS Vin Vout
M1 net0 Vin VSS VSS nch l=0.15 w=1 nf=1 m=1
M2 VDD net0 Vout VSS nch l=0.15 w=1 nf=1 m=1
R1 VDD net0 1k
R2 Vout VSS 1k
.ends dut
