* official Analog Canvas netlist; PDK X cards rewritten by convert.py
.model nch nmos
.model pch pmos

.subckt comp VDD VSS INN OUT VB1
M1 VA VA VDD VDD pch l=0.15 w=1 nf=1 m=1
M10 net4 net1 VSS VSS nch l=0.15 w=1 nf=1 m=1
M11 net1 net1 VSS VSS nch l=0.15 w=1 nf=1 m=1
M12 net2 net1 VSS VSS nch l=0.15 w=1 nf=1 m=1
M13 net2 net2 VDD VDD pch l=0.15 w=1 nf=1 m=1
M14 VB2 net2 VDD VDD pch l=0.15 w=1 nf=1 m=1
M15 VB2 VB2 VSS VSS nch l=0.15 w=1 nf=1 m=1
M16 VB1 VB2 VSS VSS nch l=0.15 w=1 nf=1 m=1
M17 VB1 VB1 VDD VDD pch l=0.15 w=1 nf=1 m=1
M2 VA INN net3 VSS nch l=0.15 w=1 nf=1 m=1
M3 OUT OUT VDD VDD pch l=0.15 w=1 nf=1 m=1
M4 OUT OUT net3 VSS nch l=0.15 w=1 nf=1 m=1
M5 OUT OUT VDD VDD pch l=0.15 w=1 nf=1 m=1
M6 OUT net0 VSS VSS nch l=0.15 w=1 nf=1 m=1
M7 net0 VA VDD VDD pch l=0.15 w=1 nf=1 m=1
M8 net0 net0 VSS VSS nch l=0.15 w=1 nf=1 m=1
M9 net3 VB2 VSS VSS nch l=0.15 w=1 nf=1 m=1
R1 VDD net4 1k
R2 net4 net1 1k
R3 VDD net1 1k
.ends comp

.subckt dut VDD VSS VSTO VCONT1 VCONT2 VCONT3 VOUT VB1
CL VOUT VSS 1p
CSTO VSTO VSS 1p
LRX net1 net2 1n
MN1 net1 VCONT2 VSS VSS nch l=0.15 w=1 nf=1 m=1
MN2 net2 VCONT3 VSS VSS nch l=0.15 w=1 nf=1 m=1
MP2 net2 net0 VOUT VDD pch l=0.15 w=1 nf=1 m=1
MP3 net1 VCONT1 VSTO VDD pch l=0.15 w=1 nf=1 m=1
X1 VDD VSS net2 net0 VB1 comp
.ends dut
