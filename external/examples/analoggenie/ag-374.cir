* official Analog Canvas netlist; PDK X cards rewritten by convert.py
.model qnpn npn

.subckt dut VDD VSS VO1 VO2
I1 VDD VO1 DC 1m
I2 VDD VO2 DC 1m
Q1 VO1 VO1 VSS VSS qnpn m=1
Q2 net0 net0 VSS VSS qnpn m=1
R VO2 net0 1k
.ends dut
