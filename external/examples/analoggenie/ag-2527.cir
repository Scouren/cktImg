* official Analog Canvas netlist; PDK X cards rewritten by convert.py
.model nch nmos
.model pch pmos

.subckt dut VDD VSS VREF VB1 VB2 VB4 VIN VOUT VBP2 VBP1
CF1 VOUT VFB 1p
Cm1 net8 VOUT 1p
Cm2 net8 net5 1p
M11 net6 VBN VSS VSS nch l=0.15 w=1 nf=1 m=1
M12 VY VFB net6 VSS nch l=0.15 w=1 nf=1 m=1
M13 VX VREF net6 VSS nch l=0.15 w=1 nf=1 m=1
M14 VY VY VIN VDD pch l=0.15 w=1 nf=1 m=1
M15 VX VX VIN VDD pch l=0.15 w=1 nf=1 m=1
M16 VX VB1 VIN VDD pch l=0.15 w=1 nf=1 m=1
M17 VX net8 VSS VSS nch l=0.15 w=1 nf=1 m=1
M18 VX VX VSS VSS nch l=0.15 w=1 nf=1 m=1
M21 net7 net8 VSS VSS nch l=0.15 w=1 nf=1 m=1
M22 net0 VX VSS VSS nch l=0.15 w=1 nf=1 m=1
M23 net7 net7 VIN VDD pch l=0.15 w=1 nf=1 m=1
M24 net0 net7 VIN VDD pch l=0.15 w=1 nf=1 m=1
M31 net8 VY VIN VDD pch l=0.15 w=1 nf=1 m=1
M32 net2 VX VIN VDD pch l=0.15 w=1 nf=1 m=1
M33 net8 net2 VSS VSS nch l=0.15 w=1 nf=1 m=1
M34 net2 net2 VSS VSS nch l=0.15 w=1 nf=1 m=1
MB1 VBP2 VBP2 VIN VDD pch l=0.15 w=1 nf=1 m=1
MB10 VBP1 VBN VSS VSS nch l=0.15 w=1 nf=1 m=1
MB2 net3 VBP2 VIN VDD pch l=0.15 w=1 nf=1 m=1
MB3 net1 net1 VIN VDD pch l=0.15 w=1 nf=1 m=1
MB4 VBN net1 VIN VDD pch l=0.15 w=1 nf=1 m=1
MB5 VBP1 VBP1 VIN VDD pch l=0.15 w=1 nf=1 m=1
MB6 VBP2 net3 VSS VSS nch l=0.15 w=1 nf=1 m=1
MB7 net3 net3 VSS VSS nch l=0.15 w=1 nf=1 m=1
MB8 net1 net3 VSS VSS nch l=0.15 w=1 nf=1 m=1
MB9 VBN VBN VSS VSS nch l=0.15 w=1 nf=1 m=1
MD1 net5 net8 VSS VSS nch l=0.15 w=1 nf=1 m=1
MD2 net9 VB2 VSS VSS nch l=0.15 w=1 nf=1 m=1
MD3 net4 net5 net9 VSS nch l=0.15 w=1 nf=1 m=1
MD4 VY VB4 net9 VSS nch l=0.15 w=1 nf=1 m=1
MD5 net5 VY VIN VDD pch l=0.15 w=1 nf=1 m=1
MD6 VY VY VIN VDD pch l=0.15 w=1 nf=1 m=1
MD7 net4 net4 VIN VDD pch l=0.15 w=1 nf=1 m=1
MPT VOUT net0 VIN VDD pch l=0.15 w=1 nf=1 m=1
RF1 VOUT VFB 1k
RF2 VFB VSS 1k
.ends dut
