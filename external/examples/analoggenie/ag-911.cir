* official Analog Canvas netlist; PDK X cards rewritten by convert.py
.model nch nmos
.model pch pmos

.subckt dut VDD VSS GND inp inn VB1 VB2 Vo
CL Vo GND 1p
ITAIL net5 VSS DC 1m
M1 net0 inp net5 VSS nch l=0.15 w=1 nf=1 m=1
M1A net2 VB2 net0 VSS nch l=0.15 w=1 nf=1 m=1
M2 net3 inn net5 VSS nch l=0.15 w=1 nf=1 m=1
M2A Vo VB2 net3 VSS nch l=0.15 w=1 nf=1 m=1
M3 net1 net2 VDD VDD pch l=0.15 w=1 nf=1 m=1
M3A net2 VB1 net1 VDD pch l=0.15 w=1 nf=1 m=1
M4 net4 net2 VDD VDD pch l=0.15 w=1 nf=1 m=1
M4A Vo VB1 net4 VDD pch l=0.15 w=1 nf=1 m=1
.ends dut
