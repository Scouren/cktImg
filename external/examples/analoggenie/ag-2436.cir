* official Analog Canvas netlist; PDK X cards rewritten by convert.py
.model nch nmos
.model pch pmos

.subckt bias VDD VSS VB1 NB
M13 net0 net0 VSS VSS nch l=0.15 w=1 nf=1 m=1
M14 net2 net0 VSS VSS nch l=0.15 w=1 nf=1 m=1
M15 net0 net2 VDD VDD pch l=0.15 w=1 nf=1 m=1
M16 net1 net1 VDD VDD pch l=0.15 w=1 nf=1 m=1
M17 net1 net0 VSS VSS nch l=0.15 w=1 nf=1 m=1
M18 NB net1 VDD VDD pch l=0.15 w=1 nf=1 m=1
M19 NB NB VSS VSS nch l=0.15 w=1 nf=1 m=1
M20 VB1 NB VSS VSS nch l=0.15 w=1 nf=1 m=1
M21 VB1 VB1 VDD VDD pch l=0.15 w=1 nf=1 m=1
R1 VDD net0 1k
R2 VDD net2 1k
.ends bias

.subckt error_amp VDD VSS VREF NB OUT
M10 net2 VREF net0 VSS nch l=0.15 w=1 nf=1 m=1
M11 net1 OUT net0 VSS nch l=0.15 w=1 nf=1 m=1
M12 net0 NB VSS VSS nch l=0.15 w=1 nf=1 m=1
M4 net2 net2 VDD VDD pch l=0.15 w=1 nf=1 m=1
M5 OUT net2 VDD VDD pch l=0.15 w=1 nf=1 m=1
M6 OUT net1 VDD VDD pch l=0.15 w=1 nf=1 m=1
M7 net1 net1 VDD VDD pch l=0.15 w=1 nf=1 m=1
M8 OUT OUT VSS VSS nch l=0.15 w=1 nf=1 m=1
M9 OUT OUT VSS VSS nch l=0.15 w=1 nf=1 m=1
.ends error_amp

.subckt dut VDD VSS VIN VOUT VERR VREF VB1
M1 net3 net4 VIN VDD pch l=0.15 w=1 nf=1 m=1
M2 net1 net1 net3 VDD pch l=0.15 w=1 nf=1 m=1
M3 net1 nb VSS VSS nch l=0.15 w=1 nf=1 m=1
MBIAS VERR nb VSS VSS nch l=0.15 w=1 nf=1 m=1
MCHG net2 pb VIN VDD pch l=0.15 w=1 nf=1 m=1
MCTRL VERR net1 VOUT VDD pch l=0.15 w=1 nf=1 m=1
MGEN net5 net5 VSS VSS nch l=0.15 w=1 nf=1 m=1
MINJ VERR net5 VSS VSS nch l=0.15 w=1 nf=1 m=1
MRES VOUT VERR VIN VDD pch l=0.15 w=1 nf=1 m=1
MSEN net5 net4 net2 VDD pch l=0.15 w=1 nf=1 m=1
X1 VDD VSS VREF net0 net4 error_amp
X2 VDD VSS VB1 net0 bias
.ends dut
