* official Analog Canvas netlist; PDK X cards rewritten by convert.py
.model nch nmos

.subckt opamp VDD VSS VIP VIN VOUT params: gain=1e6 vhigh=5 vlow=-5
Blin nlin 0 V={gain*(V(VIP)-V(VIN))}
Bcore VOUT 0 V={0.5*(vhigh+(0.5*(vlow+V(nlin)+sqrt((V(nlin)-vlow)*(V(nlin)-vlow)+(1e-4*(vhigh-vlow))*(1e-4*(vhigh-vlow))+1e-12)))-sqrt((vhigh-(0.5*(vlow+V(nlin)+sqrt((V(nlin)-vlow)*(V(nlin)-vlow)+(1e-4*(vhigh-vlow))*(1e-4*(vhigh-vlow))+1e-12))))*(vhigh-(0.5*(vlow+V(nlin)+sqrt((V(nlin)-vlow)*(V(nlin)-vlow)+(1e-4*(vhigh-vlow))*(1e-4*(vhigh-vlow))+1e-12))))+(1e-4*(vhigh-vlow))*(1e-4*(vhigh-vlow))+1e-12))}
.ends opamp

.subckt dut VSS phi1 phi2 Vin Vout b1_bar b1
C1 net0 net5 1p
C2 net4 Vout 1p
C3 net5 net2 1p
M1 phi1 b1_bar net3 VSS nch l=0.15 w=1 nf=1 m=1
M10 net2 phi2 Vout VSS nch l=0.15 w=1 nf=1 m=1
M2 phi1 b1 net1 VSS nch l=0.15 w=1 nf=1 m=1
M3 phi2 b1 net3 VSS nch l=0.15 w=1 nf=1 m=1
M4 phi2 b1_bar net1 VSS nch l=0.15 w=1 nf=1 m=1
M5 Vin net3 net0 VSS nch l=0.15 w=1 nf=1 m=1
M6 net0 net1 VSS VSS nch l=0.15 w=1 nf=1 m=1
M7 VSS phi2 net4 VSS nch l=0.15 w=1 nf=1 m=1
M8 net4 phi1 net5 VSS nch l=0.15 w=1 nf=1 m=1
M9 net2 phi1 VSS VSS nch l=0.15 w=1 nf=1 m=1
X1 0 VSS VSS net5 Vout opamp gain=1e6
.ends dut
