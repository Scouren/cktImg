* official Analog Canvas netlist; PDK X cards rewritten by convert.py
.model nch nmos
.model pch pmos
.model qpnp pnp

.subckt opamp VDD VSS INN INP OUT
M1 net3 INN net4 VSS nch l=0.15 w=1 nf=1 m=1
M10 net5 net1 VDD VDD pch l=0.15 w=1 nf=1 m=1
M11 net1 net1 VDD VDD pch l=0.15 w=1 nf=1 m=1
M12 VB2 net1 VDD VDD pch l=0.15 w=1 nf=1 m=1
M13 net5 VB1 VSS VSS nch l=0.15 w=1 nf=1 m=1
M14 net1 net5 VB1 VSS nch l=0.15 w=1 nf=1 m=1
M15 VB2 VB2 VSS VSS nch l=0.15 w=1 nf=1 m=1
M2 net2 INP net4 VSS nch l=0.15 w=1 nf=1 m=1
M3 net3 net3 VDD VDD pch l=0.15 w=1 nf=1 m=1
M4 net2 net2 VDD VDD pch l=0.15 w=1 nf=1 m=1
M5 net0 net3 VDD VDD pch l=0.15 w=1 nf=1 m=1
M6 OUT net2 VDD VDD pch l=0.15 w=1 nf=1 m=1
M7 net0 net0 VSS VSS nch l=0.15 w=1 nf=1 m=1
M8 OUT net0 VSS VSS nch l=0.15 w=1 nf=1 m=1
M9 net4 VB2 VSS VSS nch l=0.15 w=1 nf=1 m=1
R4 VB1 VSS 1k
.ends opamp

.subckt dut VDD VSS Vout
Q1 VSS VSS net1 qpnp m=1
Q2 net1 net1 Y qpnp m=1
Q3 VSS VSS net0 qpnp m=1
Q4 net0 net0 net2 qpnp m=1
R1 Vout Y 1k
R2 Vout X 1k
R3 X net2 1k
X1 VDD VSS X Y Vout opamp
.ends dut
