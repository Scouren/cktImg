* official Analog Canvas netlist; PDK X cards rewritten by convert.py
.model nch nmos
.model pch pmos
.model qpnp pnp

.global VDD

.subckt A1 VSS IN- IN+ OUT
M1 net0 net0 VDD VDD pch l=0.15 w=1 nf=1 m=1
M10 net7 net5 VDD VDD pch l=0.15 w=1 nf=1 m=1
M11 net5 net5 VDD VDD pch l=0.15 w=1 nf=1 m=1
M12 net1 net1 VDD VDD pch l=0.15 w=1 nf=1 m=1
M13 VB3 net1 VDD VDD pch l=0.15 w=1 nf=1 m=1
M14 net8 net8 VDD VDD pch l=0.15 w=1 nf=1 m=1
M15 net7 net4 VSS VSS nch l=0.15 w=1 nf=1 m=1
M16 net5 net7 net4 VSS nch l=0.15 w=1 nf=1 m=1
M17 net1 net4 VSS VSS nch l=0.15 w=1 nf=1 m=1
M18 VB3 VB3 VSS VSS nch l=0.15 w=1 nf=1 m=1
M19 net8 VB3 VSS VSS nch l=0.15 w=1 nf=1 m=1
M2 net3 net3 VDD VDD pch l=0.15 w=1 nf=1 m=1
M3 net3 IN- net6 VSS nch l=0.15 w=1 nf=1 m=1
M4 net0 IN+ net6 VSS nch l=0.15 w=1 nf=1 m=1
M5 net6 VB3 VSS VSS nch l=0.15 w=1 nf=1 m=1
M6 OUT net0 VDD VDD pch l=0.15 w=1 nf=1 m=1
M7 net2 net3 VDD VDD pch l=0.15 w=1 nf=1 m=1
M8 OUT net2 VSS VSS nch l=0.15 w=1 nf=1 m=1
M9 net2 net2 VSS VSS nch l=0.15 w=1 nf=1 m=1
R1 net4 VSS 1k
.ends A1

.subckt dut VSS Vout
Q1 VSS VSS X qpnp m=1
Q2 VSS VSS net0 qpnp m=1
R1 Vout X 1k
R2 Vout Y 1k
R3 Y net0 1k
X1 VSS Y X Vout A1
.ends dut
