* official Analog Canvas netlist; PDK X cards rewritten by convert.py
.model nch nmos
.model pch pmos

.subckt cmp VDD VSS INN INP OUT VX VB1 VB2
M1 net3 net0 VDD VDD pch l=0.15 w=1 nf=1 m=1
M10 net0 INN net11 VSS nch l=0.15 w=1 nf=1 m=1
M11 net4 INP net11 VSS nch l=0.15 w=1 nf=1 m=1
M12 OUT VB5 net12 VSS nch l=0.15 w=1 nf=1 m=1
M13 net9 VX VSS VSS nch l=0.15 w=1 nf=1 m=1
M14 net11 VB2 VSS VSS nch l=0.15 w=1 nf=1 m=1
M15 net12 VX VSS VSS nch l=0.15 w=1 nf=1 m=1
M16 net7 VP VDD VDD pch l=0.15 w=1 nf=1 m=1
M17 VP VP VDD VDD pch l=0.15 w=1 nf=1 m=1
M18 net2 VP VDD VDD pch l=0.15 w=1 nf=1 m=1
M19 VB5 VP VDD VDD pch l=0.15 w=1 nf=1 m=1
M2 net10 net0 VDD VDD pch l=0.15 w=1 nf=1 m=1
M20 VP net2 net8 VSS nch l=0.15 w=1 nf=1 m=1
M21 VB5 VB5 net5 VSS nch l=0.15 w=1 nf=1 m=1
M22 net7 net7 VSS VSS nch l=0.15 w=1 nf=1 m=1
M23 net8 net7 VSS VSS nch l=0.15 w=1 nf=1 m=1
M24 net2 net8 VSS VSS nch l=0.15 w=1 nf=1 m=1
M25 net5 VB5 VSS VSS nch l=0.15 w=1 nf=1 m=1
M3 net6 net4 VDD VDD pch l=0.15 w=1 nf=1 m=1
M4 net1 net4 VDD VDD pch l=0.15 w=1 nf=1 m=1
M5 VX VB1 net3 VDD pch l=0.15 w=1 nf=1 m=1
M6 net0 VB1 net10 VDD pch l=0.15 w=1 nf=1 m=1
M7 net4 VB1 net6 VDD pch l=0.15 w=1 nf=1 m=1
M8 OUT VB1 net1 VDD pch l=0.15 w=1 nf=1 m=1
M9 VX VB5 net9 VSS nch l=0.15 w=1 nf=1 m=1
.ends cmp

.subckt dut VDD VSS VSTO VCONT1 VOUT VB1 VB2 VCONT2 VCONT3
CL VOUT VSS 1p
CSTO VSTO VSS 1p
LRX VX net0 1n
MN1 VX VCONT2 VSS VSS nch l=0.15 w=1 nf=1 m=1
MN2 net0 VCONT3 VSS VSS nch l=0.15 w=1 nf=1 m=1
MP2 net0 net1 VOUT VDD pch l=0.15 w=1 nf=1 m=1
MP3 VX VCONT1 VSTO VDD pch l=0.15 w=1 nf=1 m=1
X1 VDD VSS net0 net1 net1 VX VB1 VB2 cmp
.ends dut
