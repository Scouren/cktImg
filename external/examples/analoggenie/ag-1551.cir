* official Analog Canvas netlist; PDK X cards rewritten by convert.py
.model nch nmos
.model pch pmos
.model qpnp pnp

.global VDD

.subckt A1 VSS INN INP OUT
M1 net7 net1 VDD VDD pch l=0.15 w=1 nf=1 m=1
M10 net9 net4 VSS VSS nch l=0.15 w=1 nf=1 m=1
M11 net1 INN net10 VSS nch l=0.15 w=1 nf=1 m=1
M12 net0 INP net10 VSS nch l=0.15 w=1 nf=1 m=1
M13 OUT VB4 net3 VSS nch l=0.15 w=1 nf=1 m=1
M14 net3 net4 VSS VSS nch l=0.15 w=1 nf=1 m=1
M15 net10 VB2 VSS VSS nch l=0.15 w=1 nf=1 m=1
M16 VB4 net8 VDD VDD pch l=0.15 w=1 nf=1 m=1
M17 VB4 VB4 net5 VSS nch l=0.15 w=1 nf=1 m=1
M18 net5 VB4 VSS VSS nch l=0.15 w=1 nf=1 m=1
M19 net8 net8 VDD VDD pch l=0.15 w=1 nf=1 m=1
M2 net4 VB1 net7 VDD pch l=0.15 w=1 nf=1 m=1
M20 net8 VB3 VSS VSS nch l=0.15 w=1 nf=1 m=1
M21 VB3 net8 VDD VDD pch l=0.15 w=1 nf=1 m=1
M22 VB3 VB3 VSS VSS nch l=0.15 w=1 nf=1 m=1
M3 net6 net1 VDD VDD pch l=0.15 w=1 nf=1 m=1
M4 net1 VB1 net6 VDD pch l=0.15 w=1 nf=1 m=1
M5 net2 net0 VDD VDD pch l=0.15 w=1 nf=1 m=1
M6 net0 VB1 net2 VDD pch l=0.15 w=1 nf=1 m=1
M7 net11 net0 VDD VDD pch l=0.15 w=1 nf=1 m=1
M8 OUT VB1 net11 VDD pch l=0.15 w=1 nf=1 m=1
M9 net4 VB4 net9 VSS nch l=0.15 w=1 nf=1 m=1
.ends A1

.subckt dut VSS Vout
Q1 VSS VSS X qpnp m=1
Q2 VSS VSS net0 qpnp m=1
R1 Vout X 1k
R2 Vout Y 1k
R3 Y net0 1k
X1 VSS Y X Vout A1
.ends dut
