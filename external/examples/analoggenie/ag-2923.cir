* official Analog Canvas netlist; PDK X cards rewritten by convert.py
.model nch nmos
.model pch pmos

.subckt opamp VDD VSS INP INN OUT VT VBP
M3 VT VBP VDD VDD pch l=0.15 w=1 nf=1 m=1
M4 net1 INP VT VDD pch l=0.15 w=1 nf=1 m=1
M5 OUT INN VT VDD pch l=0.15 w=1 nf=1 m=1
M6 net1 net0 net2 VSS nch l=0.15 w=1 nf=1 m=1
M7 OUT net0 net3 VSS nch l=0.15 w=1 nf=1 m=1
M8 net2 net1 VSS VSS nch l=0.15 w=1 nf=1 m=1
M9 net3 net1 VSS VSS nch l=0.15 w=1 nf=1 m=1
.ends opamp

.subckt dut VDD VSS vci phi1 phi2 vco VB2 VB1
C1 vcx VSS 1p
C2 net1 vco 1p
M1 vci phi1 vcx VSS nch l=0.15 w=1 nf=1 m=1
M10 VB2 net2 VDD VDD pch l=0.15 w=1 nf=1 m=1
M11 net3 VB2 VSS VSS nch l=0.15 w=1 nf=1 m=1
M12 net2 net2 VDD VDD pch l=0.15 w=1 nf=1 m=1
M13 net2 VB2 VSS VSS nch l=0.15 w=1 nf=1 m=1
M14 net0 net2 VDD VDD pch l=0.15 w=1 nf=1 m=1
M15 net0 net0 VSS VSS nch l=0.15 w=1 nf=1 m=1
M16 VB3 VB3 VDD VDD pch l=0.15 w=1 nf=1 m=1
M17 VB3 net0 VSS VSS nch l=0.15 w=1 nf=1 m=1
M18 VB1 VB3 VDD VDD pch l=0.15 w=1 nf=1 m=1
M19 VB1 VB1 VSS VSS nch l=0.15 w=1 nf=1 m=1
M2 vcx phi2 net1 VSS nch l=0.15 w=1 nf=1 m=1
R1 VB2 net3 1k
X1 VDD VSS VSS net1 vco vcx VB3 opamp
.ends dut
