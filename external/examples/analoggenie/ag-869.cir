* official Analog Canvas netlist; PDK X cards rewritten by convert.py
.model qnpn npn
.model qpnp pnp

.subckt dut VCC VEE VSS Vi Vo
Q1 VCC Vi Vo VEE qnpn m=1
Q2 VEE Vi Vo qpnp m=1
RL Vo VSS 1k
.ends dut
