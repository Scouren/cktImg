* official Analog Canvas netlist; PDK X cards rewritten by convert.py
.model nch nmos

.subckt dut VDD VSS Vin1 Vin2 Vb1 Vb2 Vout1 Vout2
M1 Vout1 Y net0 VSS nch l=0.15 w=1 nf=1 m=1
M2 Vout2 X net0 VSS nch l=0.15 w=1 nf=1 m=1
M3 net0 Vb2 VSS VSS nch l=0.15 w=1 nf=1 m=1
M4 X Vin1 net1 VSS nch l=0.15 w=1 nf=1 m=1
M5 Y Vin2 net1 VSS nch l=0.15 w=1 nf=1 m=1
M6 net1 Vb1 VSS VSS nch l=0.15 w=1 nf=1 m=1
R1 VDD X 1k
R2 VDD Y 1k
RD1 VDD Vout1 1k
RD2 VDD Vout2 1k
.ends dut
