* official Analog Canvas netlist; PDK X cards rewritten by convert.py
.model nch nmos
.model pch pmos

.subckt dut VDD VSS VCONT1 VCONT2 VCONT4 VCONT5 VP VCONT3 VIN VDR3 VB2 VREF VB1 VB4
.model DIODE D(IS=1e-14 N=1)
CFLY VX1 VX2 1p
CO VP VN 1p
COP VP VSS 1p
D1 VN VX2 DIODE
L1 VX1 VX3 1n
M1 VS VCONT1 VIN VDD pch l=0.15 w=1 nf=1 m=1
M2 VX1 VCONT2 VIN VDD pch l=0.15 w=1 nf=1 m=1
M3 VX2 VCONT3 VIN VDD pch l=0.15 w=1 nf=1 m=1
M4 VX3 VCONT4 VSS VSS nch l=0.15 w=1 nf=1 m=1
M5 VP VCONT5 VX3 VDD pch l=0.15 w=1 nf=1 m=1
MN1 net0 VC VX1 VSS nch l=0.15 w=1 nf=1 m=1
MN10 net4 net6 VSS VSS nch l=0.15 w=1 nf=1 m=1
MN11 net8 net0 VSS VSS nch l=0.15 w=1 nf=1 m=1
MN12 VC VC net9 VSS nch l=0.15 w=1 nf=1 m=1
MN13 net9 VC VSS VSS nch l=0.15 w=1 nf=1 m=1
MN14 VD VB4 net3 VSS nch l=0.15 w=1 nf=1 m=1
MN15 net3 VX2 VSS VSS nch l=0.15 w=1 nf=1 m=1
MN16 VB4 net3 VSS VSS nch l=0.15 w=1 nf=1 m=1
MN17 VX2 VX2 VSS VSS nch l=0.15 w=1 nf=1 m=1
MN2 net6 VC net10 VSS nch l=0.15 w=1 nf=1 m=1
MN3 VX1 net0 VSS VSS nch l=0.15 w=1 nf=1 m=1
MN4 net10 net6 VSS VSS nch l=0.15 w=1 nf=1 m=1
MN5 VG VC net4 VSS nch l=0.15 w=1 nf=1 m=1
MN6 VM net1 VSS VSS nch l=0.15 w=1 nf=1 m=1
MN7 net1 VDR3 VSS VSS nch l=0.15 w=1 nf=1 m=1
MN8 net1 net1 VSS VSS nch l=0.15 w=1 nf=1 m=1
MN9 VCTRL VC net8 VSS nch l=0.15 w=1 nf=1 m=1
MP1 net2 VG VDD VDD pch l=0.15 w=1 nf=1 m=1
MP10 net0 VFP1 net7 VDD pch l=0.15 w=1 nf=1 m=1
MP11 VC VD VDD VDD pch l=0.15 w=1 nf=1 m=1
MP12 VD VD VDD VDD pch l=0.15 w=1 nf=1 m=1
MP13 VB4 VD VDD VDD pch l=0.15 w=1 nf=1 m=1
MP14 VX2 VD VDD VDD pch l=0.15 w=1 nf=1 m=1
MP2 net5 VG VDD VDD pch l=0.15 w=1 nf=1 m=1
MP3 net7 VB2 VDD VDD pch l=0.15 w=1 nf=1 m=1
MP4 VM VM VS VDD pch l=0.15 w=1 nf=1 m=1
MP5 VX1 VM VS VDD pch l=0.15 w=1 nf=1 m=1
MP6 net1 VCTRL VS VDD pch l=0.15 w=1 nf=1 m=1
MP7 VG VB1 net2 VDD pch l=0.15 w=1 nf=1 m=1
MP8 VCTRL VB1 net5 VDD pch l=0.15 w=1 nf=1 m=1
MP9 net6 VREF net7 VDD pch l=0.15 w=1 nf=1 m=1
R1 VP VFP1 1k
R2 VFP1 VSS 1k
.ends dut
