* official Analog Canvas netlist; PDK X cards rewritten by convert.py
.model nch nmos
.model pch pmos

.subckt dut VDD VSS VIN VOUT Vb2
CC VOUT net0 1p
CE VDD VIN 1p
CL VOUT VSS 1p
I1 Vb VSS DC 1m
M11 VOUT Vb2 VSS VSS nch l=0.15 w=1 nf=1 m=1
M13 net1 net1 VDD VDD pch l=0.15 w=1 nf=1 m=1
M14 Vb Vb net1 VDD pch l=0.15 w=1 nf=1 m=1
M15 net0 Vb VIN VDD pch l=0.15 w=1 nf=1 m=1
M9 VOUT VIN VDD VDD pch l=0.15 w=1 nf=1 m=1
.ends dut
