* official Analog Canvas netlist; PDK X cards rewritten by convert.py
.model nch nmos
.model pch pmos
.model qnpn npn

.subckt opamp VDD VSS VB1 VB3 INN INP VB2 OUT VC2
M1 net2 VB1 VDD VDD pch l=0.15 w=1 nf=1 m=1
M10 net8 INP net4 VSS nch l=0.15 w=1 nf=1 m=1
M11 net4 VB2 VSS VSS nch l=0.15 w=1 nf=1 m=1
M12 VB5 VB6 VDD VDD pch l=0.15 w=1 nf=1 m=1
M13 VB5 VB5 VC2 VSS nch l=0.15 w=1 nf=1 m=1
M14 VC2 VB5 VSS VSS nch l=0.15 w=1 nf=1 m=1
M15 net6 VB6 VDD VDD pch l=0.15 w=1 nf=1 m=1
M16 VB6 VB6 VDD VDD pch l=0.15 w=1 nf=1 m=1
M17 net5 VB6 VDD VDD pch l=0.15 w=1 nf=1 m=1
M18 net6 net6 VSS VSS nch l=0.15 w=1 nf=1 m=1
M19 VB6 net5 net7 VSS nch l=0.15 w=1 nf=1 m=1
M2 net8 VB1 VDD VDD pch l=0.15 w=1 nf=1 m=1
M20 net7 net6 VSS VSS nch l=0.15 w=1 nf=1 m=1
M21 net5 net5 VSS VSS nch l=0.15 w=1 nf=1 m=1
M3 net3 VB3 net2 VDD pch l=0.15 w=1 nf=1 m=1
M4 OUT VB3 net8 VDD pch l=0.15 w=1 nf=1 m=1
M5 net3 VB5 net1 VSS nch l=0.15 w=1 nf=1 m=1
M6 OUT VB5 net0 VSS nch l=0.15 w=1 nf=1 m=1
M7 net1 net3 VSS VSS nch l=0.15 w=1 nf=1 m=1
M8 net0 net3 VSS VSS nch l=0.15 w=1 nf=1 m=1
M9 net2 INN net4 VSS nch l=0.15 w=1 nf=1 m=1
.ends opamp

.subckt dut VDD VSS Vout VB3 VB2 VB1
Q1 net2 net2 VSS VSS qnpn m=1
Q2 net0 net0 VSS VSS qnpn m=1
R1 Vout net2 1k
R2 Vout net1 1k
R3 net1 net0 1k
X1 VDD VSS VB1 VB3 net1 net2 VB2 Vout net0 opamp
.ends dut
