* official Analog Canvas netlist; PDK X cards rewritten by convert.py
.model nch nmos
.model pch pmos

.subckt dut VDD VSS Vb1 Vb2 Vb3 Vin1 Vout1 Vin2 Vout2
CC1 Vout1 net0 1p
CC2 Vout2 net1 1p
CL1 Vout1 VSS 1p
CL2 Vout2 VSS 1p
I1 Vout1 VSS DC 1m
I2 Vout2 VSS DC 1m
ISS net2 VSS DC 1m
M1 net0 Vin1 net2 VSS nch l=0.15 w=1 nf=1 m=1
M10 Vout1 Y VDD VDD pch l=0.15 w=1 nf=1 m=1
M2 net1 Vin2 net2 VSS nch l=0.15 w=1 nf=1 m=1
M3 Y Vb3 net0 VSS nch l=0.15 w=1 nf=1 m=1
M4 X Vb3 net1 VSS nch l=0.15 w=1 nf=1 m=1
M5 Y Vb2 net4 VDD pch l=0.15 w=1 nf=1 m=1
M6 X Vb2 net3 VDD pch l=0.15 w=1 nf=1 m=1
M7 net4 Vb1 VDD VDD pch l=0.15 w=1 nf=1 m=1
M8 net3 Vb1 VDD VDD pch l=0.15 w=1 nf=1 m=1
M9 Vout2 X VDD VDD pch l=0.15 w=1 nf=1 m=1
.ends dut
