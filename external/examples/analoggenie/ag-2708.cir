* official Analog Canvas netlist; PDK X cards rewritten by convert.py
.model nch nmos
.model pch pmos

.subckt dut VDD VSS vci phi1 phi2 vco VB2 VB1
C1 vcx VSS 1p
C2 VX vco 1p
M1 vci phi1 vcx VSS nch l=0.15 w=1 nf=1 m=1
M10 net0 net0 VSS VSS nch l=0.15 w=1 nf=1 m=1
M11 vco net0 VSS VSS nch l=0.15 w=1 nf=1 m=1
M12 VX VB2 VDD VDD pch l=0.15 w=1 nf=1 m=1
M13 VB2 VB2 VDD VDD pch l=0.15 w=1 nf=1 m=1
M14 VX net1 VSS VSS nch l=0.15 w=1 nf=1 m=1
M15 VB2 VX net1 VSS nch l=0.15 w=1 nf=1 m=1
M16 net2 net1 VSS VSS nch l=0.15 w=1 nf=1 m=1
M17 net2 net2 VDD VDD pch l=0.15 w=1 nf=1 m=1
M18 VB3 net2 VDD VDD pch l=0.15 w=1 nf=1 m=1
M19 VB3 VB3 VSS VSS nch l=0.15 w=1 nf=1 m=1
M2 vcx phi2 VX VSS nch l=0.15 w=1 nf=1 m=1
M20 VB1 VB3 VSS VSS nch l=0.15 w=1 nf=1 m=1
M21 VB1 VB1 VDD VDD pch l=0.15 w=1 nf=1 m=1
M3 vcx VX net3 VSS nch l=0.15 w=1 nf=1 m=1
M4 net4 VSS net3 VSS nch l=0.15 w=1 nf=1 m=1
M5 net3 VB3 VSS VSS nch l=0.15 w=1 nf=1 m=1
M6 vcx vcx VDD VDD pch l=0.15 w=1 nf=1 m=1
M7 net4 net4 VDD VDD pch l=0.15 w=1 nf=1 m=1
M8 net0 vcx VDD VDD pch l=0.15 w=1 nf=1 m=1
M9 vco net4 VDD VDD pch l=0.15 w=1 nf=1 m=1
R1 net1 VSS 1k
.ends dut
