* official Analog Canvas netlist; PDK X cards rewritten by convert.py
.model nch nmos
.model pch pmos

.subckt bias VDD VSS VC
M22 net0 VC VSS VSS nch l=0.15 w=1 nf=1 m=1
M23 VC VBP VDD VDD pch l=0.15 w=1 nf=1 m=1
M24 VC VC net0 VSS nch l=0.15 w=1 nf=1 m=1
M25 net2 VBP VDD VDD pch l=0.15 w=1 nf=1 m=1
M26 VBP VBP VDD VDD pch l=0.15 w=1 nf=1 m=1
M27 net2 net2 VSS VSS nch l=0.15 w=1 nf=1 m=1
M28 VBP net3 net1 VSS nch l=0.15 w=1 nf=1 m=1
M29 net1 net2 VSS VSS nch l=0.15 w=1 nf=1 m=1
M30 net3 VBP VDD VDD pch l=0.15 w=1 nf=1 m=1
M31 net3 net1 VSS VSS nch l=0.15 w=1 nf=1 m=1
.ends bias

.subckt dut VDD VSS VB1 VB3 VREF VB2 VB6 IBUF VIN VOUT
CL VOUT net4 1p
M10 EAO VB3 VX VDD pch l=0.15 w=1 nf=1 m=1
M11 net6 VB1 VDD VDD pch l=0.15 w=1 nf=1 m=1
M12 VX VB1 VDD VDD pch l=0.15 w=1 nf=1 m=1
M13 net3 VB6 VDD VDD pch l=0.15 w=1 nf=1 m=1
M14 net0 EAO net3 VDD pch l=0.15 w=1 nf=1 m=1
M15 net0 net0 VSS VSS nch l=0.15 w=1 nf=1 m=1
M16 GATE net0 VSS VSS nch l=0.15 w=1 nf=1 m=1
M17 VDD net3 GATE VSS nch l=0.15 w=1 nf=1 m=1
M18 net7 EAO IBUF VSS nch l=0.15 w=1 nf=1 m=1
M19 net7 net7 VDD VDD pch l=0.15 w=1 nf=1 m=1
M2 net5 VB2 VSS VSS nch l=0.15 w=1 nf=1 m=1
M20 GATE net7 VDD VDD pch l=0.15 w=1 nf=1 m=1
M21 VSS IBUF GATE VDD pch l=0.15 w=1 nf=1 m=1
M3 VX VREF net5 VSS nch l=0.15 w=1 nf=1 m=1
M4 net6 FB net5 VSS nch l=0.15 w=1 nf=1 m=1
M5 net8 net2 VSS VSS nch l=0.15 w=1 nf=1 m=1
M6 net1 net2 VSS VSS nch l=0.15 w=1 nf=1 m=1
M7 net2 VC net8 VSS nch l=0.15 w=1 nf=1 m=1
M8 EAO VC net1 VSS nch l=0.15 w=1 nf=1 m=1
M9 net2 VB3 net6 VDD pch l=0.15 w=1 nf=1 m=1
MNP VIN GATE VOUT VSS nch l=0.15 w=1 nf=1 m=1
R1 FB VSS 1k
R2 VOUT FB 1k
R3 net4 VSS 1k
RL VOUT VSS 1k
X1 VDD VSS VC bias
.ends dut
