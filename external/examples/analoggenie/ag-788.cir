* official Analog Canvas netlist; PDK X cards rewritten by convert.py
.model nch nmos

.subckt icm_opamp_vdd_vss VDD VSS VIP VIN VOUT params: gain=1e6
Blin nlin 0 V={gain*(V(VIP)-V(VIN))}
Bcore VOUT 0 V={0.5*(V(VDD)+(0.5*(V(VSS)+V(nlin)+sqrt((V(nlin)-V(VSS))*(V(nlin)-V(VSS))+(1e-4*(V(VDD)-V(VSS)))*(1e-4*(V(VDD)-V(VSS)))+1e-12)))-sqrt((V(VDD)-(0.5*(V(VSS)+V(nlin)+sqrt((V(nlin)-V(VSS))*(V(nlin)-V(VSS))+(1e-4*(V(VDD)-V(VSS)))*(1e-4*(V(VDD)-V(VSS)))+1e-12))))*(V(VDD)-(0.5*(V(VSS)+V(nlin)+sqrt((V(nlin)-V(VSS))*(V(nlin)-V(VSS))+(1e-4*(V(VDD)-V(VSS)))*(1e-4*(V(VDD)-V(VSS)))+1e-12))))+(1e-4*(V(VDD)-V(VSS)))*(1e-4*(V(VDD)-V(VSS)))+1e-12))}
.ends icm_opamp_vdd_vss

.subckt Gm INN INP VC OUT
.ends Gm

.subckt LPF IN OUT
.ends LPF

.subckt dut VDD VSS phi1 phi2 Vcntl
CI net1 net3 1p
Cm net0 net4 1p
I1 VDD net2 DC 1m
IB VDD net1 DC 1m
M1 net0 phi1 net2 VSS nch l=0.15 w=1 nf=1 m=1
M2 net0 phi2 VSS VSS nch l=0.15 w=1 nf=1 m=1
M3 net1 phi2 net4 VSS nch l=0.15 w=1 nf=1 m=1
M4 net4 phi1 VSS VSS nch l=0.15 w=1 nf=1 m=1
X1 net2 VSS Vcntl net2 Gm
X2 net3 Vcntl LPF
X3 VDD VSS VSS net1 net3 icm_opamp_vdd_vss gain=1e6
.ends dut
