* official Analog Canvas netlist; PDK X cards rewritten by convert.py
.model nch nmos
.model pch pmos

.subckt opamp VDD VSS INP INN OUT VCX
M10 VB1 VB1 VDD VDD pch l=0.15 w=1 nf=1 m=1
M11 VB1 net0 VSS VSS nch l=0.15 w=1 nf=1 m=1
M12 net0 net0 net4 VSS nch l=0.15 w=1 nf=1 m=1
M3 VCX VB1 VDD VDD pch l=0.15 w=1 nf=1 m=1
M4 net3 INP VCX VDD pch l=0.15 w=1 nf=1 m=1
M5 OUT INN VCX VDD pch l=0.15 w=1 nf=1 m=1
M6 net3 VB2 net1 VSS nch l=0.15 w=1 nf=1 m=1
M7 OUT VB2 net2 VSS nch l=0.15 w=1 nf=1 m=1
M8 net1 net3 VSS VSS nch l=0.15 w=1 nf=1 m=1
M9 net2 net3 VSS VSS nch l=0.15 w=1 nf=1 m=1
R1 VDD net0 1k
R2 net4 VSS 1k
.ends opamp

.subckt dut VDD VSS vci phi1 phi2 vco
C1 vcx VSS 1p
C2 net0 vco 1p
M1 vci phi1 vcx VSS nch l=0.15 w=1 nf=1 m=1
M2 vcx phi2 net0 VSS nch l=0.15 w=1 nf=1 m=1
X1 VDD VSS VSS net0 vco vcx opamp
.ends dut
