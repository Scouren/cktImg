* official Analog Canvas netlist; PDK X cards rewritten by convert.py
.model nch nmos
.model pch pmos

.subckt dut VDD VSS VCONT1 VCONT2 VCONT3 VIN VCONT4 VCONT5 VP VB3 VREF VB1 VB2
.model DIODE D(IS=1e-14 N=1)
CFLY VX1 VX2 1p
CO VP VN 1p
COP VP VSS 1p
D1 VN VX2 DIODE
L1 VX1 VX3 1n
M1 VX1 VCONT2 VIN VIN pch l=0.15 w=1 nf=1 m=1
M10 net4 net4 VSS VSS nch l=0.15 w=1 nf=1 m=1
M11 net4 VB3 VSS VSS nch l=0.15 w=1 nf=1 m=1
M12 net6 VB4 VDD VDD pch l=0.15 w=1 nf=1 m=1
M13 net1 VFP1 net6 net2 pch l=0.15 w=1 nf=1 m=1
M14 VX2 VREF net6 net2 pch l=0.15 w=1 nf=1 m=1
M15 net1 net1 VSS VSS nch l=0.15 w=1 nf=1 m=1
M16 VEA net1 VSS VSS nch l=0.15 w=1 nf=1 m=1
M17 VEA net3 VDD VDD pch l=0.15 w=1 nf=1 m=1
M18 net3 net3 VDD VDD pch l=0.15 w=1 nf=1 m=1
M19 net3 VX2 VSS VSS nch l=0.15 w=1 nf=1 m=1
M2 VX2 VCONT3 VIN VIN pch l=0.15 w=1 nf=1 m=1
M20 VX2 VX2 VSS VSS nch l=0.15 w=1 nf=1 m=1
M21 VX2 VA VSS VSS nch l=0.15 w=1 nf=1 m=1
M22 VB1 VB4 VDD VDD pch l=0.15 w=1 nf=1 m=1
M23 VB4 VB4 VDD VDD pch l=0.15 w=1 nf=1 m=1
M24 net0 VB5 VDD VDD pch l=0.15 w=1 nf=1 m=1
M25 VB5 VB5 VDD VDD pch l=0.15 w=1 nf=1 m=1
M26 VB2 VB5 VDD VDD pch l=0.15 w=1 nf=1 m=1
M27 VA VB5 VDD VDD pch l=0.15 w=1 nf=1 m=1
M28 VB1 VB1 VSS VSS nch l=0.15 w=1 nf=1 m=1
M29 VB4 net0 VSS VSS nch l=0.15 w=1 nf=1 m=1
M3 VX3 VCONT5 VP VP pch l=0.15 w=1 nf=1 m=1
M30 net0 net0 VSS VSS nch l=0.15 w=1 nf=1 m=1
M31 VB5 VB2 VX2 VSS nch l=0.15 w=1 nf=1 m=1
M32 VB2 VB2 VSS VSS nch l=0.15 w=1 nf=1 m=1
M33 VA VA VSS VSS nch l=0.15 w=1 nf=1 m=1
M4 VX3 VCONT4 VSS VSS nch l=0.15 w=1 nf=1 m=1
M5 VA VCONT1 VIN VIN pch l=0.15 w=1 nf=1 m=1
M6 VX1 net5 VA VA pch l=0.15 w=1 nf=1 m=1
M7 net5 net5 VA VA pch l=0.15 w=1 nf=1 m=1
M8 net4 VEA VA VA pch l=0.15 w=1 nf=1 m=1
M9 net5 net4 VSS VSS nch l=0.15 w=1 nf=1 m=1
R1 VP VFP1 1k
R2 VFP1 VSS 1k
.ends dut
