* official Analog Canvas netlist; PDK X cards rewritten by convert.py
.model nch nmos
.model pch pmos

.subckt dut VDD VSS Vref VB1 VB2 VIN VOUT
CL VOUT net9 1p
M1 net0 Vref net3 VSS nch l=0.15 w=1 nf=1 m=1
M10 VG VB1 net2 VDD pch l=0.15 w=1 nf=1 m=1
M11 net8 VB1 net10 VDD pch l=0.15 w=1 nf=1 m=1
M12 VG VB5 net11 VSS nch l=0.15 w=1 nf=1 m=1
M13 VG VB5 net6 VSS nch l=0.15 w=1 nf=1 m=1
M14 net11 VG VSS VSS nch l=0.15 w=1 nf=1 m=1
M15 net6 VG VSS VSS nch l=0.15 w=1 nf=1 m=1
M16 VB4 VB6 VDD VDD pch l=0.15 w=1 nf=1 m=1
M17 VB6 VB6 VDD VDD pch l=0.15 w=1 nf=1 m=1
M18 net1 VB6 VDD VDD pch l=0.15 w=1 nf=1 m=1
M19 VB5 VB6 VDD VDD pch l=0.15 w=1 nf=1 m=1
M2 net8 FB net3 VSS nch l=0.15 w=1 nf=1 m=1
M20 VB6 VB4 VB3 VSS nch l=0.15 w=1 nf=1 m=1
M21 VB5 VB5 net5 VSS nch l=0.15 w=1 nf=1 m=1
M22 VB4 VB3 VSS VSS nch l=0.15 w=1 nf=1 m=1
M23 VB3 net1 VSS VSS nch l=0.15 w=1 nf=1 m=1
M24 net1 net1 VSS VSS nch l=0.15 w=1 nf=1 m=1
M25 net5 VB5 VSS VSS nch l=0.15 w=1 nf=1 m=1
M3 net3 VB2 VSS VSS nch l=0.15 w=1 nf=1 m=1
M4 net7 net0 VDD VDD pch l=0.15 w=1 nf=1 m=1
M5 net4 net0 VDD VDD pch l=0.15 w=1 nf=1 m=1
M6 net2 net8 VDD VDD pch l=0.15 w=1 nf=1 m=1
M7 net10 net8 VDD VDD pch l=0.15 w=1 nf=1 m=1
M8 net0 VB1 net7 VDD pch l=0.15 w=1 nf=1 m=1
M9 VG VB1 net4 VDD pch l=0.15 w=1 nf=1 m=1
MNP VIN VG VOUT VSS nch l=0.15 w=1 nf=1 m=1
R1 VOUT FB 1k
R2 FB VSS 1k
R3 net9 VSS 1k
.ends dut
