* official Analog Canvas netlist; PDK X cards rewritten by convert.py
.model nch nmos
.model pch pmos
.model qpnp pnp

.subckt opamp VDD VSS INN INP OUT
M1 net3 INN net1 VSS nch l=0.15 w=1 nf=1 m=1
M10 net5 net5 VSS VSS nch l=0.15 w=1 nf=1 m=1
M11 net2 net5 VSS VSS nch l=0.15 w=1 nf=1 m=1
M12 net2 net2 VDD VDD pch l=0.15 w=1 nf=1 m=1
M13 VB2 net2 VDD VDD pch l=0.15 w=1 nf=1 m=1
M14 VB2 VB2 VSS VSS nch l=0.15 w=1 nf=1 m=1
M15 VB1 VB2 VSS VSS nch l=0.15 w=1 nf=1 m=1
M16 VB1 VB1 VDD VDD pch l=0.15 w=1 nf=1 m=1
M2 net0 INP net1 VSS nch l=0.15 w=1 nf=1 m=1
M3 net3 net3 VDD VDD pch l=0.15 w=1 nf=1 m=1
M4 net0 net0 VDD VDD pch l=0.15 w=1 nf=1 m=1
M5 net4 net3 VDD VDD pch l=0.15 w=1 nf=1 m=1
M6 OUT net0 VDD VDD pch l=0.15 w=1 nf=1 m=1
M7 net4 net4 VSS VSS nch l=0.15 w=1 nf=1 m=1
M8 OUT net4 VSS VSS nch l=0.15 w=1 nf=1 m=1
M9 net1 VB2 VSS VSS nch l=0.15 w=1 nf=1 m=1
RF VDD net5 1k
.ends opamp

.subckt dut VDD VSS Vout
Q1 VSS VSS net0 qpnp m=1
Q2 net0 net0 net3 qpnp m=1
Q3 VSS VSS net1 qpnp m=1
Q4 net1 net1 net2 qpnp m=1
R1 Vout net3 1k
R2 Vout net4 1k
R3 net4 net2 1k
X1 VDD VSS net4 net3 Vout opamp
.ends dut
