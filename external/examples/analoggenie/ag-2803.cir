* official Analog Canvas netlist; PDK X cards rewritten by convert.py
.model nch nmos
.model pch pmos

.subckt dut VDD VSS vci phi1 phi2 vco
C1 net1 VSS 1p
C2 net5 vco 1p
M1 vci phi1 net1 VSS nch l=0.15 w=1 nf=1 m=1
M10 net0 net4 VDD VDD pch l=0.15 w=1 nf=1 m=1
M11 net0 net0 VSS VSS nch l=0.15 w=1 nf=1 m=1
M12 net2 net0 VSS VSS nch l=0.15 w=1 nf=1 m=1
M13 net2 net2 VDD VDD pch l=0.15 w=1 nf=1 m=1
M14 VB2 net2 VDD VDD pch l=0.15 w=1 nf=1 m=1
M15 VB2 VB2 VSS VSS nch l=0.15 w=1 nf=1 m=1
M16 VX VB2 VSS VSS nch l=0.15 w=1 nf=1 m=1
M17 VX VX VDD VDD pch l=0.15 w=1 nf=1 m=1
M2 net1 phi2 net5 VSS nch l=0.15 w=1 nf=1 m=1
M3 VX net5 net3 VSS nch l=0.15 w=1 nf=1 m=1
M4 vco VSS net3 VSS nch l=0.15 w=1 nf=1 m=1
M5 net3 VB2 VSS VSS nch l=0.15 w=1 nf=1 m=1
M6 VX VX VDD VDD pch l=0.15 w=1 nf=1 m=1
M7 vco VX VDD VDD pch l=0.15 w=1 nf=1 m=1
M8 net4 net4 VDD VDD pch l=0.15 w=1 nf=1 m=1
M9 net4 net0 VSS VSS nch l=0.15 w=1 nf=1 m=1
R1 VDD net0 1k
.ends dut
