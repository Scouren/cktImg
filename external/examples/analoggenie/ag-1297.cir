* official Analog Canvas netlist; PDK X cards rewritten by convert.py
.model nch nmos
.model pch pmos

.subckt dut VDD VSS VCONT1 VCONT2 VCONT3 VCONT4 VCONT5 VP VIN VB3 VREF VB1 VB2
.model DIODE D(IS=1e-14 N=1)
CFLY VX1 VX2 1p
CO VP VN 1p
COP VP VSS 1p
D1 VN VX2 DIODE
L1 VX1 VX3 1n
M1 net7 VCONT1 VIN VIN pch l=0.15 w=1 nf=1 m=1
M2 VX1 VCONT2 VIN VIN pch l=0.15 w=1 nf=1 m=1
M3 VX2 VCONT3 VIN VIN pch l=0.15 w=1 nf=1 m=1
M4 VX3 VCONT4 VSS VSS nch l=0.15 w=1 nf=1 m=1
M5 VP VCONT5 VX3 VP pch l=0.15 w=1 nf=1 m=1
MN1 net2 net2 VSS VSS nch l=0.15 w=1 nf=1 m=1
MN10 VBP VBN VSS VSS nch l=0.15 w=1 nf=1 m=1
MN11 VB2 VBN VSS VSS nch l=0.15 w=1 nf=1 m=1
MN12 net5 VBN VSS VSS nch l=0.15 w=1 nf=1 m=1
MN2 VX2 VX2 VSS VSS nch l=0.15 w=1 nf=1 m=1
MN3 VEA net2 VSS VSS nch l=0.15 w=1 nf=1 m=1
MN4 net4 VX2 VSS VSS nch l=0.15 w=1 nf=1 m=1
MN6 net6 net3 VSS VSS nch l=0.15 w=1 nf=1 m=1
MN7 net3 net3 VSS VSS nch l=0.15 w=1 nf=1 m=1
MN8 net3 VB3 VSS VSS nch l=0.15 w=1 nf=1 m=1
MN9 VB1 VB1 VSS VSS nch l=0.15 w=1 nf=1 m=1
MP1 net4 net4 VDD VDD pch l=0.15 w=1 nf=1 m=1
MP10 VBP VBP VDD VDD pch l=0.15 w=1 nf=1 m=1
MP11 VB2 VB2 VDD VDD pch l=0.15 w=1 nf=1 m=1
MP12 VBN VB2 VDD VDD pch l=0.15 w=1 nf=1 m=1
MP2 VEA net4 VDD VDD pch l=0.15 w=1 nf=1 m=1
MP3 net1 VBP VDD VDD pch l=0.15 w=1 nf=1 m=1
MP4 net6 net6 net7 net7 pch l=0.15 w=1 nf=1 m=1
MP5 VX1 net6 net7 net7 pch l=0.15 w=1 nf=1 m=1
MP6 net3 VEA net7 net7 pch l=0.15 w=1 nf=1 m=1
MP7 net2 VFP1 net1 net0 pch l=0.15 w=1 nf=1 m=1
MP8 VX2 VREF net1 net0 pch l=0.15 w=1 nf=1 m=1
MP9 VB1 VBP VDD VDD pch l=0.15 w=1 nf=1 m=1
R1 VP VFP1 1k
R2 VFP1 VSS 1k
RBIAS VBN net5 1k
.ends dut
