* official Analog Canvas netlist; PDK X cards rewritten by convert.py
.model nch nmos
.model pch pmos
.model qpnp pnp

.subckt opamp VDD VSS VB1 VB2 OUT INN INP VE
M10 net5 INN net1 VDD pch l=0.15 w=1 nf=1 m=1
M11 VE INP net1 VDD pch l=0.15 w=1 nf=1 m=1
M12 OUT VB5 net8 VSS nch l=0.15 w=1 nf=1 m=1
M13 net5 VB5 net3 VSS nch l=0.15 w=1 nf=1 m=1
M14 VE VB5 net0 VSS nch l=0.15 w=1 nf=1 m=1
M15 VC VB5 net7 VSS nch l=0.15 w=1 nf=1 m=1
M16 net8 net5 VSS VSS nch l=0.15 w=1 nf=1 m=1
M17 net3 net5 VSS VSS nch l=0.15 w=1 nf=1 m=1
M18 net0 VE VSS VSS nch l=0.15 w=1 nf=1 m=1
M19 net7 VE VSS VSS nch l=0.15 w=1 nf=1 m=1
M20 net2 VB6 VDD VDD pch l=0.15 w=1 nf=1 m=1
M21 VB6 VB6 VDD VDD pch l=0.15 w=1 nf=1 m=1
M22 VB4 VB6 VDD VDD pch l=0.15 w=1 nf=1 m=1
M23 VB5 VB6 VDD VDD pch l=0.15 w=1 nf=1 m=1
M24 net2 net2 VSS VSS nch l=0.15 w=1 nf=1 m=1
M25 VB6 VB4 VB3 VSS nch l=0.15 w=1 nf=1 m=1
M26 VB5 VB5 net4 VSS nch l=0.15 w=1 nf=1 m=1
M27 VB3 net2 VSS VSS nch l=0.15 w=1 nf=1 m=1
M28 VB4 VB3 VSS VSS nch l=0.15 w=1 nf=1 m=1
M29 net4 VB5 VSS VSS nch l=0.15 w=1 nf=1 m=1
M5 net1 VB2 VDD VDD pch l=0.15 w=1 nf=1 m=1
M6 net9 VC VDD VDD pch l=0.15 w=1 nf=1 m=1
M7 net6 VC VDD VDD pch l=0.15 w=1 nf=1 m=1
M8 OUT VB1 net9 VDD pch l=0.15 w=1 nf=1 m=1
M9 VC VB1 net6 VDD pch l=0.15 w=1 nf=1 m=1
.ends opamp

.subckt dut VDD VSS Vout VB1 VB2
M1 X net2 VDD VDD pch l=0.15 w=1 nf=1 m=1
M2 Vout net2 VDD VDD pch l=0.15 w=1 nf=1 m=1
M3 net1 net2 VDD VDD pch l=0.15 w=1 nf=1 m=1
M4 net3 net2 VDD VDD pch l=0.15 w=1 nf=1 m=1
Q1 VSS VSS net1 qpnp m=1
Q2 VSS net1 X qpnp m=1
Q3 VSS VSS net3 qpnp m=1
Q4 VSS net3 net0 qpnp m=1
R1 Y net0 1k
R2 Vout Y 1k
X1 VDD VSS VB1 VB2 net2 X Y net0 opamp
.ends dut
