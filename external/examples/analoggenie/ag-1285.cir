* official Analog Canvas netlist; PDK X cards rewritten by convert.py
.model nch nmos
.model pch pmos

.subckt dut VDD VSS VIN VCONT1 VCONT2 VCONT3 VCONT4 VCONT5 VP VB3 VREF
.model DIODE D(IS=1e-14 N=1)
CFLY VX1 VX2 1p
CO VP VN 1p
COP VP VSS 1p
D1 VN VX2 DIODE
L1 VX1 VX3 1n
M1 VX1 VCONT2 VIN VDD pch l=0.15 w=1 nf=1 m=1
M2 VX2 VCONT3 VIN VDD pch l=0.15 w=1 nf=1 m=1
M3 VX3 VCONT5 VP VDD pch l=0.15 w=1 nf=1 m=1
M4 VX3 VCONT4 VSS VSS nch l=0.15 w=1 nf=1 m=1
M5 net9 VCONT1 VIN VDD pch l=0.15 w=1 nf=1 m=1
MN1 net4 VFP1 net8 VSS nch l=0.15 w=1 nf=1 m=1
MN10 net5 net0 VSS VSS nch l=0.15 w=1 nf=1 m=1
MN11 net0 net0 VSS VSS nch l=0.15 w=1 nf=1 m=1
MN12 net2 net3 VSS VSS nch l=0.15 w=1 nf=1 m=1
MN13 net3 net3 VSS VSS nch l=0.15 w=1 nf=1 m=1
MN2 VX3 VREF net8 VSS nch l=0.15 w=1 nf=1 m=1
MN3 VBN VBN VSS VSS nch l=0.15 w=1 nf=1 m=1
MN4 net8 VBN VSS VSS nch l=0.15 w=1 nf=1 m=1
MN5 net6 net6 VSS VSS nch l=0.15 w=1 nf=1 m=1
MN6 VCTRL net6 VSS VSS nch l=0.15 w=1 nf=1 m=1
MN7 net7 net7 VSS VSS nch l=0.15 w=1 nf=1 m=1
MN8 net1 net7 VSS VSS nch l=0.15 w=1 nf=1 m=1
MN9 net7 VB3 VSS VSS nch l=0.15 w=1 nf=1 m=1
MP1 net4 net4 VDD VDD pch l=0.15 w=1 nf=1 m=1
MP10 net0 net2 VDD VDD pch l=0.15 w=1 nf=1 m=1
MP11 net2 net2 VDD VDD pch l=0.15 w=1 nf=1 m=1
MP12 net3 net2 VDD VDD pch l=0.15 w=1 nf=1 m=1
MP2 VX3 VX3 VDD VDD pch l=0.15 w=1 nf=1 m=1
MP3 net6 net4 VDD VDD pch l=0.15 w=1 nf=1 m=1
MP4 VCTRL VX3 VDD VDD pch l=0.15 w=1 nf=1 m=1
MP5 net1 net1 net9 VDD pch l=0.15 w=1 nf=1 m=1
MP6 VX1 net1 net9 VDD pch l=0.15 w=1 nf=1 m=1
MP7 net7 VCTRL net9 VDD pch l=0.15 w=1 nf=1 m=1
MP8 VBN net5 VDD VDD pch l=0.15 w=1 nf=1 m=1
MP9 net5 net5 VDD VDD pch l=0.15 w=1 nf=1 m=1
R1 VP VFP1 1k
R2 VFP1 VSS 1k
.ends dut
