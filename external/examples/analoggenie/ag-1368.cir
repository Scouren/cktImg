* official Analog Canvas netlist; PDK X cards rewritten by convert.py
.model nch nmos
.model pch pmos

.subckt comparator VDD VSS VB1 Vin Vo VB2 VB3
M1 net1 VX VDD VDD pch l=0.15 w=1 nf=1 m=1
M10 net11 net8 VSS VSS nch l=0.15 w=1 nf=1 m=1
M11 net6 VX VDD VDD pch l=0.15 w=1 nf=1 m=1
M12 VX VB1 net6 VDD pch l=0.15 w=1 nf=1 m=1
M13 VX VBN net12 VSS nch l=0.15 w=1 nf=1 m=1
M14 net12 net8 VSS VSS nch l=0.15 w=1 nf=1 m=1
M15 net4 VB2 VDD VDD pch l=0.15 w=1 nf=1 m=1
M16 VBN net5 VDD VDD pch l=0.15 w=1 nf=1 m=1
M17 net5 net5 VDD VDD pch l=0.15 w=1 nf=1 m=1
M18 VB3 net5 VDD VDD pch l=0.15 w=1 nf=1 m=1
M19 VBN VBN net10 VSS nch l=0.15 w=1 nf=1 m=1
M2 Vo VB1 net1 VDD pch l=0.15 w=1 nf=1 m=1
M20 net10 VBN VSS VSS nch l=0.15 w=1 nf=1 m=1
M21 net5 VB3 net7 VSS nch l=0.15 w=1 nf=1 m=1
M22 VB3 VB3 VSS VSS nch l=0.15 w=1 nf=1 m=1
M3 Vo VBN net9 VSS nch l=0.15 w=1 nf=1 m=1
M4 net9 net0 VSS VSS nch l=0.15 w=1 nf=1 m=1
M5 net0 Vin net4 net2 pch l=0.15 w=1 nf=1 m=1
M6 net0 VBN net3 VSS nch l=0.15 w=1 nf=1 m=1
M7 net3 net0 VSS VSS nch l=0.15 w=1 nf=1 m=1
M8 net8 Vo net4 net2 pch l=0.15 w=1 nf=1 m=1
M9 net8 VBN net11 VSS nch l=0.15 w=1 nf=1 m=1
R1 net7 VSS 1k
.ends comparator

.subckt dut VDD VSS VSTO VCONT1 VCONT2 VCONT3 VOUT VB1 VB2 VB3
CL VOUT VSS 1p
CSTO VSTO VSS 1p
LRX net0 net1 1n
MN1 net0 VCONT2 VSS VSS nch l=0.15 w=1 nf=1 m=1
MN2 net1 VCONT3 VSS VSS nch l=0.15 w=1 nf=1 m=1
MP2 net1 net2 VOUT VOUT pch l=0.15 w=1 nf=1 m=1
MP3 net0 VCONT1 VSTO VSTO pch l=0.15 w=1 nf=1 m=1
X1 VDD VSS VB1 net1 net2 VB2 VB3 comparator
.ends dut
