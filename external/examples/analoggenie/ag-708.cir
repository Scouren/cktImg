* official Analog Canvas netlist; PDK X cards rewritten by convert.py
.model nch nmos
.model pch pmos

.subckt dut VDD VSS Vbias Vb
CC net1 net2 1p
M11 net0 Vbias VDD VDD pch l=0.15 w=15 nf=1 m=1
M12 net0 net0 Va VSS nch l=0.15 w=6 nf=1 m=1
M13 Va Va VSS VSS nch l=0.15 w=6 nf=1 m=1
M6 net2 Vbias VDD VDD pch l=0.15 w=45 nf=1 m=1
M7 net2 Vb VSS VSS nch l=0.15 w=18 nf=1 m=1
M9 net1 net0 Vb VSS nch l=0.15 w=1 nf=1 m=1
.ends dut
