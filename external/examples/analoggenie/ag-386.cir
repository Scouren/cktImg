* official Analog Canvas netlist; PDK X cards rewritten by convert.py
.model nch nmos
.model pch pmos

.subckt dut VDD VSS Vin CK CK_bar Vout
CH Vout VSS 1p
M1 Vout CK Vin VSS nch l=0.15 w=1 nf=1 m=1
M2 Vin CK_bar Vout VDD pch l=0.15 w=1 nf=1 m=1
.ends dut
