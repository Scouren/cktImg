* official Analog Canvas netlist; PDK X cards rewritten by convert.py
.model nch nmos
.model pch pmos

.subckt CMP VDD VSS INN OUT LX VB1
M10 net2 net2 VSS VSS nch l=0.15 w=1 nf=1 m=1
M11 net2 VA VDD VDD pch l=0.15 w=1 nf=1 m=1
M12 net1 VB2 VSS VSS nch l=0.15 w=1 nf=1 m=1
M13 VB2 VB1 VDD VDD pch l=0.15 w=1 nf=1 m=1
M14 VB1 VB1 VDD VDD pch l=0.15 w=1 nf=1 m=1
M15 VB2 VB2 VSS VSS nch l=0.15 w=1 nf=1 m=1
M16 VB1 net0 VSS VSS nch l=0.15 w=1 nf=1 m=1
M17 net0 LX VDD VDD pch l=0.15 w=1 nf=1 m=1
M18 net0 net0 VSS VSS nch l=0.15 w=1 nf=1 m=1
M19 LX net0 VSS VSS nch l=0.15 w=1 nf=1 m=1
M4 VA VA VDD VDD pch l=0.15 w=1 nf=1 m=1
M5 VA INN net1 VSS nch l=0.15 w=1 nf=1 m=1
M6 OUT OUT VDD VDD pch l=0.15 w=1 nf=1 m=1
M7 OUT OUT VDD VDD pch l=0.15 w=1 nf=1 m=1
M8 OUT OUT net1 VSS nch l=0.15 w=1 nf=1 m=1
M9 OUT net2 VSS VSS nch l=0.15 w=1 nf=1 m=1
R1 VDD net0 1k
R2 VDD LX 1k
.ends CMP

.subckt dut VDD VSS VSTO VCONT1 VCONT2 VCONT3 VOUT VB1
CL VOUT VSS 1p
CSTO VSTO VSS 1p
LRX LX net0 1n
MN1 LX VCONT2 VSS VSS nch l=0.15 w=1 nf=1 m=1
MN2 net0 VCONT3 VSS VSS nch l=0.15 w=1 nf=1 m=1
MP2 net0 net1 VOUT VDD pch l=0.15 w=1 nf=1 m=1
MP3 LX VCONT1 VSTO VDD pch l=0.15 w=1 nf=1 m=1
X1 VDD VSS net0 net1 LX VB1 CMP
.ends dut
