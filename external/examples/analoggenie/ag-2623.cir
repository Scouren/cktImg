* official Analog Canvas netlist; PDK X cards rewritten by convert.py
.model nch nmos
.model pch pmos

.subckt amp1 VDD VSS OUT INP INN
M10 INN INP net2 VSS nch l=0.15 w=1 nf=1 m=1
M11 net5 INN net2 VSS nch l=0.15 w=1 nf=1 m=1
M12 net2 VBN VSS VSS nch l=0.15 w=1 nf=1 m=1
M13 OUT net3 VSS VSS nch l=0.15 w=1 nf=1 m=1
M14 net3 net3 VSS VSS nch l=0.15 w=1 nf=1 m=1
M15 net4 net4 VDD VDD pch l=0.15 w=1 nf=1 m=1
M16 VBN net4 VDD VDD pch l=0.15 w=1 nf=1 m=1
M17 VB1 VB1 VDD VDD pch l=0.15 w=1 nf=1 m=1
M18 net4 VX VSS VSS nch l=0.15 w=1 nf=1 m=1
M19 VBN VBN VSS VSS nch l=0.15 w=1 nf=1 m=1
M20 VB1 VBN VSS VSS nch l=0.15 w=1 nf=1 m=1
M21 net1 VB2 VDD VDD pch l=0.15 w=1 nf=1 m=1
M22 VB2 VB2 VDD VDD pch l=0.15 w=1 nf=1 m=1
M23 VX VB2 VDD VDD pch l=0.15 w=1 nf=1 m=1
M24 VB2 VX net0 VSS nch l=0.15 w=1 nf=1 m=1
M25 VX VX VSS VSS nch l=0.15 w=1 nf=1 m=1
M26 net1 net1 VSS VSS nch l=0.15 w=1 nf=1 m=1
M27 net0 net1 VSS VSS nch l=0.15 w=1 nf=1 m=1
M6 OUT INN VDD VDD pch l=0.15 w=1 nf=1 m=1
M7 INN INN VDD VDD pch l=0.15 w=1 nf=1 m=1
M8 net5 net5 VDD VDD pch l=0.15 w=1 nf=1 m=1
M9 net3 net5 VDD VDD pch l=0.15 w=1 nf=1 m=1
.ends amp1

.subckt dut VDD VSS Vref biasp biascas biasn Vout
C1 Vset VSS 1p
C2 n3 Vout 1p
M1 Vout n3 VDD VDD pch l=0.15 w=1 nf=1 m=1
M2 n1 Vset Vout VDD pch l=0.15 w=1 nf=1 m=1
M3 n1 biasn VSS VSS nch l=0.15 w=1 nf=1 m=1
M4 n3 biasp VDD VDD pch l=0.15 w=1 nf=1 m=1
M5 n3 biascas n1 VSS nch l=0.15 w=1 nf=1 m=1
R1 fb VSS 1k
R2 Vout fb 1k
X1 VDD VSS Vset Vref fb amp1
.ends dut
