* official Analog Canvas netlist; PDK X cards rewritten by convert.py
.model nch nmos
.model pch pmos

.subckt bias VDD VSS VBN1 VBN2
M23 net0 net1 VDD VDD pch l=0.15 w=1 nf=1 m=1
M24 net1 net1 VDD VDD pch l=0.15 w=1 nf=1 m=1
M25 net2 net0 VSS VSS nch l=0.15 w=1 nf=1 m=1
M26 net1 net0 VSS VSS nch l=0.15 w=1 nf=1 m=1
M27 VBN1 net1 VDD VDD pch l=0.15 w=1 nf=1 m=1
M28 VBN1 VBN1 VBN2 VSS nch l=0.15 w=1 nf=1 m=1
M29 VBN2 VBN2 VSS VSS nch l=0.15 w=1 nf=1 m=1
R4 net0 net2 1k
.ends bias

.subckt dut VDD VSS VB1 VREF VB4 IBUF VIN VOUT
CL VOUT net5 1p
M10 EAO VB2 net0 VDD pch l=0.15 w=1 nf=1 m=1
M11 net7 VX VDD VDD pch l=0.15 w=1 nf=1 m=1
M12 net0 VX VDD VDD pch l=0.15 w=1 nf=1 m=1
M13 net2 VB4 VDD VDD pch l=0.15 w=1 nf=1 m=1
M14 VX EAO net2 VDD pch l=0.15 w=1 nf=1 m=1
M15 VX VX VSS VSS nch l=0.15 w=1 nf=1 m=1
M16 net1 VX VSS VSS nch l=0.15 w=1 nf=1 m=1
M17 VDD net2 net1 VSS nch l=0.15 w=1 nf=1 m=1
M18 net0 EAO IBUF VSS nch l=0.15 w=1 nf=1 m=1
M19 net0 net0 VDD VDD pch l=0.15 w=1 nf=1 m=1
M2 net6 VB1 VDD VDD pch l=0.15 w=1 nf=1 m=1
M20 net1 net0 VDD VDD pch l=0.15 w=1 nf=1 m=1
M21 VSS IBUF net1 VDD pch l=0.15 w=1 nf=1 m=1
M3 net3 VREF net6 VDD pch l=0.15 w=1 nf=1 m=1
M4 net4 FB net6 VDD pch l=0.15 w=1 nf=1 m=1
M5 net3 VBN2 VSS VSS nch l=0.15 w=1 nf=1 m=1
M6 net4 VBN2 VSS VSS nch l=0.15 w=1 nf=1 m=1
M7 VX VBN1 net3 VSS nch l=0.15 w=1 nf=1 m=1
M8 EAO VBN1 net4 VSS nch l=0.15 w=1 nf=1 m=1
M9 VX VB2 net7 VDD pch l=0.15 w=1 nf=1 m=1
MNP VIN net1 VOUT VSS nch l=0.15 w=1 nf=1 m=1
R1 FB VSS 1k
R2 VOUT FB 1k
R3 net5 VSS 1k
RL VOUT VSS 1k
X1 VDD VSS VBN1 VBN2 bias
.ends dut
