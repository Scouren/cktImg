* official Analog Canvas netlist; PDK X cards rewritten by convert.py
.model nch nmos
.model qnpn npn

.subckt opamp_differential VDD VSS VIP VIN VOP VON params: gain=1e6 vocm=0
VCM ncm 0 DC {vocm}
EPLUS VOP ncm VIP VIN {gain/2}
EMINUS VON ncm VIN VIP {gain/2}
.ends opamp_differential

.subckt dut Vdd Vbuf VSS Vtune OUT+ OUT- Vpd
C1 Vpd VSS 1p
Cp net0 VSS 1p
Iref Vdd Vb DC 1m
L1 Von Vdd 3nH
L2 Vdd Vop 3nH
M1 Von Vop net0 VSS nch l=0.25 w=120 nf=1 m=1
M2 Vop Von net0 VSS nch l=0.25 w=120 nf=1 m=1
M3 net0 Vb VSS VSS nch l=0.15 w=1 nf=1 m=1
M4 Vb Vb VSS VSS nch l=0.15 w=1 nf=1 m=1
M5 Vtune Von Vtune VSS nch l=0.15 w=1 nf=1 m=1
M6 Vtune Vop Vtune VSS nch l=0.15 w=1 nf=1 m=1
M7 Vpd Vb VSS VSS nch l=0.15 w=1 nf=1 m=1
Q1 Vbuf Von Vpd VSS qnpn m=1
Q2 Vbuf Vop Vpd VSS qnpn m=1
X1 Vbuf VSS Vop Von OUT+ OUT- opamp_differential gain=1e6
.ends dut
