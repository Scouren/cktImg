* official Analog Canvas netlist; PDK X cards rewritten by convert.py
.model nch nmos
.model pch pmos

.subckt dut VDD VSS VB1 VB2 VREF VB3 VB4 IBUF VIN VOUT
CL VOUT net6 1p
M1 VBN net8 VDD VDD pch l=0.15 w=1 nf=1 m=1
M10 EAO VB1 net11 VDD pch l=0.15 w=1 nf=1 m=1
M11 net1 net9 VDD VDD pch l=0.15 w=1 nf=1 m=1
M12 net11 net5 VDD VDD pch l=0.15 w=1 nf=1 m=1
M13 VX VB4 VDD VDD pch l=0.15 w=1 nf=1 m=1
M14 net2 EAO VX VDD pch l=0.15 w=1 nf=1 m=1
M15 net2 net2 VSS VSS nch l=0.15 w=1 nf=1 m=1
M16 net3 net2 VSS VSS nch l=0.15 w=1 nf=1 m=1
M17 VDD VX net3 VSS nch l=0.15 w=1 nf=1 m=1
M18 net0 EAO IBUF VSS nch l=0.15 w=1 nf=1 m=1
M19 net0 net0 VDD VDD pch l=0.15 w=1 nf=1 m=1
M2 VX VB2 VSS VSS nch l=0.15 w=1 nf=1 m=1
M20 net3 net0 VDD VDD pch l=0.15 w=1 nf=1 m=1
M21 VSS IBUF net3 VDD pch l=0.15 w=1 nf=1 m=1
M22 net4 net9 VDD VDD pch l=0.15 w=1 nf=1 m=1
M23 net9 VB1 net4 VDD pch l=0.15 w=1 nf=1 m=1
M24 net10 net5 VDD VDD pch l=0.15 w=1 nf=1 m=1
M25 net5 VB1 net10 VDD pch l=0.15 w=1 nf=1 m=1
M26 VBN VBN net14 VSS nch l=0.15 w=1 nf=1 m=1
M27 net14 VBN VSS VSS nch l=0.15 w=1 nf=1 m=1
M28 net8 net8 VDD VDD pch l=0.15 w=1 nf=1 m=1
M29 net8 VB3 VSS VSS nch l=0.15 w=1 nf=1 m=1
M3 net5 VREF VX VSS nch l=0.15 w=1 nf=1 m=1
M30 VB3 net8 VDD VDD pch l=0.15 w=1 nf=1 m=1
M31 net13 VB3 VSS VSS nch l=0.15 w=1 nf=1 m=1
M4 net9 FB VX VSS nch l=0.15 w=1 nf=1 m=1
M5 net12 VC VSS VSS nch l=0.15 w=1 nf=1 m=1
M6 net7 VC VSS VSS nch l=0.15 w=1 nf=1 m=1
M7 VC VBN net12 VSS nch l=0.15 w=1 nf=1 m=1
M8 EAO VBN net7 VSS nch l=0.15 w=1 nf=1 m=1
M9 VC VB1 net1 VDD pch l=0.15 w=1 nf=1 m=1
MNP VIN net3 VOUT VSS nch l=0.15 w=1 nf=1 m=1
R1 FB VSS 1k
R2 VOUT FB 1k
R3 VB3 net13 1k
R4 net6 VSS 1k
RL VOUT VSS 1k
.ends dut
