* official Analog Canvas netlist; PDK X cards rewritten by convert.py
.model nch nmos
.model pch pmos

.subckt AMP1 VDD VSS INP INN OUT
M1 INN INN VDD VDD pch l=0.15 w=1 nf=1 m=1
M10 net0 net0 VDD VDD pch l=0.15 w=1 nf=1 m=1
M11 net3 net0 VDD VDD pch l=0.15 w=1 nf=1 m=1
M12 net0 net3 VSS VSS nch l=0.15 w=1 nf=1 m=1
M13 net3 net3 VSS VSS nch l=0.15 w=1 nf=1 m=1
M14 net1 net1 VDD VDD pch l=0.15 w=1 nf=1 m=1
M15 VN net1 VDD VDD pch l=0.15 w=1 nf=1 m=1
M16 net1 net3 VSS VSS nch l=0.15 w=1 nf=1 m=1
M17 VN VN VSS VSS nch l=0.15 w=1 nf=1 m=1
M2 net2 net2 VDD VDD pch l=0.15 w=1 nf=1 m=1
M3 INN INP net4 VSS nch l=0.15 w=1 nf=1 m=1
M4 net2 INN net4 VSS nch l=0.15 w=1 nf=1 m=1
M5 OUT INN VDD VDD pch l=0.15 w=1 nf=1 m=1
M6 net0 net2 VDD VDD pch l=0.15 w=1 nf=1 m=1
M7 OUT net0 VSS VSS nch l=0.15 w=1 nf=1 m=1
M8 net0 net0 VSS VSS nch l=0.15 w=1 nf=1 m=1
M9 net4 VN VSS VSS nch l=0.15 w=1 nf=1 m=1
R3 VDD net3 1k
.ends AMP1

.subckt dut VDD VSS Vref Vout biasp biascas biasn
C1 Vset VSS 1p
C2 n3 Vout 1p
M1 Vout n3 VDD VDD pch l=0.15 w=1 nf=1 m=1
M2 n1 Vset Vout VDD pch l=0.15 w=1 nf=1 m=1
M3 n1 biasn VSS VSS nch l=0.15 w=1 nf=1 m=1
M4 n3 biasp VDD VDD pch l=0.15 w=1 nf=1 m=1
M5 n3 biascas n1 VSS nch l=0.15 w=1 nf=1 m=1
R1 fb VSS 1k
R2 Vout fb 1k
X1 VDD VSS Vref fb Vset AMP1
.ends dut
