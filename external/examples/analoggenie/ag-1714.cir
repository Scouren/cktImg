* official Analog Canvas netlist; PDK X cards rewritten by convert.py
.model nch nmos
.model pch pmos
.model qpnp pnp

.subckt dut VDD VSS Vout VB1
M1 net5 net5 VDD VDD pch l=0.15 w=1 nf=1 m=1
M10 net4 net4 net0 VSS nch l=0.15 w=1 nf=1 m=1
M11 VB1 net4 VSS VSS nch l=0.15 w=1 nf=1 m=1
M12 VB1 VB1 VDD VDD pch l=0.15 w=1 nf=1 m=1
M13 VB2 VB1 VDD VDD pch l=0.15 w=1 nf=1 m=1
M14 VB2 VB2 VSS VSS nch l=0.15 w=1 nf=1 m=1
M2 net1 net1 VDD VDD pch l=0.15 w=1 nf=1 m=1
M3 net1 Y net6 VSS nch l=0.15 w=1 nf=1 m=1
M4 net5 X net6 VSS nch l=0.15 w=1 nf=1 m=1
M5 Vout net5 VDD VDD pch l=0.15 w=1 nf=1 m=1
M6 net3 net1 VDD VDD pch l=0.15 w=1 nf=1 m=1
M7 net6 VB2 VSS VSS nch l=0.15 w=1 nf=1 m=1
M8 net3 net3 VSS VSS nch l=0.15 w=1 nf=1 m=1
M9 Vout net3 VSS VSS nch l=0.15 w=1 nf=1 m=1
Q1 VSS VSS net2 qpnp m=1
Q2 net2 net2 X qpnp m=1
Q3 VSS VSS net8 qpnp m=1
Q4 net8 net8 net7 qpnp m=1
R1 Vout X 1k
R2 Vout Y 1k
R3 Y net7 1k
R4 VDD net4 1k
R5 net0 VSS 1k
.ends dut
