* official Analog Canvas netlist; PDK X cards rewritten by convert.py
.model nch nmos
.model pch pmos

.subckt opamp VDD VSS INP INN OUT
M1 net3 VB1 VDD VDD pch l=0.15 w=1 nf=1 m=1
M10 net6 net5 VSS VSS nch l=0.15 w=1 nf=1 m=1
M11 OUT VB2 VSS VSS nch l=0.15 w=1 nf=1 m=1
M12 VB5 VB6 VDD VDD pch l=0.15 w=1 nf=1 m=1
M13 VB5 VB5 net2 VSS nch l=0.15 w=1 nf=1 m=1
M14 net2 VB5 VSS VSS nch l=0.15 w=1 nf=1 m=1
M15 net4 VB6 VDD VDD pch l=0.15 w=1 nf=1 m=1
M16 net4 net4 VSS VSS nch l=0.15 w=1 nf=1 m=1
M17 VB6 VB6 VDD VDD pch l=0.15 w=1 nf=1 m=1
M18 VB6 VB4 net1 VSS nch l=0.15 w=1 nf=1 m=1
M19 net1 net4 VSS VSS nch l=0.15 w=1 nf=1 m=1
M2 net0 VB1 VDD VDD pch l=0.15 w=1 nf=1 m=1
M20 VB4 VB6 VDD VDD pch l=0.15 w=1 nf=1 m=1
M21 VB4 VB4 VSS VSS nch l=0.15 w=1 nf=1 m=1
M3 net3 INP OUT VSS nch l=0.15 w=1 nf=1 m=1
M4 net0 INN OUT VSS nch l=0.15 w=1 nf=1 m=1
M5 OUT VB3 net3 VDD pch l=0.15 w=1 nf=1 m=1
M6 net5 VB3 net0 VDD pch l=0.15 w=1 nf=1 m=1
M7 OUT VB5 net7 VSS nch l=0.15 w=1 nf=1 m=1
M8 net5 VB5 net6 VSS nch l=0.15 w=1 nf=1 m=1
M9 net7 net5 VSS VSS nch l=0.15 w=1 nf=1 m=1
.ends opamp

.subckt dut VDD VSS VIN VOUT Vref
CL VOUT net1 1p
MNP VIN net0 VOUT VSS nch l=0.15 w=1 nf=1 m=1
R1 VOUT FB 1k
R2 FB VSS 1k
R3 net1 VSS 1k
X1 VDD VSS Vref FB net0 opamp
.ends dut
