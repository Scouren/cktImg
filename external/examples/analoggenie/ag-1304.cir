* official Analog Canvas netlist; PDK X cards rewritten by convert.py
.model nch nmos
.model pch pmos

.subckt dut VDD VSS VCONT1 VCONT2 VCONT3 VIN VCONT4 VCONT5 VP VB2
.model DIODE D(IS=1e-14 N=1)
CFLY VX1 VX2 1p
CO VP VN 1p
COP VP VSS 1p
D1 VN VX2 DIODE
L1 VX1 VX3 1n
M1 VX1 VCONT2 VIN VDD pch l=0.15 w=1 nf=1 m=1
M2 VX2 VCONT3 VIN VDD pch l=0.15 w=1 nf=1 m=1
M3 VP VCONT5 VX3 VDD pch l=0.15 w=1 nf=1 m=1
M4 VX3 VCONT4 VSS VSS nch l=0.15 w=1 nf=1 m=1
M5 VS VCONT1 VIN VDD pch l=0.15 w=1 nf=1 m=1
MN1 net3 net3 VSS VSS nch l=0.15 w=1 nf=1 m=1
MN10 net2 net4 VSS VSS nch l=0.15 w=1 nf=1 m=1
MN2 VX2 VX2 VSS VSS nch l=0.15 w=1 nf=1 m=1
MN3 net0 net3 VSS VSS nch l=0.15 w=1 nf=1 m=1
MN4 net1 VX2 VSS VSS nch l=0.15 w=1 nf=1 m=1
MN5 VBP net6 VSS VSS nch l=0.15 w=1 nf=1 m=1
MN6 net6 net6 net7 VSS nch l=0.15 w=1 nf=1 m=1
MN7 VB1 VB1 VSS VSS nch l=0.15 w=1 nf=1 m=1
MN8 net4 net4 VSS VSS nch l=0.15 w=1 nf=1 m=1
MN9 net4 VB2 VSS VSS nch l=0.15 w=1 nf=1 m=1
MP1 net3 VFP1 net5 VDD pch l=0.15 w=1 nf=1 m=1
MP10 VX1 net2 VS VDD pch l=0.15 w=1 nf=1 m=1
MP2 VX2 VREF net5 VDD pch l=0.15 w=1 nf=1 m=1
MP3 net5 VBP VDD VDD pch l=0.15 w=1 nf=1 m=1
MP4 net1 net1 VDD VDD pch l=0.15 w=1 nf=1 m=1
MP5 net0 net1 VDD VDD pch l=0.15 w=1 nf=1 m=1
MP6 VBP VBP VDD VDD pch l=0.15 w=1 nf=1 m=1
MP7 VB1 VBP VDD VDD pch l=0.15 w=1 nf=1 m=1
MP8 net4 net0 VS VDD pch l=0.15 w=1 nf=1 m=1
MP9 net2 net2 VS VDD pch l=0.15 w=1 nf=1 m=1
R1 VP VFP1 1k
R2 VFP1 VSS 1k
RBIAS net7 VSS 1k
RF VDD net6 1k
.ends dut
