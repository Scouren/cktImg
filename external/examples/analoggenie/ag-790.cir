* official Analog Canvas netlist; PDK X cards rewritten by convert.py
.model nch nmos
.model pch pmos

.subckt opamp VDD VSS VB3 INP INN IB1 VB1 VB2 OUT
M10 OUT VB1 net4 VDD pch l=0.15 w=1 nf=1 m=1
M11 net0 VB2 net2 VSS nch l=0.15 w=1 nf=1 m=1
M12 OUT VB2 net1 VSS nch l=0.15 w=1 nf=1 m=1
M13 net2 net0 VSS VSS nch l=0.15 w=1 nf=1 m=1
M14 net1 net0 VSS VSS nch l=0.15 w=1 nf=1 m=1
M5 net3 INP IB1 VSS nch l=0.15 w=1 nf=1 m=1
M6 net4 INN IB1 VSS nch l=0.15 w=1 nf=1 m=1
M7 net3 VB3 VDD VDD pch l=0.15 w=1 nf=1 m=1
M8 net4 VB3 VDD VDD pch l=0.15 w=1 nf=1 m=1
M9 net0 VB1 net3 VDD pch l=0.15 w=1 nf=1 m=1
.ends opamp

.subckt dut VDD VSS vci phi1 phi2 vco VB1 VB2 VB3 IB1
C1 net1 net0 1p
C2 net2 vco 1p
M1 vci phi1 net1 VSS nch l=0.15 w=1 nf=1 m=1
M2 net1 phi2 VSS VSS nch l=0.15 w=1 nf=1 m=1
M3 net0 phi1 VSS VSS nch l=0.15 w=1 nf=1 m=1
M4 net0 phi2 net2 VSS nch l=0.15 w=1 nf=1 m=1
X1 VDD VSS VB3 VSS net2 IB1 VB1 VB2 vco opamp
.ends dut
