* official Analog Canvas netlist; PDK X cards rewritten by convert.py
.model nch nmos

.subckt dut VDD VSS Vin1 Vin2 Vb
M1 net2 Y P VSS nch l=0.15 w=1 nf=1 m=1
M2 net0 X P VSS nch l=0.15 w=1 nf=1 m=1
M3 X Vin1 net1 VSS nch l=0.15 w=1 nf=1 m=1
M4 Y Vin2 net1 VSS nch l=0.15 w=1 nf=1 m=1
M5 net1 Vb VSS VSS nch l=0.15 w=1 nf=1 m=1
M6 P Vb VSS VSS nch l=0.15 w=1 nf=1 m=1
RP1 VDD X 1k
RP2 VDD Y 1k
RP3 VDD net2 1k
RP4 VDD net0 1k
.ends dut
