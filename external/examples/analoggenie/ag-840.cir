* official Analog Canvas netlist; PDK X cards rewritten by convert.py
.model qnpn npn

.subckt dut VCC VSS VIN VOUT
IIN VCC VIN DC 1m
Q1 net0 net0 VSS VSS qnpn m=1
Q2 VOUT VIN net0 VSS qnpn m=1
Q3 VIN net0 VSS VSS qnpn m=1
.ends dut
