* official Analog Canvas netlist; PDK X cards rewritten by convert.py
.model nch nmos
.model pch pmos
.model qpnp pnp

.subckt A1 VDD VSS VB1 VZ X VB2 Y VG VB3
M10 VC VB1 net6 VDD pch l=0.15 w=1 nf=1 m=1
M11 Y VB1 net0 VDD pch l=0.15 w=1 nf=1 m=1
M12 VG VB1 net1 VDD pch l=0.15 w=1 nf=1 m=1
M13 VZ X net2 VSS nch l=0.15 w=1 nf=1 m=1
M14 VC Y net2 VSS nch l=0.15 w=1 nf=1 m=1
M15 net2 VB2 VSS VSS nch l=0.15 w=1 nf=1 m=1
M16 Y VN net7 VSS nch l=0.15 w=1 nf=1 m=1
M17 net7 Y VSS VSS nch l=0.15 w=1 nf=1 m=1
M18 VG VN net3 VSS nch l=0.15 w=1 nf=1 m=1
M19 net3 Y VSS VSS nch l=0.15 w=1 nf=1 m=1
M20 VP VP VDD VDD pch l=0.15 w=1 nf=1 m=1
M21 VZ VP VDD VDD pch l=0.15 w=1 nf=1 m=1
M22 VN VP VDD VDD pch l=0.15 w=1 nf=1 m=1
M23 VP VZ VB3 VSS nch l=0.15 w=1 nf=1 m=1
M24 VZ VB3 VSS VSS nch l=0.15 w=1 nf=1 m=1
M25 VN VN net5 VSS nch l=0.15 w=1 nf=1 m=1
M26 net5 VN VSS VSS nch l=0.15 w=1 nf=1 m=1
M5 net4 VZ VDD VDD pch l=0.15 w=1 nf=1 m=1
M6 net6 VC VDD VDD pch l=0.15 w=1 nf=1 m=1
M7 net0 VZ VDD VDD pch l=0.15 w=1 nf=1 m=1
M8 net1 VC VDD VDD pch l=0.15 w=1 nf=1 m=1
M9 VZ VB1 net4 VDD pch l=0.15 w=1 nf=1 m=1
R3 VB3 VSS 1k
.ends A1

.subckt dut VDD VSS Vout VB1 VB2 VB3
M1 X VG VDD VDD pch l=0.15 w=1 nf=1 m=1
M2 Vout VG VDD VDD pch l=0.15 w=1 nf=1 m=1
M3 net1 VG VDD VDD pch l=0.15 w=1 nf=1 m=1
M4 VZ VG VDD VDD pch l=0.15 w=1 nf=1 m=1
Q1 VSS VSS net1 qpnp m=1
Q2 VSS net1 X qpnp m=1
Q3 VSS VSS VZ qpnp m=1
Q4 VSS VZ net0 qpnp m=1
R1 Y net0 1k
R2 Vout Y 1k
X1 VDD VSS VB1 VZ X VB2 Y VG VB3 A1
.ends dut
