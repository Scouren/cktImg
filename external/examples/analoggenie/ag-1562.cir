* official Analog Canvas netlist; PDK X cards rewritten by convert.py
.model nch nmos
.model pch pmos
.model qpnp pnp

.subckt opamp VDD VSS INP INN VB2 VB1 OUT
M1 net7 INN net3 VDD pch l=0.15 w=1 nf=1 m=1
M10 VX VB3 net2 VSS nch l=0.15 w=1 nf=1 m=1
M11 OUT VB3 net5 VSS nch l=0.15 w=1 nf=1 m=1
M12 VX VB1 net4 VDD pch l=0.15 w=1 nf=1 m=1
M13 OUT VB1 net1 VDD pch l=0.15 w=1 nf=1 m=1
M14 net4 VX VDD VDD pch l=0.15 w=1 nf=1 m=1
M15 net1 VX VDD VDD pch l=0.15 w=1 nf=1 m=1
M16 net8 net8 VDD VDD pch l=0.15 w=1 nf=1 m=1
M17 VB3 net8 VDD VDD pch l=0.15 w=1 nf=1 m=1
M18 VB3 VB3 net10 VSS nch l=0.15 w=1 nf=1 m=1
M19 net10 VB3 VSS VSS nch l=0.15 w=1 nf=1 m=1
M2 net9 INP net3 VDD pch l=0.15 w=1 nf=1 m=1
M3 net7 VB3 net6 VSS nch l=0.15 w=1 nf=1 m=1
M4 net9 VB3 net0 VSS nch l=0.15 w=1 nf=1 m=1
M5 net6 net7 VSS VSS nch l=0.15 w=1 nf=1 m=1
M6 net0 net9 VSS VSS nch l=0.15 w=1 nf=1 m=1
M7 net3 VB2 VDD VDD pch l=0.15 w=1 nf=1 m=1
M8 net2 net9 VSS VSS nch l=0.15 w=1 nf=1 m=1
M9 net5 net7 VSS VSS nch l=0.15 w=1 nf=1 m=1
R1 net8 VSS 1k
.ends opamp

.subckt dut VDD VSS VB1 VB2 Vout
Q1 VSS VSS X qpnp m=1
Q2 VSS VSS net0 qpnp m=1
R1 Vout X 1k
R2 Vout Y 1k
R3 Y net0 1k
X1 VDD VSS X Y VB2 VB1 Vout opamp
.ends dut
