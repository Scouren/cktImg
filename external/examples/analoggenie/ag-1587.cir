* official Analog Canvas netlist; PDK X cards rewritten by convert.py
.model nch nmos
.model pch pmos
.model qpnp pnp

.subckt opamp VDD VSS INP INN VB1 VB2 OUT
M1 net5 INP net6 VDD pch l=0.15 w=1 nf=1 m=1
M10 OUT VB4 net1 VSS nch l=0.15 w=1 nf=1 m=1
M11 net1 VB5 VSS VSS nch l=0.15 w=1 nf=1 m=1
M12 net4 net0 VDD VDD pch l=0.15 w=1 nf=1 m=1
M13 net0 net0 VDD VDD pch l=0.15 w=1 nf=1 m=1
M14 VB4 net0 VDD VDD pch l=0.15 w=1 nf=1 m=1
M15 net4 net4 VSS VSS nch l=0.15 w=1 nf=1 m=1
M16 net0 net4 VSS VSS nch l=0.15 w=1 nf=1 m=1
M17 VB4 VB4 VB5 VSS nch l=0.15 w=1 nf=1 m=1
M18 VB5 VB5 VSS VSS nch l=0.15 w=1 nf=1 m=1
M2 net1 INN net6 VDD pch l=0.15 w=1 nf=1 m=1
M3 net2 VX VDD VDD pch l=0.15 w=1 nf=1 m=1
M4 VX VB2 net2 VDD pch l=0.15 w=1 nf=1 m=1
M5 VX VB4 net5 VSS nch l=0.15 w=1 nf=1 m=1
M6 net5 VB5 VSS VSS nch l=0.15 w=1 nf=1 m=1
M7 net6 VB1 VDD VDD pch l=0.15 w=1 nf=1 m=1
M8 net3 VX VDD VDD pch l=0.15 w=1 nf=1 m=1
M9 OUT VB2 net3 VDD pch l=0.15 w=1 nf=1 m=1
.ends opamp

.subckt dut VDD VSS VB1 VB2 Vout
Q1 VSS VSS X qpnp m=1
Q2 VSS VSS net0 qpnp m=1
R1 Vout X 1k
R2 Vout Y 1k
R3 Y net0 1k
X1 VDD VSS X Y VB1 VB2 Vout opamp
.ends dut
