* official Analog Canvas netlist; PDK X cards rewritten by convert.py
.model nch nmos
.model pch pmos

.subckt dut VDD VSS VB2 Vref VB1 VIN VOUT
CL VOUT VX 1p
M1 net2 VB2 VDD VDD pch l=0.15 w=1 nf=1 m=1
M10 net1 VB1 net6 VDD pch l=0.15 w=1 nf=1 m=1
M11 net8 VB1 net0 VDD pch l=0.15 w=1 nf=1 m=1
M12 net1 VB3 net4 VSS nch l=0.15 w=1 nf=1 m=1
M13 net8 VB3 net12 VSS nch l=0.15 w=1 nf=1 m=1
M14 net4 VY VSS VSS nch l=0.15 w=1 nf=1 m=1
M15 net12 VX VSS VSS nch l=0.15 w=1 nf=1 m=1
M16 net7 net7 net11 VDD pch l=0.15 w=1 nf=1 m=1
M17 VB3 net7 VDD VDD pch l=0.15 w=1 nf=1 m=1
M18 VB3 VB3 net10 VSS nch l=0.15 w=1 nf=1 m=1
M19 net10 VB3 VSS VSS nch l=0.15 w=1 nf=1 m=1
M2 VY Vref net2 net3 pch l=0.15 w=1 nf=1 m=1
M3 VX FB net2 net3 pch l=0.15 w=1 nf=1 m=1
M4 VY VB3 net9 VSS nch l=0.15 w=1 nf=1 m=1
M5 VX VB3 net5 VSS nch l=0.15 w=1 nf=1 m=1
M6 net9 VY VSS VSS nch l=0.15 w=1 nf=1 m=1
M7 net5 VX VSS VSS nch l=0.15 w=1 nf=1 m=1
M8 net6 net1 VDD VDD pch l=0.15 w=1 nf=1 m=1
M9 net0 net1 VDD VDD pch l=0.15 w=1 nf=1 m=1
MNP VIN net8 VOUT VOUT nch l=0.15 w=1 nf=1 m=1
R1 VOUT FB 1k
R2 FB VSS 1k
R3 VX VSS 1k
R4 VDD net11 1k
R5 net7 VSS 1k
.ends dut
