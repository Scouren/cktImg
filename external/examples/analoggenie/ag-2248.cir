* official Analog Canvas netlist; PDK X cards rewritten by convert.py
.model nch nmos
.model pch pmos

.subckt opamp VDD VSS INN INP OUT VX
M1 net2 net2 VDD VDD pch l=0.15 w=1 nf=1 m=1
M10 net0 net0 VSS VSS nch l=0.15 w=1 nf=1 m=1
M11 VB1 net0 VSS VSS nch l=0.15 w=1 nf=1 m=1
M12 VB1 VB1 VDD VDD pch l=0.15 w=1 nf=1 m=1
M13 VB2 VB1 VDD VDD pch l=0.15 w=1 nf=1 m=1
M14 VB2 VB2 VSS VSS nch l=0.15 w=1 nf=1 m=1
M2 VX VX VDD VDD pch l=0.15 w=1 nf=1 m=1
M3 VX INN net3 VSS nch l=0.15 w=1 nf=1 m=1
M4 net2 INP net3 VSS nch l=0.15 w=1 nf=1 m=1
M5 OUT net2 VDD VDD pch l=0.15 w=1 nf=1 m=1
M6 net1 VX VDD VDD pch l=0.15 w=1 nf=1 m=1
M7 OUT net1 VSS VSS nch l=0.15 w=1 nf=1 m=1
M8 net1 net1 VSS VSS nch l=0.15 w=1 nf=1 m=1
M9 net3 VB2 VSS VSS nch l=0.15 w=1 nf=1 m=1
R1 VDD net0 1k
.ends opamp

.subckt dut VDD VSS VIN VOUT Vref
CL VOUT VX 1p
MNP VIN net0 VOUT VOUT nch l=0.15 w=1 nf=1 m=1
R1 VOUT FB 1k
R2 FB VSS 1k
R3 VX VSS 1k
X1 VDD VSS FB Vref net0 VX opamp
.ends dut
