* official Analog Canvas netlist; PDK X cards rewritten by convert.py
.model nch nmos
.model pch pmos
.model qpnp pnp

.subckt dut VDD VSS IBIAS
M3 net4 net4 net3 VSS nch l=0.15 w=1 nf=1 m=1
M4 net2 net4 net0 VSS nch l=0.15 w=1 nf=1 m=1
M5 net4 net2 VDD VDD pch l=0.15 w=1 nf=1 m=1
M6 net2 net2 VDD VDD pch l=0.15 w=1 nf=1 m=1
M7 IBIAS net2 VDD VDD pch l=0.15 w=1 nf=1 m=1
Q1 VSS VSS net3 qpnp m=1
Q2 VSS VSS net1 qpnp m=1
R net0 net1 1k
.ends dut
