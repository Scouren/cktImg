* official Analog Canvas netlist; PDK X cards rewritten by convert.py
.model nch nmos
.model pch pmos
.model qpnp pnp

.global VDD

.subckt opamp VSS VB1 VB3 VB2 INN INP OUT
M1 net5 VB1 VDD VDD pch l=0.15 w=1 nf=1 m=1
M10 OUT VB5 net2 VSS nch l=0.15 w=1 nf=1 m=1
M11 net2 VX VSS VSS nch l=0.15 w=1 nf=1 m=1
M12 net6 VP VDD VDD pch l=0.15 w=1 nf=1 m=1
M13 net6 net6 VSS VSS nch l=0.15 w=1 nf=1 m=1
M14 VP VP VDD VDD pch l=0.15 w=1 nf=1 m=1
M15 VP VB4 net0 VSS nch l=0.15 w=1 nf=1 m=1
M16 net0 net6 VSS VSS nch l=0.15 w=1 nf=1 m=1
M17 VB4 VP VDD VDD pch l=0.15 w=1 nf=1 m=1
M18 VB4 VB4 VSS VSS nch l=0.15 w=1 nf=1 m=1
M19 VB5 VP VDD VDD pch l=0.15 w=1 nf=1 m=1
M2 VX VB3 net5 VDD pch l=0.15 w=1 nf=1 m=1
M20 VB5 VB5 net4 VSS nch l=0.15 w=1 nf=1 m=1
M21 net4 VB5 VSS VSS nch l=0.15 w=1 nf=1 m=1
M3 VX VB5 net3 VSS nch l=0.15 w=1 nf=1 m=1
M4 net3 VX VSS VSS nch l=0.15 w=1 nf=1 m=1
M5 net5 INN net7 VSS nch l=0.15 w=1 nf=1 m=1
M6 net1 INP net7 VSS nch l=0.15 w=1 nf=1 m=1
M7 net7 VB2 VSS VSS nch l=0.15 w=1 nf=1 m=1
M8 net1 VB1 VDD VDD pch l=0.15 w=1 nf=1 m=1
M9 OUT VB3 net1 VDD pch l=0.15 w=1 nf=1 m=1
.ends opamp

.subckt dut VSS Vout VB1 VB2 VB3
Q1 VSS VSS net0 qpnp m=1
Q2 VSS VSS net1 qpnp m=1
R1 Vout net0 1k
R2 Vout net2 1k
R3 net2 net1 1k
X1 VSS VB1 VB3 VB2 net2 net0 Vout opamp
.ends dut
