* official Analog Canvas netlist; PDK X cards rewritten by convert.py
.model nch nmos
.model pch pmos
.model qpnp pnp

.subckt opamp VDD VSS INP INN OUT VE
M10 VE VB4 net1 VSS nch l=0.15 w=1 nf=1 m=1
M11 net1 VE VSS VSS nch l=0.15 w=1 nf=1 m=1
M12 net8 VB2 VDD VDD pch l=0.15 w=1 nf=1 m=1
M13 net4 INN net8 VDD pch l=0.15 w=1 nf=1 m=1
M14 net4 VB4 net5 VSS nch l=0.15 w=1 nf=1 m=1
M15 net5 net4 VSS VSS nch l=0.15 w=1 nf=1 m=1
M16 net10 net7 VDD VDD pch l=0.15 w=1 nf=1 m=1
M17 OUT VB1 net10 VDD pch l=0.15 w=1 nf=1 m=1
M18 OUT VB4 net6 VSS nch l=0.15 w=1 nf=1 m=1
M19 net6 net4 VSS VSS nch l=0.15 w=1 nf=1 m=1
M20 net2 VB5 VDD VDD pch l=0.15 w=1 nf=1 m=1
M21 net2 net2 VSS VSS nch l=0.15 w=1 nf=1 m=1
M22 VB5 VB5 VDD VDD pch l=0.15 w=1 nf=1 m=1
M23 VB5 VB3 net9 VSS nch l=0.15 w=1 nf=1 m=1
M24 net9 net2 VSS VSS nch l=0.15 w=1 nf=1 m=1
M25 VB3 VB5 VDD VDD pch l=0.15 w=1 nf=1 m=1
M26 VB3 VB3 VSS VSS nch l=0.15 w=1 nf=1 m=1
M27 VB4 VB5 VDD VDD pch l=0.15 w=1 nf=1 m=1
M28 VB4 VB4 net0 VSS nch l=0.15 w=1 nf=1 m=1
M29 net0 VB4 VSS VSS nch l=0.15 w=1 nf=1 m=1
M5 net11 net7 VDD VDD pch l=0.15 w=1 nf=1 m=1
M6 net7 VB1 net11 VDD pch l=0.15 w=1 nf=1 m=1
M7 net7 VB4 net3 VSS nch l=0.15 w=1 nf=1 m=1
M8 net3 VE VSS VSS nch l=0.15 w=1 nf=1 m=1
M9 VE INP net8 VDD pch l=0.15 w=1 nf=1 m=1
.ends opamp

.subckt dut VDD VSS Vout
M1 X net1 VDD VDD pch l=0.15 w=1 nf=1 m=1
M2 Vout net1 VDD VDD pch l=0.15 w=1 nf=1 m=1
M3 net0 net1 VDD VDD pch l=0.15 w=1 nf=1 m=1
M4 net3 net1 VDD VDD pch l=0.15 w=1 nf=1 m=1
Q1 VSS VSS net0 qpnp m=1
Q2 VSS net0 X qpnp m=1
Q3 VSS VSS net3 qpnp m=1
Q4 VSS net3 net2 qpnp m=1
R1 Y net2 1k
R2 Vout Y 1k
X1 VDD VSS Y X net1 net2 opamp
.ends dut
