* official Analog Canvas netlist; PDK X cards rewritten by convert.py
.model nch nmos
.model pch pmos
.model qpnp pnp

.subckt opamp VDD VSS INN INP OUT
M1 net2 net0 VDD VDD pch l=0.15 w=1 nf=1 m=1
M10 net3 net3 VDD VDD pch l=0.15 w=1 nf=1 m=1
M11 VB net3 VDD VDD pch l=0.15 w=1 nf=1 m=1
M12 VB VB VSS VSS nch l=0.15 w=1 nf=1 m=1
M2 net0 net0 VDD VDD pch l=0.15 w=1 nf=1 m=1
M3 net4 net4 VDD VDD pch l=0.15 w=1 nf=1 m=1
M4 OUT net4 VDD VDD pch l=0.15 w=1 nf=1 m=1
M5 net0 INN net1 VSS nch l=0.15 w=1 nf=1 m=1
M6 net4 INP net1 VSS nch l=0.15 w=1 nf=1 m=1
M7 net1 VB VSS VSS nch l=0.15 w=1 nf=1 m=1
M8 net2 net2 VSS VSS nch l=0.15 w=1 nf=1 m=1
M9 OUT net2 VSS VSS nch l=0.15 w=1 nf=1 m=1
R4 net3 VSS 1k
.ends opamp

.subckt dut VDD VSS Vout
Q1 VSS VSS net1 qpnp m=1
Q2 net1 net1 X qpnp m=1
Q3 VSS VSS net2 qpnp m=1
Q4 net2 net2 net0 qpnp m=1
R1 Vout X 1k
R2 Vout Y 1k
R3 Y net0 1k
X1 VDD VSS Y X Vout opamp
.ends dut
