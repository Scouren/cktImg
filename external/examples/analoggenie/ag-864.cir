* official Analog Canvas netlist; PDK X cards rewritten by convert.py
.model nch nmos

.subckt dut VDD VSS IOUT1 IOUT2
IIN VDD net1 DC 1m
M1 net1 net1 VSS VSS nch l=0.15 w=1 nf=1 m=1
M2 IOUT1 net1 net2 VSS nch l=0.15 w=1 nf=1 m=1
M3 IOUT2 net1 net0 VSS nch l=0.15 w=1 nf=1 m=1
RS1 VSS net2 1k
RS2 net2 net0 1k
.ends dut
