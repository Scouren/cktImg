* official Analog Canvas netlist; PDK X cards rewritten by convert.py
.model nch nmos
.model pch pmos
.model qnpn npn

.subckt opamp VDD VSS INN INP OUT VB1 VB3 VC VB2
M1 net0 INP net5 VSS nch l=0.15 w=1 nf=1 m=1
M10 net1 net3 VSS VSS nch l=0.15 w=1 nf=1 m=1
M11 net2 net3 VSS VSS nch l=0.15 w=1 nf=1 m=1
M2 net4 INN net5 VSS nch l=0.15 w=1 nf=1 m=1
M3 net5 VB2 VSS VSS nch l=0.15 w=1 nf=1 m=1
M4 net0 VB1 VDD VDD pch l=0.15 w=1 nf=1 m=1
M5 net4 VB1 VDD VDD pch l=0.15 w=1 nf=1 m=1
M6 OUT VB3 net0 VDD pch l=0.15 w=1 nf=1 m=1
M7 net3 VB3 net4 VDD pch l=0.15 w=1 nf=1 m=1
M8 OUT VC net1 VSS nch l=0.15 w=1 nf=1 m=1
M9 net3 VC net2 VSS nch l=0.15 w=1 nf=1 m=1
.ends opamp

.subckt dut VDD VSS Vout VB1 VB2 VB3
M12 VC net1 VDD VDD pch l=0.15 w=1 nf=1 m=1
M13 net1 net1 net0 VDD pch l=0.15 w=1 nf=1 m=1
M14 VC VC Z VSS nch l=0.15 w=1 nf=1 m=1
M15 Z VC VSS VSS nch l=0.15 w=1 nf=1 m=1
Q1 X X VSS VSS qnpn m=1
Q2 Z Z VSS VSS qnpn m=1
R1 Vout X 1k
R2 Vout Y 1k
R3 Y Z 1k
R4 VDD net0 1k
R5 net1 VSS 1k
X1 VDD VSS Y X Vout VB1 VB3 VC VB2 opamp
.ends dut
