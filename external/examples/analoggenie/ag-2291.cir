* official Analog Canvas netlist; PDK X cards rewritten by convert.py
.model nch nmos
.model pch pmos

.subckt dut VDD VSS VB1 VB2 VREF VB3 IB1 VIN VOUT
CL VOUT net6 1p
M1 VBN VBN VSS VSS nch l=0.15 w=1 nf=1 m=1
M10 EAO VB2 net2 VDD pch l=0.15 w=1 nf=1 m=1
M11 net8 VB1 VDD VDD pch l=0.15 w=1 nf=1 m=1
M12 net2 VB1 VDD VDD pch l=0.15 w=1 nf=1 m=1
M13 net9 VB3 VDD VDD pch l=0.15 w=1 nf=1 m=1
M14 net4 EAO net9 VDD pch l=0.15 w=1 nf=1 m=1
M15 net4 net4 VSS VSS nch l=0.15 w=1 nf=1 m=1
M16 GATE net4 VSS VSS nch l=0.15 w=1 nf=1 m=1
M17 net0 EAO IB1 VSS nch l=0.15 w=1 nf=1 m=1
M18 VDD net9 GATE VSS nch l=0.15 w=1 nf=1 m=1
M19 net0 net0 VDD VDD pch l=0.15 w=1 nf=1 m=1
M2 net7 VBN VSS VSS nch l=0.15 w=1 nf=1 m=1
M20 GATE net0 VDD VDD pch l=0.15 w=1 nf=1 m=1
M21 VSS IB1 GATE VDD pch l=0.15 w=1 nf=1 m=1
M22 VBC VBC VBN VSS nch l=0.15 w=1 nf=1 m=1
M23 VBC net3 VDD VDD pch l=0.15 w=1 nf=1 m=1
M24 net3 net3 VDD VDD pch l=0.15 w=1 nf=1 m=1
M3 net2 VREF net7 VSS nch l=0.15 w=1 nf=1 m=1
M4 net8 FB net7 VSS nch l=0.15 w=1 nf=1 m=1
M5 net1 VX VSS VSS nch l=0.15 w=1 nf=1 m=1
M6 net5 VX VSS VSS nch l=0.15 w=1 nf=1 m=1
M7 VX VBC net1 VSS nch l=0.15 w=1 nf=1 m=1
M8 EAO VBC net5 VSS nch l=0.15 w=1 nf=1 m=1
M9 VX VB2 net8 VDD pch l=0.15 w=1 nf=1 m=1
MNP VIN GATE VOUT VSS nch l=0.15 w=1 nf=1 m=1
R1 FB VSS 1k
R2 VOUT FB 1k
R3 net3 VSS 1k
R4 net6 VSS 1k
RL VOUT VSS 1k
.ends dut
