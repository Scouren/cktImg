* official Analog Canvas netlist; PDK X cards rewritten by convert.py
.model nch nmos
.model pch pmos

.subckt opamp VDD VSS INN OUT
M10 OUT OUT VSS VSS nch l=0.15 w=1 nf=1 m=1
M11 net1 OUT net4 VSS nch l=0.15 w=1 nf=1 m=1
M12 net4 VBN VSS VSS nch l=0.15 w=1 nf=1 m=1
M13 net0 net0 net3 VDD pch l=0.15 w=1 nf=1 m=1
M14 VBN net0 VDD VDD pch l=0.15 w=1 nf=1 m=1
M15 VBN VBN VSS VSS nch l=0.15 w=1 nf=1 m=1
M4 net2 net2 VDD VDD pch l=0.15 w=1 nf=1 m=1
M5 OUT net2 VDD VDD pch l=0.15 w=1 nf=1 m=1
M6 OUT net1 VDD VDD pch l=0.15 w=1 nf=1 m=1
M7 net1 net1 VDD VDD pch l=0.15 w=1 nf=1 m=1
M8 net2 INN net4 VSS nch l=0.15 w=1 nf=1 m=1
M9 OUT OUT VSS VSS nch l=0.15 w=1 nf=1 m=1
R1 VDD net3 1k
R2 net0 VSS 1k
.ends opamp

.subckt dut VDD VSS VIN nb pb VOUT VERR VREF
M1 net3 net1 VIN VDD pch l=0.15 w=1 nf=1 m=1
M2 net0 net0 net3 VDD pch l=0.15 w=1 nf=1 m=1
M3 net0 nb VSS VSS nch l=0.15 w=1 nf=1 m=1
MBIAS VERR nb VSS VSS nch l=0.15 w=1 nf=1 m=1
MCHG net2 pb VIN VDD pch l=0.15 w=1 nf=1 m=1
MCTRL VERR net0 VOUT VDD pch l=0.15 w=1 nf=1 m=1
MGEN net4 net4 VSS VSS nch l=0.15 w=1 nf=1 m=1
MINJ VERR net4 VSS VSS nch l=0.15 w=1 nf=1 m=1
MRES VOUT VERR VIN VDD pch l=0.15 w=1 nf=1 m=1
MSEN net4 net1 net2 VDD pch l=0.15 w=1 nf=1 m=1
X1 VDD VSS VREF net1 opamp
.ends dut
