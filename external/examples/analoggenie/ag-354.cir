* official Analog Canvas netlist; PDK X cards rewritten by convert.py
.model nch nmos
.model pch pmos

.subckt dut VDD VSS Vout
I1 VDD net1 DC 1m
I2 Vout VSS DC 1m
I3 VDD net0 DC 1m
Iin VSS net0 DC 1m
M1 net1 net0 VSS VSS nch l=0.15 w=1 nf=1 m=1
M2 Vout net1 VDD VDD pch l=0.15 w=1 nf=1 m=1
M3 net0 Vout VSS VSS nch l=0.15 w=1 nf=1 m=1
.ends dut
