* official Analog Canvas netlist; PDK X cards rewritten by convert.py
.model nch nmos

.subckt dut VDD VSS Vin1 Vin2 Vout1 Vout2 Vb
C1 Vin1 net0 1p
C2 Vin1 net2 1p
C3 Vin2 net3 1p
C4 Vin2 net4 1p
L1 VDD Vout1 1n
L2 VDD Vout2 1n
M1 net1 net0 VSS VSS nch l=0.15 w=1 nf=1 m=1
M2 net5 net3 VSS VSS nch l=0.15 w=1 nf=1 m=1
M3 Vout1 Vb net1 VSS nch l=0.15 w=1 nf=1 m=1
M4 Vout2 Vb net5 VSS nch l=0.15 w=1 nf=1 m=1
M5 net1 net2 VSS VSS nch l=0.15 w=1 nf=1 m=1
M6 net5 net4 VSS VSS nch l=0.15 w=1 nf=1 m=1
R1 net0 Vb 1k
R2 net2 VSS 1k
R3 net3 Vb 1k
R4 net4 VSS 1k
.ends dut
