* official Analog Canvas netlist; PDK X cards rewritten by convert.py
.model nch nmos
.model pch pmos

.subckt dut VDD VSS VIN VS5 VB4 VS1 VS3 VS4 VP VS2 VREF
.model DIODE D(IS=1e-14 N=1)
CFLY VX1 VX2 1p
CO VP VN 1p
COP VP VSS 1p
D1 VN VX2 DIODE
L1 VX1 VX3 1n
M1 VX1 VS1 VIN VDD pch l=0.15 w=1 nf=1 m=1
M2 VX2 VS2 VIN VDD pch l=0.15 w=1 nf=1 m=1
M3 VP VS3 VX3 VDD pch l=0.15 w=1 nf=1 m=1
M4 VX3 VS4 VSS VSS nch l=0.15 w=1 nf=1 m=1
M5 net5 VS5 VIN VDD pch l=0.15 w=1 nf=1 m=1
MB1 VB1 VB1 VDD VDD pch l=0.15 w=1 nf=1 m=1
MB10 VX2 VBP VDD VDD pch l=0.15 w=1 nf=1 m=1
MB11 VX2 VX2 VSS VSS nch l=0.15 w=1 nf=1 m=1
MB2 VB1 VBN VSS VSS nch l=0.15 w=1 nf=1 m=1
MB3 VBN VBP VDD VDD pch l=0.15 w=1 nf=1 m=1
MB4 VBN VBN VSS VSS nch l=0.15 w=1 nf=1 m=1
MB5 VBP VBP VDD VDD pch l=0.15 w=1 nf=1 m=1
MB6 VBP VB3 VB2 VSS nch l=0.15 w=1 nf=1 m=1
MB7 VB2 VX2 VSS VSS nch l=0.15 w=1 nf=1 m=1
MB8 VB3 VBP VDD VDD pch l=0.15 w=1 nf=1 m=1
MB9 VB3 VB2 VSS VSS nch l=0.15 w=1 nf=1 m=1
MN1 net1 VFP1 net3 VSS nch l=0.15 w=1 nf=1 m=1
MN2 VX3 VREF net3 VSS nch l=0.15 w=1 nf=1 m=1
MN3 net2 net2 VSS VSS nch l=0.15 w=1 nf=1 m=1
MN4 VCTRL net2 VSS VSS nch l=0.15 w=1 nf=1 m=1
MN5 net3 VBN VSS VSS nch l=0.15 w=1 nf=1 m=1
MN6 net0 net0 VSS VSS nch l=0.15 w=1 nf=1 m=1
MN7 net0 VB4 VSS VSS nch l=0.15 w=1 nf=1 m=1
MN8 net4 net0 VSS VSS nch l=0.15 w=1 nf=1 m=1
MP1 net1 net1 VDD VDD pch l=0.15 w=1 nf=1 m=1
MP2 VX3 VX3 VDD VDD pch l=0.15 w=1 nf=1 m=1
MP3 net2 net1 VDD VDD pch l=0.15 w=1 nf=1 m=1
MP4 VCTRL VX3 VDD VDD pch l=0.15 w=1 nf=1 m=1
MP5 net0 VCTRL net5 VDD pch l=0.15 w=1 nf=1 m=1
MP6 net4 net4 net5 VDD pch l=0.15 w=1 nf=1 m=1
MP7 VX1 net4 net5 VDD pch l=0.15 w=1 nf=1 m=1
R1 VP VFP1 1k
R2 VFP1 VSS 1k
.ends dut
