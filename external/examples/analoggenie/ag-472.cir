* official Analog Canvas netlist; PDK X cards rewritten by convert.py
.model nch nmos

.subckt dut VDD VSS
C1 VDD net0 1p
CB net2 VSS 1p
IREF VDD net2 DC 1m
L1 VDD net0 1n
LB net1 VSS 1n
M1 net3 net2 net1 VSS nch l=0.15 w=1 nf=1 m=1
M2 net0 VDD net3 VSS nch l=0.15 w=1 nf=1 m=1
MB net2 net2 VSS VSS nch l=0.15 w=1 nf=1 m=1
R1 VDD net0 1k
RS net1 net4 1k
Vin net4 VSS DC 1
.ends dut
