* official Analog Canvas netlist; PDK X cards rewritten by convert.py
.model nch nmos
.model pch pmos
.model qpnp pnp

.subckt A1 VDD VSS INP INN OUT VZ VB1 VB2
M1 net5 net0 VDD VDD pch l=0.15 w=1 nf=1 m=1
M10 net1 INN net8 VSS nch l=0.15 w=1 nf=1 m=1
M11 net2 net1 VDD VDD pch l=0.15 w=1 nf=1 m=1
M12 OUT VB1 net2 VDD pch l=0.15 w=1 nf=1 m=1
M13 OUT VB4 VZ VSS nch l=0.15 w=1 nf=1 m=1
M14 VZ VN VSS VSS nch l=0.15 w=1 nf=1 m=1
M15 net8 VB2 VSS VSS nch l=0.15 w=1 nf=1 m=1
M16 VB3 net7 VDD VDD pch l=0.15 w=1 nf=1 m=1
M17 net7 net7 VDD VDD pch l=0.15 w=1 nf=1 m=1
M18 VB4 net7 VDD VDD pch l=0.15 w=1 nf=1 m=1
M19 net9 VB3 VSS VSS nch l=0.15 w=1 nf=1 m=1
M2 VN VB1 net5 VDD pch l=0.15 w=1 nf=1 m=1
M20 net7 VB3 VSS VSS nch l=0.15 w=1 nf=1 m=1
M21 VB4 VB4 net6 VSS nch l=0.15 w=1 nf=1 m=1
M22 net6 VB4 VSS VSS nch l=0.15 w=1 nf=1 m=1
M3 VN VB4 net3 VSS nch l=0.15 w=1 nf=1 m=1
M4 net3 VN VSS VSS nch l=0.15 w=1 nf=1 m=1
M5 net10 net0 VDD VDD pch l=0.15 w=1 nf=1 m=1
M6 net0 VB1 net10 VDD pch l=0.15 w=1 nf=1 m=1
M7 net0 INP net8 VSS nch l=0.15 w=1 nf=1 m=1
M8 net4 net1 VDD VDD pch l=0.15 w=1 nf=1 m=1
M9 net1 VB1 net4 VDD pch l=0.15 w=1 nf=1 m=1
R1 VB3 net9 1k
.ends A1

.subckt dut VDD VSS Vout VB1 VB2
Q1 VSS VSS net0 qpnp m=1
Q2 net0 net0 VZ qpnp m=1
Q3 VSS VSS net1 qpnp m=1
Q4 net1 net1 Y qpnp m=1
R1 Vout X 1k
R2 Vout Y 1k
R3 X VZ 1k
X1 VDD VSS X Y Vout VZ VB1 VB2 A1
.ends dut
