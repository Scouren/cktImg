* official Analog Canvas netlist; PDK X cards rewritten by convert.py
.model nch nmos
.model pch pmos

.subckt opamp VDD VSS INP INN OUT
M10 OUT net5 VDD VDD pch l=0.15 w=1 nf=1 m=1
M11 OUT net4 VSS VSS nch l=0.15 w=1 nf=1 m=1
M12 VB3 VB3 VDD VDD pch l=0.15 w=1 nf=1 m=1
M13 VB3 VB1 VSS VSS nch l=0.15 w=1 nf=1 m=1
M14 VB1 net0 VDD VDD pch l=0.15 w=1 nf=1 m=1
M15 VB1 VB1 VSS VSS nch l=0.15 w=1 nf=1 m=1
M16 net0 net0 VDD VDD pch l=0.15 w=1 nf=1 m=1
M17 net0 net2 VSS VSS nch l=0.15 w=1 nf=1 m=1
M18 net2 VB2 VDD VDD pch l=0.15 w=1 nf=1 m=1
M19 net1 net2 VSS VSS nch l=0.15 w=1 nf=1 m=1
M20 VB2 VB2 VDD VDD pch l=0.15 w=1 nf=1 m=1
M21 VB2 net2 VSS VSS nch l=0.15 w=1 nf=1 m=1
M3 net6 VB3 VDD VDD pch l=0.15 w=1 nf=1 m=1
M4 net5 net5 VDD VDD pch l=0.15 w=1 nf=1 m=1
M5 net5 net3 VSS VSS nch l=0.15 w=1 nf=1 m=1
M6 net3 INP net6 VDD pch l=0.15 w=1 nf=1 m=1
M7 net3 net3 VSS VSS nch l=0.15 w=1 nf=1 m=1
M8 net4 INN net6 VDD pch l=0.15 w=1 nf=1 m=1
M9 net4 net4 VSS VSS nch l=0.15 w=1 nf=1 m=1
R1 net2 net1 1k
.ends opamp

.subckt dut VDD VSS vci phi1 phi2 vco
C1 net1 VSS 1p
C2 net0 vco 1p
M1 vci phi1 net1 VSS nch l=0.15 w=1 nf=1 m=1
M2 net1 phi2 net0 VSS nch l=0.15 w=1 nf=1 m=1
X1 VDD VSS VSS net0 vco opamp
.ends dut
