* official Analog Canvas netlist; PDK X cards rewritten by convert.py
.model nch nmos
.model pch pmos

.subckt opamp VDD VSS INN INP OUT
M10 VB1 VB1 VDD VDD pch l=0.15 w=1 nf=1 m=1
M11 VB1 VB3 VSS VSS nch l=0.15 w=1 nf=1 m=1
M12 VB3 net0 VDD VDD pch l=0.15 w=1 nf=1 m=1
M13 VB3 VB3 VSS VSS nch l=0.15 w=1 nf=1 m=1
M14 net0 net0 VDD VDD pch l=0.15 w=1 nf=1 m=1
M15 net0 VB2 VSS VSS nch l=0.15 w=1 nf=1 m=1
M16 VB2 net0 VDD VDD pch l=0.15 w=1 nf=1 m=1
M17 VB2 VB2 VSS VSS nch l=0.15 w=1 nf=1 m=1
M3 net1 INN net2 VSS nch l=0.15 w=1 nf=1 m=1
M4 OUT INP net2 VSS nch l=0.15 w=1 nf=1 m=1
M5 net3 net1 VDD VDD pch l=0.15 w=1 nf=1 m=1
M6 net4 net1 VDD VDD pch l=0.15 w=1 nf=1 m=1
M7 net1 VB4 net3 VDD pch l=0.15 w=1 nf=1 m=1
M8 OUT VB4 net4 VDD pch l=0.15 w=1 nf=1 m=1
M9 net2 VB3 VSS VSS nch l=0.15 w=1 nf=1 m=1
.ends opamp

.subckt dut VDD VSS vci phi1 phi2 vco
C1 net1 net0 1p
C2 net2 vco 1p
M1 vci phi1 net1 VSS nch l=0.15 w=1 nf=1 m=1
M2 net1 phi2 VSS VSS nch l=0.15 w=1 nf=1 m=1
M3 net0 phi1 VSS VSS nch l=0.15 w=1 nf=1 m=1
M4 net0 phi2 net2 VSS nch l=0.15 w=1 nf=1 m=1
X1 VDD VSS net2 VSS vco opamp
.ends dut
