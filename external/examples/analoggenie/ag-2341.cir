* official Analog Canvas netlist; PDK X cards rewritten by convert.py
.model nch nmos
.model pch pmos

.subckt dut VDD VSS VREF VB3 IBUF VIN VOUT VB1
CL VOUT net0 1p
M1 net5 net5 VDD VDD pch l=0.15 w=1 nf=1 m=1
M10 net3 net1 VDD VDD pch l=0.15 w=1 nf=1 m=1
M11 VBN VB1 VDD VDD pch l=0.15 w=1 nf=1 m=1
M12 VB1 VX VSS VSS nch l=0.15 w=1 nf=1 m=1
M13 net2 VB3 VDD VDD pch l=0.15 w=1 nf=1 m=1
M14 net9 EAO net2 VDD pch l=0.15 w=1 nf=1 m=1
M15 net9 net9 VSS VSS nch l=0.15 w=1 nf=1 m=1
M16 GATE net9 VSS VSS nch l=0.15 w=1 nf=1 m=1
M17 VDD net2 GATE VSS nch l=0.15 w=1 nf=1 m=1
M18 net4 EAO IBUF VSS nch l=0.15 w=1 nf=1 m=1
M19 net4 net4 VDD VDD pch l=0.15 w=1 nf=1 m=1
M2 net1 net1 VDD VDD pch l=0.15 w=1 nf=1 m=1
M20 GATE net4 VDD VDD pch l=0.15 w=1 nf=1 m=1
M21 VSS IBUF GATE VDD pch l=0.15 w=1 nf=1 m=1
M22 VBN VBN VSS VSS nch l=0.15 w=1 nf=1 m=1
M23 net6 VB2 VDD VDD pch l=0.15 w=1 nf=1 m=1
M24 net8 VB2 VDD VDD pch l=0.15 w=1 nf=1 m=1
M25 VB2 net10 VSS VSS nch l=0.15 w=1 nf=1 m=1
M26 net6 net6 net10 VSS nch l=0.15 w=1 nf=1 m=1
M27 net10 net6 net7 VSS nch l=0.15 w=1 nf=1 m=1
M28 net8 net8 net7 VSS nch l=0.15 w=1 nf=1 m=1
M29 net7 net8 VX VSS nch l=0.15 w=1 nf=1 m=1
M3 net5 VREF net9 VSS nch l=0.15 w=1 nf=1 m=1
M30 VB2 VB2 VDD VDD pch l=0.15 w=1 nf=1 m=1
M31 VX VB2 VDD VDD pch l=0.15 w=1 nf=1 m=1
M32 VX VX VSS VSS nch l=0.15 w=1 nf=1 m=1
M4 net1 FB net9 VSS nch l=0.15 w=1 nf=1 m=1
M5 net9 VBN VSS VSS nch l=0.15 w=1 nf=1 m=1
M6 VB1 VB1 VDD VDD pch l=0.15 w=1 nf=1 m=1
M7 EAO net3 VSS VSS nch l=0.15 w=1 nf=1 m=1
M8 net3 net3 VSS VSS nch l=0.15 w=1 nf=1 m=1
M9 EAO net5 VDD VDD pch l=0.15 w=1 nf=1 m=1
MNP VIN GATE VOUT VSS nch l=0.15 w=1 nf=1 m=1
R1 FB VSS 1k
R2 VOUT FB 1k
R3 net0 VSS 1k
RL VOUT VSS 1k
.ends dut
