* official Analog Canvas netlist; PDK X cards rewritten by convert.py
.model nch nmos
.model pch pmos

.subckt dut VDD VSS VIN VOUT Vref VB1 VB2
CL VOUT VX 1p
M1 VX FB net4 VDD pch l=0.15 w=1 nf=1 m=1
M10 net6 VB3 net11 VSS nch l=0.15 w=1 nf=1 m=1
M11 VX VB3 net8 VSS nch l=0.15 w=1 nf=1 m=1
M12 net10 net1 VSS VSS nch l=0.15 w=1 nf=1 m=1
M13 net9 net1 VSS VSS nch l=0.15 w=1 nf=1 m=1
M14 net11 VX VSS VSS nch l=0.15 w=1 nf=1 m=1
M15 net8 VX VSS VSS nch l=0.15 w=1 nf=1 m=1
M16 net2 net2 VDD VDD pch l=0.15 w=1 nf=1 m=1
M17 VB3 net2 VDD VDD pch l=0.15 w=1 nf=1 m=1
M18 VB3 VB3 net5 VSS nch l=0.15 w=1 nf=1 m=1
M19 net5 VB3 VSS VSS nch l=0.15 w=1 nf=1 m=1
M2 net1 Vref net4 VDD pch l=0.15 w=1 nf=1 m=1
M3 net4 VB2 VDD VDD pch l=0.15 w=1 nf=1 m=1
M4 net7 net0 VDD VDD pch l=0.15 w=1 nf=1 m=1
M5 net3 net0 VDD VDD pch l=0.15 w=1 nf=1 m=1
M6 net0 VB1 net7 VDD pch l=0.15 w=1 nf=1 m=1
M7 net6 VB1 net3 VDD pch l=0.15 w=1 nf=1 m=1
M8 net1 VB3 net10 VSS nch l=0.15 w=1 nf=1 m=1
M9 net0 VB3 net9 VSS nch l=0.15 w=1 nf=1 m=1
MNP VIN net6 VOUT VSS nch l=0.15 w=1 nf=1 m=1
R1 VOUT FB 1k
R2 FB VSS 1k
R3 VX VSS 1k
R4 net2 VSS 1k
.ends dut
