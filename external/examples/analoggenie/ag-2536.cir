* official Analog Canvas netlist; PDK X cards rewritten by convert.py
.model nch nmos
.model pch pmos

.subckt dut VDD VSS VREF VB4 VB5 VIN VB1 VB2 VB3 VOUT
CF1 VOUT VFB 1p
Cm1 VOUT VO1 1p
Cm2 VO1 net1 1p
M11 net0 VBN VSS VSS nch l=0.15 w=1 nf=1 m=1
M12 VX VFB net0 VSS nch l=0.15 w=1 nf=1 m=1
M13 VG VREF net0 VSS nch l=0.15 w=1 nf=1 m=1
M14 VX VX VIN VDD pch l=0.15 w=1 nf=1 m=1
M15 VG VG VIN VDD pch l=0.15 w=1 nf=1 m=1
M16 VG VB4 VIN VDD pch l=0.15 w=1 nf=1 m=1
M17 VG VG VSS VSS nch l=0.15 w=1 nf=1 m=1
M18 VG VO1 VSS VSS nch l=0.15 w=1 nf=1 m=1
M21 net2 VO1 VSS VSS nch l=0.15 w=1 nf=1 m=1
M22 net7 VG VSS VSS nch l=0.15 w=1 nf=1 m=1
M23 net2 net2 VIN VDD pch l=0.15 w=1 nf=1 m=1
M24 net7 net2 VIN VDD pch l=0.15 w=1 nf=1 m=1
M25 net3 VG VIN VDD pch l=0.15 w=1 nf=1 m=1
M26 VO1 VX VIN VDD pch l=0.15 w=1 nf=1 m=1
M27 net3 net3 VSS VSS nch l=0.15 w=1 nf=1 m=1
M28 VO1 net3 VSS VSS nch l=0.15 w=1 nf=1 m=1
M31 VB1 VB1 VIN VDD pch l=0.15 w=1 nf=1 m=1
M32 VB1 VBN VSS VSS nch l=0.15 w=1 nf=1 m=1
M33 VBN net4 VIN VDD pch l=0.15 w=1 nf=1 m=1
M34 VBN VBN VSS VSS nch l=0.15 w=1 nf=1 m=1
M35 net4 net4 VIN VDD pch l=0.15 w=1 nf=1 m=1
M36 net4 VB2 VSS VSS nch l=0.15 w=1 nf=1 m=1
M37 VB2 net4 VIN VDD pch l=0.15 w=1 nf=1 m=1
M38 VB2 VB2 VSS VSS nch l=0.15 w=1 nf=1 m=1
MD1 net1 VO1 VSS VSS nch l=0.15 w=1 nf=1 m=1
MD2 net6 VB5 VSS VSS nch l=0.15 w=1 nf=1 m=1
MD3 net5 net1 net6 VSS nch l=0.15 w=1 nf=1 m=1
MD4 VX VB3 net6 VSS nch l=0.15 w=1 nf=1 m=1
MD5 net1 VX VIN VDD pch l=0.15 w=1 nf=1 m=1
MD6 VX VX VIN VDD pch l=0.15 w=1 nf=1 m=1
MD7 net5 net5 VIN VDD pch l=0.15 w=1 nf=1 m=1
MPT VOUT net7 VIN VDD pch l=0.15 w=1 nf=1 m=1
RF1 VOUT VFB 1k
RF2 VFB VSS 1k
.ends dut
