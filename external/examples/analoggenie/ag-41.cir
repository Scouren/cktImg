* official Analog Canvas netlist; PDK X cards rewritten by convert.py
.model nch nmos
.model pch pmos

.subckt dut VDD VSS Vb3 Vb2 Vin Vout Vb
I1 net0 VSS DC 1m
M1 net0 Vin VDD VDD pch l=0.15 w=1 nf=1 m=1
M2 Vout Vb net0 VSS nch l=0.15 w=1 nf=1 m=1
M4 Vout Vb2 net1 VDD pch l=0.15 w=1 nf=1 m=1
M5 net1 Vb3 VDD VDD pch l=0.15 w=1 nf=1 m=1
.ends dut
