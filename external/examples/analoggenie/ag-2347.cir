* official Analog Canvas netlist; PDK X cards rewritten by convert.py
.model nch nmos
.model pch pmos

.subckt dut VDD VSS VREF VB3 IBUF VIN VOUT FB VB1 VB2
CL VOUT net7 1p
M1 net1 net1 VDD VDD pch l=0.15 w=1 nf=1 m=1
M13 net6 VB3 VDD VDD pch l=0.15 w=1 nf=1 m=1
M14 VX EAO net6 VDD pch l=0.15 w=1 nf=1 m=1
M15 VX VX VSS VSS nch l=0.15 w=1 nf=1 m=1
M16 GATE VX VSS VSS nch l=0.15 w=1 nf=1 m=1
M17 VDD net6 GATE VSS nch l=0.15 w=1 nf=1 m=1
M18 net5 EAO IBUF VSS nch l=0.15 w=1 nf=1 m=1
M19 net5 net5 VDD VDD pch l=0.15 w=1 nf=1 m=1
M2 net3 net3 VDD VDD pch l=0.15 w=1 nf=1 m=1
M20 GATE net5 VDD VDD pch l=0.15 w=1 nf=1 m=1
M21 VSS IBUF GATE VDD pch l=0.15 w=1 nf=1 m=1
M22 VB1 VB1 VDD VDD pch l=0.15 w=1 nf=1 m=1
M23 VB1 VBN VSS VSS nch l=0.15 w=1 nf=1 m=1
M24 VBN net0 VDD VDD pch l=0.15 w=1 nf=1 m=1
M25 VBN VBN VSS VSS nch l=0.15 w=1 nf=1 m=1
M26 net0 net0 VDD VDD pch l=0.15 w=1 nf=1 m=1
M27 net0 net4 VSS VSS nch l=0.15 w=1 nf=1 m=1
M28 net4 VB2 VDD VDD pch l=0.15 w=1 nf=1 m=1
M29 net4 net4 VSS VSS nch l=0.15 w=1 nf=1 m=1
M3 net1 VREF VX VSS nch l=0.15 w=1 nf=1 m=1
M30 VB2 VB2 VDD VDD pch l=0.15 w=1 nf=1 m=1
M31 VB2 net4 VSS VSS nch l=0.15 w=1 nf=1 m=1
M4 net3 FB VX VSS nch l=0.15 w=1 nf=1 m=1
M5 VX VBN VSS VSS nch l=0.15 w=1 nf=1 m=1
M6 EAO net1 VDD VDD pch l=0.15 w=1 nf=1 m=1
M7 net2 net3 VDD VDD pch l=0.15 w=1 nf=1 m=1
M8 net2 net2 VSS VSS nch l=0.15 w=1 nf=1 m=1
M9 EAO net2 VSS VSS nch l=0.15 w=1 nf=1 m=1
MNP VIN GATE VOUT VSS nch l=0.15 w=1 nf=1 m=1
R1 FB VSS 1k
R2 VOUT FB 1k
R3 net7 VSS 1k
RL VOUT VSS 1k
.ends dut
