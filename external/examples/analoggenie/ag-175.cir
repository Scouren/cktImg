* official Analog Canvas netlist; PDK X cards rewritten by convert.py
.model nch nmos
.model pch pmos

.subckt dut VDD VSS Vin Vb1 Vb2 Vout
I1 VDD Vout DC 1m
I2 net0 VSS DC 1m
M1 Vout Vb2 net0 VSS nch l=0.15 w=1 nf=1 m=1
M2 net0 Vb1 Vout VDD pch l=0.15 w=1 nf=1 m=1
RS Vin net0 1k
.ends dut
