* official Analog Canvas netlist; PDK X cards rewritten by convert.py
.model nch nmos
.model pch pmos

.subckt dut VDD VSS VTUNE Vout1 Vout2 Iin
L1 Vout1 net1 1n
L2 net1 Vout2 1n
M1 Vout1 Vout2 VDD VDD pch l=0.28 w=47 nf=1 m=1
M2 Vout2 Vout1 VDD VDD pch l=0.28 w=47 nf=1 m=1
M3 NC0001 Vout1 NC0002 VTUNE pch l=0.15 w=1 nf=1 m=1
M4 NC0003 Vout2 NC0004 VTUNE pch l=0.15 w=1 nf=1 m=1
M5 Vout1 Vout2 net0 VSS nch l=0.24 w=23 nf=1 m=1
M6 Vout2 Vout1 net0 VSS nch l=0.24 w=23 nf=1 m=1
M7 Iin Iin VSS VSS nch l=1 w=400 nf=1 m=1
M8 net0 Iin VSS VSS nch l=1 w=400 nf=1 m=1
.ends dut
