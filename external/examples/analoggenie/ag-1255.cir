* official Analog Canvas netlist; PDK X cards rewritten by convert.py
.model nch nmos
.model pch pmos

.subckt dut VDD VSS VIN VCONT1 VCONT2 VCONT3 VCONT4 VCONT5 VP VREF VB2 VB1
.model DIODE D(IS=1e-14 N=1)
CFLY VX1 VX2 1p
CO VP VN 1p
COP VP VSS 1p
D1 VN VX2 DIODE
L1 VX1 VX3 1n
M1 VX1 VCONT2 VIN VDD pch l=0.15 w=1 nf=1 m=1
M10 VX3 VREF net3 VSS nch l=0.15 w=1 nf=1 m=1
M11 net1 VFP1 net3 VSS nch l=0.15 w=1 nf=1 m=1
M12 net3 VBN VSS VSS nch l=0.15 w=1 nf=1 m=1
M13 VEA VX VSS VSS nch l=0.15 w=1 nf=1 m=1
M14 VX VX VSS VSS nch l=0.15 w=1 nf=1 m=1
M15 net6 VEA net4 VDD pch l=0.15 w=1 nf=1 m=1
M16 net2 net2 net4 VDD pch l=0.15 w=1 nf=1 m=1
M17 VX1 net2 net4 VDD pch l=0.15 w=1 nf=1 m=1
M18 net6 net6 VSS VSS nch l=0.15 w=1 nf=1 m=1
M19 net2 net6 VSS VSS nch l=0.15 w=1 nf=1 m=1
M2 VX2 VCONT3 VIN VDD pch l=0.15 w=1 nf=1 m=1
M20 net6 VB2 VSS VSS nch l=0.15 w=1 nf=1 m=1
M21 VBN VB1 VDD VDD pch l=0.15 w=1 nf=1 m=1
M22 VB1 VB1 VDD VDD pch l=0.15 w=1 nf=1 m=1
M23 VBN VBN VSS VSS nch l=0.15 w=1 nf=1 m=1
M24 VB1 net5 VSS VSS nch l=0.15 w=1 nf=1 m=1
M25 net5 net0 VDD VDD pch l=0.15 w=1 nf=1 m=1
M26 net5 net5 VSS VSS nch l=0.15 w=1 nf=1 m=1
M27 net0 net5 VSS VSS nch l=0.15 w=1 nf=1 m=1
M3 VP VCONT5 VX3 VDD pch l=0.15 w=1 nf=1 m=1
M4 VX3 VCONT4 VSS VSS nch l=0.15 w=1 nf=1 m=1
M5 net4 VCONT1 VIN VDD pch l=0.15 w=1 nf=1 m=1
M6 VX3 VX3 VDD VDD pch l=0.15 w=1 nf=1 m=1
M7 net1 net1 VDD VDD pch l=0.15 w=1 nf=1 m=1
M8 VEA VX3 VDD VDD pch l=0.15 w=1 nf=1 m=1
M9 VX net1 VDD VDD pch l=0.15 w=1 nf=1 m=1
R1 VP VFP1 1k
R2 VFP1 VSS 1k
R3 VDD net5 1k
R4 VDD net0 1k
.ends dut
