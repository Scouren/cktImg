* official Analog Canvas netlist; PDK X cards rewritten by convert.py
.model nch nmos
.model pch pmos

.subckt opamp VDD VSS VB3 VB1 VB2 OUT INN INP IB
M0 net4 VB3 VDD VDD pch l=0.15 w=1 nf=1 m=1
M1 net1 VB3 VDD VDD pch l=0.15 w=1 nf=1 m=1
M2 net3 VB1 net4 VDD pch l=0.15 w=1 nf=1 m=1
M3 OUT VB1 net1 VDD pch l=0.15 w=1 nf=1 m=1
M4 net3 VB2 net0 VSS nch l=0.15 w=1 nf=1 m=1
M5 OUT VB2 net2 VSS nch l=0.15 w=1 nf=1 m=1
M6 net0 net3 VSS VSS nch l=0.15 w=1 nf=1 m=1
M7 net2 net3 VSS VSS nch l=0.15 w=1 nf=1 m=1
M8 net4 INP IB VSS nch l=0.15 w=1 nf=1 m=1
M9 net1 INN IB VSS nch l=0.15 w=1 nf=1 m=1
.ends opamp

.subckt comparator VDD VSS OUT INN INP CLK
M10 net3 CLK VSS VSS nch l=0.15 w=1 nf=1 m=1
M12 net2 INP net3 VSS nch l=0.15 w=1 nf=1 m=1
M13 net0 INN net3 VSS nch l=0.15 w=1 nf=1 m=1
M14 net1 OUT net2 VSS nch l=0.15 w=1 nf=1 m=1
M15 OUT net1 net0 VSS nch l=0.15 w=1 nf=1 m=1
M16 net1 CLK VDD VDD pch l=0.15 w=1 nf=1 m=1
M17 net1 OUT VDD VDD pch l=0.15 w=1 nf=1 m=1
M18 OUT net1 VDD VDD pch l=0.15 w=1 nf=1 m=1
M19 OUT CLK VDD VDD pch l=0.15 w=1 nf=1 m=1
M20 net0 CLK VDD VDD pch l=0.15 w=1 nf=1 m=1
M21 net2 CLK VDD VDD pch l=0.15 w=1 nf=1 m=1
.ends comparator

.subckt dut VDD VSS phi2 phi1 vout phic VB1 VB2 VB3 IB
C1 net0 net2 1p
C2 net1 vout 1p
C3 net1 vx 1p
M1 net1 phi2 net0 VSS nch l=0.15 w=1 nf=1 m=1
M2 net2 phi1 vout VSS nch l=0.15 w=1 nf=1 m=1
M3 net0 phi1 VSS VSS nch l=0.15 w=1 nf=1 m=1
M4 net2 phi2 VSS VSS nch l=0.15 w=1 nf=1 m=1
X1 VDD VSS VB3 VB1 VB2 vx net1 VSS IB opamp
X2 VDD VSS vout vx VSS phic comparator
.ends dut
