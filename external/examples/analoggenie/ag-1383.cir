* official Analog Canvas netlist; PDK X cards rewritten by convert.py
.model nch nmos
.model pch pmos

.subckt dut VDD VSS VSTO VCONT1 VCONT2 VCONT3 VOUT VB1 VB3 VB2
CL VOUT VSS 1p
CSTO VSTO VSS 1p
LRX VX1 VX2 1n
M1 net0 VB1 VDD VDD pch l=0.15 w=1 nf=1 m=1
M10 net2 net4 VSS VSS nch l=0.15 w=1 nf=1 m=1
M11 net3 net4 VSS VSS nch l=0.15 w=1 nf=1 m=1
M12 net5 net5 VDD VDD pch l=0.15 w=1 nf=1 m=1
M13 VB4 net5 VDD VDD pch l=0.15 w=1 nf=1 m=1
M14 VB4 VB4 net1 VSS nch l=0.15 w=1 nf=1 m=1
M15 net1 VB4 VSS VSS nch l=0.15 w=1 nf=1 m=1
M2 net6 VB1 VDD VDD pch l=0.15 w=1 nf=1 m=1
M3 VC VB3 net0 VDD pch l=0.15 w=1 nf=1 m=1
M4 net4 VB3 net6 VDD pch l=0.15 w=1 nf=1 m=1
M5 net0 VC VX1 VSS nch l=0.15 w=1 nf=1 m=1
M6 net6 VX2 VX1 VSS nch l=0.15 w=1 nf=1 m=1
M7 VX1 VB2 VSS VSS nch l=0.15 w=1 nf=1 m=1
M8 VC VB4 net2 VSS nch l=0.15 w=1 nf=1 m=1
M9 net4 VB4 net3 VSS nch l=0.15 w=1 nf=1 m=1
MN1 VX1 VCONT2 VSS VSS nch l=0.15 w=1 nf=1 m=1
MN2 VX2 VCONT3 VSS VSS nch l=0.15 w=1 nf=1 m=1
MP2 VX2 VC VOUT VDD pch l=0.15 w=1 nf=1 m=1
MP3 VX1 VCONT1 VSTO VDD pch l=0.15 w=1 nf=1 m=1
R1 net5 VSS 1k
.ends dut
