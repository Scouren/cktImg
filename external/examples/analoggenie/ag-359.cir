* official Analog Canvas netlist; PDK X cards rewritten by convert.py
.model nch nmos

.subckt dut VDD VSS Vin1 Vin2 Vin3 Vin4
I1 VDD net1 DC 25uA
M1 NC0001 Vin1 net2 VSS nch l=0.15 w=1 nf=1 m=1
M11 net2 net1 VSS VSS nch l=0.15 w=1 nf=1 m=1
M12 net0 net1 VSS VSS nch l=0.15 w=1 nf=1 m=1
M13 net1 Vin3 net0 VSS nch l=0.15 w=1 nf=1 m=1
M14 net1 Vin4 net0 VSS nch l=0.15 w=1 nf=1 m=1
M2 NC0002 Vin2 net2 VSS nch l=0.15 w=1 nf=1 m=1
.ends dut
