* official Analog Canvas netlist; PDK X cards rewritten by convert.py
.model nch nmos
.model pch pmos

.subckt EA1 VDD VSS VFP1 VREF VX3 VCTRL
MN1 net1 VFP1 net4 VSS nch l=0.15 w=1 nf=1 m=1
MN10 VBN VBN VSS VSS nch l=0.15 w=1 nf=1 m=1
MN2 VX3 VREF net4 VSS nch l=0.15 w=1 nf=1 m=1
MN3 net4 VBN VSS VSS nch l=0.15 w=1 nf=1 m=1
MN4 net0 net0 VSS VSS nch l=0.15 w=1 nf=1 m=1
MN5 VCTRL net0 VSS VSS nch l=0.15 w=1 nf=1 m=1
MN6 VBC VB2 VSS VSS nch l=0.15 w=1 nf=1 m=1
MN7 net2 VBC VB2 VSS nch l=0.15 w=1 nf=1 m=1
MN8 net3 net3 VSS VSS nch l=0.15 w=1 nf=1 m=1
MN9 VB1 net3 VSS VSS nch l=0.15 w=1 nf=1 m=1
MP1 net0 net1 VDD VDD pch l=0.15 w=1 nf=1 m=1
MP2 net1 net1 VDD VDD pch l=0.15 w=1 nf=1 m=1
MP3 VX3 VX3 VDD VDD pch l=0.15 w=1 nf=1 m=1
MP4 VCTRL VX3 VDD VDD pch l=0.15 w=1 nf=1 m=1
MP5 VBC net2 VDD VDD pch l=0.15 w=1 nf=1 m=1
MP6 net2 net2 VDD VDD pch l=0.15 w=1 nf=1 m=1
MP7 net3 net2 VDD VDD pch l=0.15 w=1 nf=1 m=1
MP8 VB1 VB1 VDD VDD pch l=0.15 w=1 nf=1 m=1
MP9 VBN VB1 VDD VDD pch l=0.15 w=1 nf=1 m=1
RBIAS VB2 VSS 1k
.ends EA1

.subckt dut VDD VSS VS5 VB3 VIN VS1 VS2 VS4 VS3 VP VREF
.model DIODE D(IS=1e-14 N=1)
CFLY VX1 VX2 1p
CO VP VN 1p
COP VP VSS 1p
D1 VN VX2 DIODE
L1 VX1 VX3 1n
M1 VX1 VS1 VIN VDD pch l=0.15 w=1 nf=1 m=1
M2 VX2 VS2 VIN VDD pch l=0.15 w=1 nf=1 m=1
M3 VP VS3 VX3 VDD pch l=0.15 w=1 nf=1 m=1
M4 VX3 VS4 VSS VSS nch l=0.15 w=1 nf=1 m=1
M5 net0 VS5 VIN VDD pch l=0.15 w=1 nf=1 m=1
MN11 net2 net1 VSS VSS nch l=0.15 w=1 nf=1 m=1
MN12 net1 net1 VSS VSS nch l=0.15 w=1 nf=1 m=1
MN13 net1 VB3 VSS VSS nch l=0.15 w=1 nf=1 m=1
MP10 net2 net2 net0 VDD pch l=0.15 w=1 nf=1 m=1
MP11 VX1 net2 net0 VDD pch l=0.15 w=1 nf=1 m=1
MP12 net1 VCTRL net0 VDD pch l=0.15 w=1 nf=1 m=1
R1 VP VFP1 1k
R2 VFP1 VSS 1k
X1 VDD VSS VFP1 VREF VX3 VCTRL EA1
.ends dut
