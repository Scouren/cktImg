* official Analog Canvas netlist; PDK X cards rewritten by convert.py
.model nch nmos
.model pch pmos

.subckt dut VDD VSS Vb Vin1 Vin2 Vout
M1 X Vin1 net0 VDD pch l=0.15 w=1 nf=1 m=1
M2 Y Vin2 net0 VDD pch l=0.15 w=1 nf=1 m=1
M3 X X VSS VSS nch l=0.15 w=1 nf=1 m=1
M4 Y X VSS VSS nch l=0.15 w=1 nf=1 m=1
M5 Vout Y VSS VSS nch l=0.15 w=1 nf=1 m=1
M6 Vout Vb VDD VDD pch l=0.15 w=1 nf=1 m=1
M7 net0 Vb VDD VDD pch l=0.15 w=1 nf=1 m=1
.ends dut
