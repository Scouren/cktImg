* official Analog Canvas netlist; PDK X cards rewritten by convert.py
.model qnpn npn

.subckt dut VDD VSS VREF
IPTAT VDD net1 DC 1m
Q1 net3 net3 net4 VSS qnpn m=1
Q2 net0 net0 net3 VSS qnpn m=1
Q3 net1 VDD net0 VSS qnpn m=1
Q4 net2 net2 VREF VSS qnpn m=1
Q5 VDD VDD net2 VSS qnpn m=1
Q6 VDD net1 VDD VSS qnpn m=1
R2 net4 VSS 1k
R3 VREF VSS 1k
.ends dut
