* official Analog Canvas netlist; PDK X cards rewritten by convert.py
.model nch nmos
.model pch pmos

.subckt dut VDD VSS Iout
IREF VDD net1 DC 1m
M1 net1 net1 VSS VSS nch l=0.15 w=1 nf=1 m=1
M2 net0 net1 VSS VSS nch l=0.15 w=1 nf=1 m=1
M3 net0 net0 VDD VDD pch l=0.15 w=1 nf=1 m=1
M4 Iout net0 VDD VDD pch l=0.15 w=1 nf=1 m=1
.ends dut
