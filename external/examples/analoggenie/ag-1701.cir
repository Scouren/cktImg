* official Analog Canvas netlist; PDK X cards rewritten by convert.py
.model nch nmos
.model pch pmos
.model qpnp pnp

.subckt opamp VDD VSS INN INP OUT
M1 net2 INN net8 VSS nch l=0.15 w=1 nf=1 m=1
M10 VB3 VB2 VDD VDD pch l=0.15 w=1 nf=1 m=1
M11 VB3 VB3 VSS VSS nch l=0.15 w=1 nf=1 m=1
M12 VB2 VB2 VDD VDD pch l=0.15 w=1 nf=1 m=1
M13 VB2 net7 VSS VSS nch l=0.15 w=1 nf=1 m=1
M14 net0 VB2 VDD VDD pch l=0.15 w=1 nf=1 m=1
M15 net0 net0 net7 VSS nch l=0.15 w=1 nf=1 m=1
M16 net7 net0 net6 VSS nch l=0.15 w=1 nf=1 m=1
M17 net5 VB2 VDD VDD pch l=0.15 w=1 nf=1 m=1
M18 net5 net5 net6 VSS nch l=0.15 w=1 nf=1 m=1
M19 net6 net5 net4 VSS nch l=0.15 w=1 nf=1 m=1
M2 net1 INP net8 VSS nch l=0.15 w=1 nf=1 m=1
M20 net4 net4 VSS VSS nch l=0.15 w=1 nf=1 m=1
M21 net4 VB2 VDD VDD pch l=0.15 w=1 nf=1 m=1
M3 net2 net2 VDD VDD pch l=0.15 w=1 nf=1 m=1
M4 net1 net1 VDD VDD pch l=0.15 w=1 nf=1 m=1
M5 net3 net2 VDD VDD pch l=0.15 w=1 nf=1 m=1
M6 OUT net1 VDD VDD pch l=0.15 w=1 nf=1 m=1
M7 net3 net3 VSS VSS nch l=0.15 w=1 nf=1 m=1
M8 OUT net3 VSS VSS nch l=0.15 w=1 nf=1 m=1
M9 net8 VB3 VSS VSS nch l=0.15 w=1 nf=1 m=1
.ends opamp

.subckt dut VDD VSS Vout
Q1 VSS VSS net1 qpnp m=1
Q2 net1 net1 X qpnp m=1
Q3 VSS VSS net0 qpnp m=1
Q4 net0 net0 net2 qpnp m=1
R1 Vout X 1k
R2 Vout Y 1k
R3 Y net2 1k
X1 VDD VSS Y X Vout opamp
.ends dut
