* official Analog Canvas netlist; PDK X cards rewritten by convert.py
.model nch nmos
.model pch pmos

.subckt dut VDD VSS Vout
C1 Y net1 1p
C2 VSS net2 1p
I1 VDD net2 DC 1m
M1 Y X VSS VSS nch l=0.15 w=1 nf=1 m=1
M2 Vout X VSS VSS nch l=0.15 w=1 nf=1 m=1
M3 VDD net1 Vout VSS nch l=0.15 w=1 nf=1 m=1
M4 Y X net2 VDD pch l=0.15 w=1 nf=1 m=1
RB VDD net1 1k
RF X Y 1k
RS net0 X 1k
Vin net0 VSS DC 1
.ends dut
