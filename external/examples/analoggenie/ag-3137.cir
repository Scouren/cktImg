* official Analog Canvas netlist; PDK X cards rewritten by convert.py
.model nch nmos
.model pch pmos

.subckt opamp VDD VSS INN INP OUT
M10 OUT net5 VDD VDD pch l=0.15 w=1 nf=1 m=1
M11 VX VX VSS VSS nch l=0.15 w=1 nf=1 m=1
M12 OUT VX VSS VSS nch l=0.15 w=1 nf=1 m=1
M13 VB1 VB1 VDD VDD pch l=0.15 w=1 nf=1 m=1
M14 VB1 VB3 VSS VSS nch l=0.15 w=1 nf=1 m=1
M15 VB3 net1 VDD VDD pch l=0.15 w=1 nf=1 m=1
M16 VB3 VB3 VSS VSS nch l=0.15 w=1 nf=1 m=1
M17 net1 net1 VDD VDD pch l=0.15 w=1 nf=1 m=1
M18 net1 net3 VSS VSS nch l=0.15 w=1 nf=1 m=1
M19 net3 VB2 VDD VDD pch l=0.15 w=1 nf=1 m=1
M20 net0 net3 VSS VSS nch l=0.15 w=1 nf=1 m=1
M21 VB2 VB2 VDD VDD pch l=0.15 w=1 nf=1 m=1
M22 VB2 net3 VSS VSS nch l=0.15 w=1 nf=1 m=1
M3 INN INN net4 VSS nch l=0.15 w=1 nf=1 m=1
M4 net5 INP net4 VSS nch l=0.15 w=1 nf=1 m=1
M5 INN net2 VDD VDD pch l=0.15 w=1 nf=1 m=1
M6 net5 net2 VDD VDD pch l=0.15 w=1 nf=1 m=1
M7 net4 VB3 VSS VSS nch l=0.15 w=1 nf=1 m=1
M9 VX INN VDD VDD pch l=0.15 w=1 nf=1 m=1
R1 net3 net0 1k
.ends opamp

.subckt dut VDD VSS vci phi1 phi2 vco
C1 net0 VSS 1p
C2 net1 vco 1p
M1 vci phi1 net0 VSS nch l=0.15 w=1 nf=1 m=1
M2 net0 phi2 net1 VSS nch l=0.15 w=1 nf=1 m=1
X1 VDD VSS net1 VSS vco opamp
.ends dut
