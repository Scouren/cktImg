* official Analog Canvas netlist; PDK X cards rewritten by convert.py
.model nch nmos
.model pch pmos

.subckt dut VDD VSS VCONT1 VCONT2 VCONT3 VIN VCONT4 VCONT5 VP VB3
.model DIODE D(IS=1e-14 N=1)
CFLY VX1 VX2 1p
CO VP VN 1p
COP VP VSS 1p
D1 VN VX2 DIODE
L1 VX1 VX3 1n
M1 VX1 VCONT2 VIN VDD pch l=0.15 w=1 nf=1 m=1
M2 VX2 VCONT3 VIN VDD pch l=0.15 w=1 nf=1 m=1
M3 VX3 VCONT5 VP VDD pch l=0.15 w=1 nf=1 m=1
M4 VX3 VCONT4 VSS VSS nch l=0.15 w=1 nf=1 m=1
M5 net6 VCONT1 VIN VDD pch l=0.15 w=1 nf=1 m=1
MN1 net1 VFP1 net5 VSS nch l=0.15 w=1 nf=1 m=1
MN10 VB1 net7 VSS VSS nch l=0.15 w=1 nf=1 m=1
MN11 VB2 net4 net7 VSS nch l=0.15 w=1 nf=1 m=1
MN12 net4 net7 VSS VSS nch l=0.15 w=1 nf=1 m=1
MN2 VX3 VREF net5 VSS nch l=0.15 w=1 nf=1 m=1
MN3 net5 VBN VSS VSS nch l=0.15 w=1 nf=1 m=1
MN4 net3 net3 VSS VSS nch l=0.15 w=1 nf=1 m=1
MN5 VEA net3 VSS VSS nch l=0.15 w=1 nf=1 m=1
MN6 net0 net0 VSS VSS nch l=0.15 w=1 nf=1 m=1
MN7 net0 VB3 VSS VSS nch l=0.15 w=1 nf=1 m=1
MN8 net2 net0 VSS VSS nch l=0.15 w=1 nf=1 m=1
MN9 VBN VBN VSS VSS nch l=0.15 w=1 nf=1 m=1
MP1 net1 net1 VDD VDD pch l=0.15 w=1 nf=1 m=1
MP10 VB2 VB2 VDD VDD pch l=0.15 w=1 nf=1 m=1
MP11 net4 VB2 VDD VDD pch l=0.15 w=1 nf=1 m=1
MP2 VX3 VX3 VDD VDD pch l=0.15 w=1 nf=1 m=1
MP3 net3 net1 VDD VDD pch l=0.15 w=1 nf=1 m=1
MP4 VEA VX3 VDD VDD pch l=0.15 w=1 nf=1 m=1
MP5 net0 VEA net6 VDD pch l=0.15 w=1 nf=1 m=1
MP6 net2 net2 net6 VDD pch l=0.15 w=1 nf=1 m=1
MP7 VX1 net2 net6 VDD pch l=0.15 w=1 nf=1 m=1
MP8 VB1 VB1 VDD VDD pch l=0.15 w=1 nf=1 m=1
MP9 VBN VB1 VDD VDD pch l=0.15 w=1 nf=1 m=1
R1 VP VFP1 1k
R2 VFP1 VSS 1k
RBIAS net7 VSS 1k
.ends dut
