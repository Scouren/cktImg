* official Analog Canvas netlist; PDK X cards rewritten by convert.py
.model nch nmos

.subckt dut VDD VSS Iout
IREF VDD net0 DC 1m
M2a Iout net0 VSS VSS nch l=0.15 w=1 nf=1 m=1
M2b Iout net0 VSS VSS nch l=0.15 w=1 nf=1 m=1
MREF net0 net0 VSS VSS nch l=0.15 w=1 nf=1 m=1
.ends dut
