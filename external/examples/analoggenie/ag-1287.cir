* official Analog Canvas netlist; PDK X cards rewritten by convert.py
.model nch nmos
.model pch pmos

.subckt EA1 VDD VSS VFP1 VREF VX3 VS VB2 IOUT
MN1 net4 VFP1 net0 VSS nch l=0.15 w=1 nf=1 m=1
MN10 VB1 net6 VSS VSS nch l=0.15 w=1 nf=1 m=1
MN11 net6 net6 VSS VSS nch l=0.15 w=1 nf=1 m=1
MN2 VX3 VREF net0 VSS nch l=0.15 w=1 nf=1 m=1
MN3 net3 net3 VSS VSS nch l=0.15 w=1 nf=1 m=1
MN4 net7 net3 VSS VSS nch l=0.15 w=1 nf=1 m=1
MN5 net0 VBN VSS VSS nch l=0.15 w=1 nf=1 m=1
MN6 net2 net2 VSS VSS nch l=0.15 w=1 nf=1 m=1
MN7 net1 net2 VSS VSS nch l=0.15 w=1 nf=1 m=1
MN8 net2 VB2 VSS VSS nch l=0.15 w=1 nf=1 m=1
MN9 VBN VBN VSS VSS nch l=0.15 w=1 nf=1 m=1
MP1 net4 net4 VDD VDD pch l=0.15 w=1 nf=1 m=1
MP10 net6 net5 VDD VDD pch l=0.15 w=1 nf=1 m=1
MP11 net5 net5 VDD VDD pch l=0.15 w=1 nf=1 m=1
MP2 net3 net4 VDD VDD pch l=0.15 w=1 nf=1 m=1
MP3 VX3 VX3 VDD VDD pch l=0.15 w=1 nf=1 m=1
MP4 net7 VX3 VDD VDD pch l=0.15 w=1 nf=1 m=1
MP5 net2 net7 VS VDD pch l=0.15 w=1 nf=1 m=1
MP6 net1 net1 VS VDD pch l=0.15 w=1 nf=1 m=1
MP7 IOUT net1 VS VDD pch l=0.15 w=1 nf=1 m=1
MP8 VBN VB1 VDD VDD pch l=0.15 w=1 nf=1 m=1
MP9 VB1 VB1 VDD VDD pch l=0.15 w=1 nf=1 m=1
RBIAS net5 VSS 1k
.ends EA1

.subckt dut VDD VSS VIN VP VCONT1 VCONT5 VCONT2 VCONT3 VCONT4 VREF VB2
.model DIODE D(IS=1e-14 N=1)
CFLY VX1 VX2 1p
CO VP VSS 1p
COP VP VN 1p
D1 VN VX2 DIODE
L1 VX1 VX3 1n
M1 VX1 VCONT2 VIN VDD pch l=0.15 w=1 nf=1 m=1
M2 VX2 VCONT3 VIN VDD pch l=0.15 w=1 nf=1 m=1
M3 VP VCONT5 VX3 VDD pch l=0.15 w=1 nf=1 m=1
M4 VX3 VCONT4 VSS VSS nch l=0.15 w=1 nf=1 m=1
M5 net0 VCONT1 VIN VDD pch l=0.15 w=1 nf=1 m=1
R1 VP VFP1 1k
R2 VFP1 VSS 1k
X1 VDD VSS VFP1 VREF VX3 net0 VB2 VX1 EA1
.ends dut
