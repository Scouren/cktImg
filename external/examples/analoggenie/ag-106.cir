* official Analog Canvas netlist; PDK X cards rewritten by convert.py
.model nch nmos

.subckt dut VDD VSS Iout1 Iout2
IREF VDD net0 DC 1m
M1 Iout1 net0 VSS VSS nch l=0.15 w=1 nf=1 m=1
M2 Iout1 net0 VSS VSS nch l=0.15 w=1 nf=1 m=1
M3 Iout2 net0 net1 VSS nch l=0.15 w=1 nf=1 m=1
M4 net1 net0 VSS VSS nch l=0.15 w=1 nf=1 m=1
MREF net0 net0 VSS VSS nch l=0.15 w=1 nf=1 m=1
.ends dut
