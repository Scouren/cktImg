* official Analog Canvas netlist; PDK X cards rewritten by convert.py
.model pch pmos

.subckt dut VDD VSS Vin
C Vin net0 1p
I VDD Vin DC 1m
M1 VSS net0 Vin VDD pch l=0.15 w=1 nf=1 m=1
R net0 VSS 1k
.ends dut
