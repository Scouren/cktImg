* official Analog Canvas netlist; PDK X cards rewritten by convert.py
.model nch nmos
.model pch pmos
.model qpnp pnp

.subckt A1 VDD VSS INP INN OUT
M1 net6 INP net5 VDD pch l=0.15 w=1 nf=1 m=1
M10 VC VCN net6 VSS nch l=0.15 w=1 nf=1 m=1
M11 OUT VCN net4 VSS nch l=0.15 w=1 nf=1 m=1
M12 net6 VBN VSS VSS nch l=0.15 w=1 nf=1 m=1
M13 net4 VBN VSS VSS nch l=0.15 w=1 nf=1 m=1
M14 VCN VBP VDD VDD pch l=0.15 w=1 nf=1 m=1
M15 VCN VCN VBN VSS nch l=0.15 w=1 nf=1 m=1
M16 VBN VBN VSS VSS nch l=0.15 w=1 nf=1 m=1
M17 net2 VBP VDD VDD pch l=0.15 w=1 nf=1 m=1
M18 net2 net2 net0 VSS nch l=0.15 w=1 nf=1 m=1
M19 net0 net2 net7 VSS nch l=0.15 w=1 nf=1 m=1
M2 net4 INN net5 VDD pch l=0.15 w=1 nf=1 m=1
M20 VBP VBP VDD VDD pch l=0.15 w=1 nf=1 m=1
M21 VBP net0 VSS VSS nch l=0.15 w=1 nf=1 m=1
M22 net8 VBP VDD VDD pch l=0.15 w=1 nf=1 m=1
M23 net8 net8 net7 VSS nch l=0.15 w=1 nf=1 m=1
M24 net7 net8 VB3 VSS nch l=0.15 w=1 nf=1 m=1
M25 VB3 VB3 VSS VSS nch l=0.15 w=1 nf=1 m=1
M26 VB3 VBP VDD VDD pch l=0.15 w=1 nf=1 m=1
M5 net5 VB1 VDD VDD pch l=0.15 w=1 nf=1 m=1
M6 VC VB2 net1 VDD pch l=0.15 w=1 nf=1 m=1
M7 OUT VB2 net3 VDD pch l=0.15 w=1 nf=1 m=1
M8 net1 VC VDD VDD pch l=0.15 w=1 nf=1 m=1
M9 net3 VC VDD VDD pch l=0.15 w=1 nf=1 m=1
.ends A1

.subckt dut VDD VSS Vout
Q1 VSS VSS X qpnp m=1
Q2 VSS VSS net0 qpnp m=1
R1 Vout X 1k
R2 Vout Y 1k
R3 Y net0 1k
X1 VDD VSS X Y Vout A1
.ends dut
