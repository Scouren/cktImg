* official Analog Canvas netlist; PDK X cards rewritten by convert.py
.model nch nmos
.model pch pmos
.model qnpn npn

.subckt dut VDD VSS GND vin+ vin- vout
Cc net4 net0 1p
CL vout GND 1p
IBIAS net2 VSS DC 1m
M1 net1 vin- net3 VDD pch l=0.15 w=1 nf=1 m=1
M10 net2 net2 VDD VDD pch l=0.15 w=1 nf=1 m=1
M2 net4 vin+ net3 VDD pch l=0.15 w=1 nf=1 m=1
M3 net1 net1 VSS VSS nch l=0.15 w=1 nf=1 m=1
M4 net4 net1 VSS VSS nch l=0.15 w=1 nf=1 m=1
M5 net3 net2 VDD VDD pch l=0.15 w=1 nf=1 m=1
M6 net0 net4 VSS VSS nch l=0.15 w=1 nf=1 m=1
M7 net0 net2 VDD VDD pch l=0.15 w=1 nf=1 m=1
M9 vout net4 VSS VSS nch l=0.15 w=1 nf=1 m=1
Q8 VDD net0 vout VSS qnpn m=1
RL vout GND 1k
.ends dut
