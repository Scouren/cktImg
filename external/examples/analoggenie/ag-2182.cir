* official Analog Canvas netlist; PDK X cards rewritten by convert.py
.model nch nmos
.model pch pmos

.subckt Opamp VDD VSS INN INP OUT VB1 VB2
M1 net6 net5 VDD VDD pch l=0.15 w=1 nf=1 m=1
M10 OUT VB1 net9 VDD pch l=0.15 w=1 nf=1 m=1
M11 net5 VB1 net6 VDD pch l=0.15 w=1 nf=1 m=1
M12 net2 VB1 net8 VDD pch l=0.15 w=1 nf=1 m=1
M13 OUT VB4 net1 VSS nch l=0.15 w=1 nf=1 m=1
M14 OUT VB4 net4 VSS nch l=0.15 w=1 nf=1 m=1
M15 net0 VB2 VSS VSS nch l=0.15 w=1 nf=1 m=1
M16 VB4 net11 VDD VDD pch l=0.15 w=1 nf=1 m=1
M17 net11 net11 VDD VDD pch l=0.15 w=1 nf=1 m=1
M18 VB3 net11 VDD VDD pch l=0.15 w=1 nf=1 m=1
M19 VB4 VB4 net3 VSS nch l=0.15 w=1 nf=1 m=1
M2 net8 net2 VDD VDD pch l=0.15 w=1 nf=1 m=1
M20 net3 VB4 VSS VSS nch l=0.15 w=1 nf=1 m=1
M21 net11 VB3 VSS VSS nch l=0.15 w=1 nf=1 m=1
M22 net10 VB3 VSS VSS nch l=0.15 w=1 nf=1 m=1
M3 net2 INN net0 VSS nch l=0.15 w=1 nf=1 m=1
M4 net5 INP net0 VSS nch l=0.15 w=1 nf=1 m=1
M5 net7 net5 VDD VDD pch l=0.15 w=1 nf=1 m=1
M6 net9 net2 VDD VDD pch l=0.15 w=1 nf=1 m=1
M7 net1 OUT VSS VSS nch l=0.15 w=1 nf=1 m=1
M8 net4 OUT VSS VSS nch l=0.15 w=1 nf=1 m=1
M9 OUT VB1 net7 VDD pch l=0.15 w=1 nf=1 m=1
R1 VB3 net10 1k
.ends Opamp

.subckt dut VDD VSS VIN VOUT Vref VB1 VB2
CL VOUT net0 1p
MNP VIN net1 VOUT VSS nch l=0.15 w=1 nf=1 m=1
R1 VOUT FB 1k
R2 FB VSS 1k
R3 net0 VSS 1k
X1 VDD VSS FB Vref net1 VB1 VB2 Opamp
.ends dut
