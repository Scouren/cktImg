* official Analog Canvas netlist; PDK X cards rewritten by convert.py
.model nch nmos
.model pch pmos

* Ideal inverter: switches at V(VDD,VSS)/2; vt sets the step width, td the delay
.subckt inverter VDD VSS A Y params: vt=10m td=10p
BhA hA 0 V={0.5*(1+tanh((V(A,VSS)-0.5*V(VDD,VSS))/vt))}
Bf nfn VSS V={V(VDD,VSS)*(1-V(hA))}
Rd nfn ndl 1k
Cd ndl VSS {td/1000}
BY Y VSS V={V(ndl,VSS)}
.ends inverter

.subckt dut VDD VSS VB1 vX VCM VCMFB VB2 VB3 VB4 Q Q_bar
M1 net1 VB1 VDD VDD pch l=0.15 w=1 nf=1 m=1
M10 net15 net11 net2 VSS nch l=0.15 w=1 nf=1 m=1
M11 net2 VB2 VSS VSS nch l=0.15 w=1 nf=1 m=1
M12 net4 net4 VDD VDD pch l=0.15 w=1 nf=1 m=1
M13 vM2 net9 net3 VSS nch l=0.15 w=1 nf=1 m=1
M14 vP2 net15 net3 VSS nch l=0.15 w=1 nf=1 m=1
M15 net3 VB2 VSS VSS nch l=0.15 w=1 nf=1 m=1
M16 VOP vM2 net5 VSS nch l=0.15 w=1 nf=1 m=1
M17 VON vP2 net5 VSS nch l=0.15 w=1 nf=1 m=1
M18 net5 VB3 VSS VSS nch l=0.15 w=1 nf=1 m=1
M19 VDD VON net6 VSS nch l=0.15 w=1 nf=1 m=1
M2 net11 VB1 VDD VDD pch l=0.15 w=1 nf=1 m=1
M20 net6 net6 net13 VSS nch l=0.15 w=1 nf=1 m=1
M21 net13 VB4 VSS VSS nch l=0.15 w=1 nf=1 m=1
M22 net10 VON VDD VDD pch l=0.15 w=1 nf=1 m=1
M23 net10 net13 VSS VSS nch l=0.15 w=1 nf=1 m=1
M24 VDD VOP net12 VSS nch l=0.15 w=1 nf=1 m=1
M25 net12 net12 net0 VSS nch l=0.15 w=1 nf=1 m=1
M26 net0 VB4 VSS VSS nch l=0.15 w=1 nf=1 m=1
M27 net14 VOP VDD VDD pch l=0.15 w=1 nf=1 m=1
M28 net14 net0 VSS VSS nch l=0.15 w=1 nf=1 m=1
M3 net1 vX net8 VSS nch l=0.15 w=1 nf=1 m=1
M4 net11 VCM net8 VSS nch l=0.15 w=1 nf=1 m=1
M5 net8 VCMFB VSS VSS nch l=0.15 w=1 nf=1 m=1
M6 net11 net11 net1 VSS nch l=0.15 w=1 nf=1 m=1
M7 net1 net1 net11 VSS nch l=0.15 w=1 nf=1 m=1
M8 net7 net7 VDD VDD pch l=0.15 w=1 nf=1 m=1
M9 net9 net1 net2 VSS nch l=0.15 w=1 nf=1 m=1
R1 net7 net9 1k
R2 net7 net15 1k
R3 net4 vM2 1k
R4 net4 vP2 1k
R5 VDD VOP 1k
R6 VDD VON 1k
X1 VDD VSS net14 Q inverter td=10p vt=10m
X2 VDD VSS net10 Q_bar inverter td=10p vt=10m
.ends dut
