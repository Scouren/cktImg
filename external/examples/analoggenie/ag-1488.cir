* official Analog Canvas netlist; PDK X cards rewritten by convert.py
.model nch nmos
.model pch pmos
.model qnpn npn

.subckt dut VDD VSS Vout VB1 VB3 VB2
M1 net1 Y net2 VSS nch l=0.15 w=1 nf=1 m=1
M10 net4 VN VSS VSS nch l=0.15 w=1 nf=1 m=1
M11 net2 VB2 VSS VSS nch l=0.15 w=1 nf=1 m=1
M12 VP VP VDD VDD pch l=0.15 w=1 nf=1 m=1
M13 VP VB4 VSS VSS nch l=0.15 w=1 nf=1 m=1
M14 VB4 VP VDD VDD pch l=0.15 w=1 nf=1 m=1
M15 VB4 VB4 VSS VSS nch l=0.15 w=1 nf=1 m=1
M16 VC VP VDD VDD pch l=0.15 w=1 nf=1 m=1
M17 VC VC Z VSS nch l=0.15 w=1 nf=1 m=1
M18 Z VC VSS VSS nch l=0.15 w=1 nf=1 m=1
M2 net0 X net2 VSS nch l=0.15 w=1 nf=1 m=1
M3 net1 VB1 VDD VDD pch l=0.15 w=1 nf=1 m=1
M4 net0 VB1 VDD VDD pch l=0.15 w=1 nf=1 m=1
M5 VN VB3 net1 VDD pch l=0.15 w=1 nf=1 m=1
M6 Vout VB3 net0 VDD pch l=0.15 w=1 nf=1 m=1
M7 VN VC net3 VSS nch l=0.15 w=1 nf=1 m=1
M8 Vout VC net4 VSS nch l=0.15 w=1 nf=1 m=1
M9 net3 VN VSS VSS nch l=0.15 w=1 nf=1 m=1
Q1 X X VSS VSS qnpn m=1
Q2 Z Z VSS VSS qnpn m=1
R1 Vout X 1k
R2 Vout Y 1k
R3 Y Z 1k
.ends dut
