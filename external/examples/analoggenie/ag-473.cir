* official Analog Canvas netlist; PDK X cards rewritten by convert.py
.model nch nmos

.subckt dut VDD VSS Vout
C1 VDD Vout 30fF
C2 Vout VSS 30fF
C3 net0 VSS 50fF
C4 net2 VSS 1pF
C5 net0 VSS 30fF
I1 VDD net2 DC 1mA
L1 VDD net3 10nH
LB net0 net4 10nH
M1 net1 net2 net0 VSS nch l=0.15 w=1 nf=1 m=1
M2 Vout VDD net1 VSS nch l=0.15 w=1 nf=1 m=1
M3 net2 net2 VSS VSS nch l=0.15 w=1 nf=1 m=1
R1 net3 Vout 17Ω
R2 VDD Vout 6.9kΩ
R3 VDD Vout 1kΩ
R4 net4 VSS 17Ω
R5 net0 VSS 6.9kΩ
RS net5 net0 1k
Vin net5 VSS DC 1
.ends dut
