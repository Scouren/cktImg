* official Analog Canvas netlist; PDK X cards rewritten by convert.py
.model nch nmos
.model pch pmos

.subckt dut VDD VSS VBIAS1 VBIAS2 VBIAS3
IBIAS net0 VSS DC 1m
M101 net0 net0 VBIAS1 VDD pch l=0.15 w=1 nf=1 m=1
M102 VBIAS1 VBIAS1 VDD VDD pch l=0.15 w=1 nf=1 m=1
M103 net3 VBIAS1 VDD VDD pch l=0.15 w=1 nf=1 m=1
M104 VBIAS2 net0 net3 VDD pch l=0.15 w=1 nf=1 m=1
M105 VBIAS2 VBIAS2 net2 VSS nch l=0.15 w=1 nf=1 m=1
M106 net2 VBIAS2 VSS VSS nch l=0.15 w=1 nf=1 m=1
M107 VBIAS3 VBIAS3 VSS VSS nch l=0.15 w=1 nf=1 m=1
M108 VBIAS3 net0 net1 VDD pch l=0.15 w=1 nf=1 m=1
M109 net1 VBIAS1 VDD VDD pch l=0.15 w=1 nf=1 m=1
.ends dut
