* official Analog Canvas netlist; PDK X cards rewritten by convert.py
.model nch nmos
.model pch pmos

.subckt dut VDD VSS VC1 VC2 VC3 VIN VB3 VC4 VC5 VP VREF
.model DIODE D(IS=1e-14 N=1)
CFLY VX1 VX2 1p
CO VP VN 1p
COP VP VSS 1p
D1 VN VX2 DIODE
L1 VX1 VX3 1n
MN1 net7 VFP1 net4 VSS nch l=0.15 w=1 nf=1 m=1
MN10 VB1 net5 VSS VSS nch l=0.15 w=1 nf=1 m=1
MN11 net5 net5 VSS VSS nch l=0.15 w=1 nf=1 m=1
MN12 net3 VB2 VX2 VSS nch l=0.15 w=1 nf=1 m=1
MN13 VB2 VB2 VSS VSS nch l=0.15 w=1 nf=1 m=1
MN2 VX3 VREF net4 VSS nch l=0.15 w=1 nf=1 m=1
MN3 net4 VBN VSS VSS nch l=0.15 w=1 nf=1 m=1
MN4 net0 net0 VSS VSS nch l=0.15 w=1 nf=1 m=1
MN5 VCTRL net0 VSS VSS nch l=0.15 w=1 nf=1 m=1
MN6 net2 net2 VSS VSS nch l=0.15 w=1 nf=1 m=1
MN7 net1 net2 VSS VSS nch l=0.15 w=1 nf=1 m=1
MN8 net2 VB3 VSS VSS nch l=0.15 w=1 nf=1 m=1
MN9 VBN VBN VSS VSS nch l=0.15 w=1 nf=1 m=1
MP1 net0 net7 VDD VDD pch l=0.15 w=1 nf=1 m=1
MP10 net5 net3 VDD VDD pch l=0.15 w=1 nf=1 m=1
MP11 net3 net3 VDD VDD pch l=0.15 w=1 nf=1 m=1
MP12 VB2 net3 VDD VDD pch l=0.15 w=1 nf=1 m=1
MP2 net7 net7 VDD VDD pch l=0.15 w=1 nf=1 m=1
MP3 VX3 VX3 VDD VDD pch l=0.15 w=1 nf=1 m=1
MP4 VCTRL VX3 VDD VDD pch l=0.15 w=1 nf=1 m=1
MP5 net1 net1 net6 VDD pch l=0.15 w=1 nf=1 m=1
MP6 VX1 net1 net6 VDD pch l=0.15 w=1 nf=1 m=1
MP7 net2 VCTRL net6 VDD pch l=0.15 w=1 nf=1 m=1
MP8 VBN VB1 VDD VDD pch l=0.15 w=1 nf=1 m=1
MP9 VB1 VB1 VDD VDD pch l=0.15 w=1 nf=1 m=1
MS1 VX1 VC2 VIN VDD pch l=0.15 w=1 nf=1 m=1
MS2 VX2 VC3 VIN VDD pch l=0.15 w=1 nf=1 m=1
MS3 VP VC5 VX3 VDD pch l=0.15 w=1 nf=1 m=1
MS4 VX3 VC4 VSS VSS nch l=0.15 w=1 nf=1 m=1
MS5 net6 VC1 VIN VDD pch l=0.15 w=1 nf=1 m=1
R1 VP VFP1 1k
R2 VFP1 VSS 1k
RBIAS VX2 VSS 1k
.ends dut
