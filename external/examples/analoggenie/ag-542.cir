* official Analog Canvas netlist; PDK X cards rewritten by convert.py
.model nch nmos

.subckt dut VDD VSS
I1 net7 VSS DC 1m
I2 net6 VSS DC 1m
I3 net1 VSS DC 1m
I4 net0 VSS DC 1m
L1 VDD net5 1n
L2 VDD net3 1n
L3 VDD net4 1n
L4 VDD net2 1n
M1 net5 net4 net6 VSS nch l=0.15 w=1 nf=1 m=1
M2 net5 net3 net7 VSS nch l=0.15 w=1 nf=1 m=1
M3 net3 net5 net7 VSS nch l=0.15 w=1 nf=1 m=1
M4 net3 net2 net6 VSS nch l=0.15 w=1 nf=1 m=1
M5 net4 net5 net0 VSS nch l=0.15 w=1 nf=1 m=1
M6 net4 net2 net1 VSS nch l=0.15 w=1 nf=1 m=1
M7 net2 net4 net1 VSS nch l=0.15 w=1 nf=1 m=1
M8 net2 net3 net0 VSS nch l=0.15 w=1 nf=1 m=1
.ends dut
