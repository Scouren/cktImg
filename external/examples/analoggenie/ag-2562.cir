* official Analog Canvas netlist; PDK X cards rewritten by convert.py
.model nch nmos
.model pch pmos

.subckt dut VDD VSS biasp biascas biasn Vout Vref
C1 Vset VSS 1p
C2 n3 Vout 1p
M1 Vout n3 VDD VDD pch l=0.15 w=1 nf=1 m=1
M10 Vset VCN n1 VSS nch l=0.15 w=1 nf=1 m=1
M11 n3 VCN net3 VSS nch l=0.15 w=1 nf=1 m=1
M12 n1 n3 VSS VSS nch l=0.15 w=1 nf=1 m=1
M13 net3 n3 VSS VSS nch l=0.15 w=1 nf=1 m=1
M14 net4 Vref net1 VSS nch l=0.15 w=1 nf=1 m=1
M15 net5 fb net1 VSS nch l=0.15 w=1 nf=1 m=1
M16 net1 VTN VSS VSS nch l=0.15 w=1 nf=1 m=1
M17 VCN net2 VDD VDD pch l=0.15 w=1 nf=1 m=1
M18 VCN VCN VTN VSS nch l=0.15 w=1 nf=1 m=1
M19 VTN VTN VSS VSS nch l=0.15 w=1 nf=1 m=1
M2 n1 Vset Vout VDD pch l=0.15 w=1 nf=1 m=1
M20 net2 net2 net0 VDD pch l=0.15 w=1 nf=1 m=1
M3 n1 biasn VSS VSS nch l=0.15 w=1 nf=1 m=1
M4 n3 biasp VDD VDD pch l=0.15 w=1 nf=1 m=1
M5 n3 biascas n1 VSS nch l=0.15 w=1 nf=1 m=1
M6 net4 VB1 VDD VDD pch l=0.15 w=1 nf=1 m=1
M7 net5 VB1 VDD VDD pch l=0.15 w=1 nf=1 m=1
M8 Vset VB2 net4 VDD pch l=0.15 w=1 nf=1 m=1
M9 n3 VB2 net5 VDD pch l=0.15 w=1 nf=1 m=1
R1 fb VSS 1k
R2 Vout fb 1k
R3 VDD net0 1k
R4 net2 VSS 1k
.ends dut
