* official Analog Canvas netlist; PDK X cards rewritten by convert.py
.model nch nmos
.model pch pmos
.model qpnp pnp

.subckt dut VDD VSS Vout
M1 X VG VDD VDD pch l=0.15 w=1 nf=1 m=1
M10 VG VB3 net7 VDD pch l=0.15 w=1 nf=1 m=1
M11 Z VB3 net2 VDD pch l=0.15 w=1 nf=1 m=1
M12 VG VB5 net1 VSS nch l=0.15 w=1 nf=1 m=1
M13 Z VB5 net8 VSS nch l=0.15 w=1 nf=1 m=1
M14 net1 Z VSS VSS nch l=0.15 w=1 nf=1 m=1
M15 net8 Z VSS VSS nch l=0.15 w=1 nf=1 m=1
M16 net6 VB5 VSS VSS nch l=0.15 w=1 nf=1 m=1
M17 VB5 VB5 net6 VSS nch l=0.15 w=1 nf=1 m=1
M18 VB5 net3 VDD VDD pch l=0.15 w=1 nf=1 m=1
M19 net3 net3 VDD VDD pch l=0.15 w=1 nf=1 m=1
M2 Vout VG VDD VDD pch l=0.15 w=1 nf=1 m=1
M20 VB4 net3 VDD VDD pch l=0.15 w=1 nf=1 m=1
M21 VB4 VB4 VSS VSS nch l=0.15 w=1 nf=1 m=1
M22 net3 VB4 net4 VSS nch l=0.15 w=1 nf=1 m=1
M3 net0 VG VDD VDD pch l=0.15 w=1 nf=1 m=1
M4 Z VG VDD VDD pch l=0.15 w=1 nf=1 m=1
M5 net2 X Y VSS nch l=0.15 w=1 nf=1 m=1
M6 net7 VB1 VDD VDD pch l=0.15 w=1 nf=1 m=1
M7 net2 VB1 VDD VDD pch l=0.15 w=1 nf=1 m=1
M8 net7 Y Y VSS nch l=0.15 w=1 nf=1 m=1
M9 Y VB2 VSS VSS nch l=0.15 w=1 nf=1 m=1
Q1 VSS VSS net0 qpnp m=1
Q2 VSS net0 X qpnp m=1
Q3 VSS VSS Z qpnp m=1
Q4 VSS Z net5 qpnp m=1
R1 Y net5 1k
R2 Vout Y 1k
R3 net4 VSS 1k
.ends dut
