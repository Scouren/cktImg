* official Analog Canvas netlist; PDK X cards rewritten by convert.py
.model nch nmos
.model pch pmos

.subckt bias VDD VSS VX VB5 VB6
M22 VB6 VB6 VSS VSS nch l=0.15 w=1 nf=1 m=1
M23 VB5 VB5 VB6 VSS nch l=0.15 w=1 nf=1 m=1
M24 VB5 net0 VDD VDD pch l=0.15 w=1 nf=1 m=1
M25 VX VB3 VSS VSS nch l=0.15 w=1 nf=1 m=1
M26 VX net0 VDD VDD pch l=0.15 w=1 nf=1 m=1
M27 net0 VX VB3 VSS nch l=0.15 w=1 nf=1 m=1
M28 net0 net0 VDD VDD pch l=0.15 w=1 nf=1 m=1
R3 VB3 VSS 1k
.ends bias

.subckt dut VDD VSS VREF VB1 VB4 VIN VOUT
CL VOUT net2 1p
M10 EAO VB2 VZ VDD pch l=0.15 w=1 nf=1 m=1
M11 net4 VY VDD VDD pch l=0.15 w=1 nf=1 m=1
M12 VZ VY VDD VDD pch l=0.15 w=1 nf=1 m=1
M13 net3 VB4 VDD VDD pch l=0.15 w=1 nf=1 m=1
M14 VY EAO net3 VDD pch l=0.15 w=1 nf=1 m=1
M15 VY VY VSS VSS nch l=0.15 w=1 nf=1 m=1
M16 GATE VY VSS VSS nch l=0.15 w=1 nf=1 m=1
M17 VDD net3 GATE VSS nch l=0.15 w=1 nf=1 m=1
M18 VZ EAO IBUF VSS nch l=0.15 w=1 nf=1 m=1
M19 VZ VZ VDD VDD pch l=0.15 w=1 nf=1 m=1
M2 VX VB1 VDD VDD pch l=0.15 w=1 nf=1 m=1
M20 GATE VZ VDD VDD pch l=0.15 w=1 nf=1 m=1
M21 VSS IBUF GATE VDD pch l=0.15 w=1 nf=1 m=1
M3 net0 VREF VX VDD pch l=0.15 w=1 nf=1 m=1
M4 net1 FB VX VDD pch l=0.15 w=1 nf=1 m=1
M5 net0 VB6 VSS VSS nch l=0.15 w=1 nf=1 m=1
M6 net1 VB6 VSS VSS nch l=0.15 w=1 nf=1 m=1
M7 VY VB5 net0 VSS nch l=0.15 w=1 nf=1 m=1
M8 EAO VB5 net1 VSS nch l=0.15 w=1 nf=1 m=1
M9 VY VB2 net4 VDD pch l=0.15 w=1 nf=1 m=1
MNP VIN GATE VOUT VSS nch l=0.15 w=1 nf=1 m=1
R1 FB VSS 1k
R2 VOUT FB 1k
R4 net2 VSS 1k
RL VOUT VSS 1k
X1 VDD VSS VX VB5 VB6 bias
.ends dut
