* official Analog Canvas netlist; PDK X cards rewritten by convert.py
.model nch nmos

.subckt icm_opamp_vdd_vss VDD VSS VIP VIN VOUT params: gain=1e6
Blin nlin 0 V={gain*(V(VIP)-V(VIN))}
Bcore VOUT 0 V={0.5*(V(VDD)+(0.5*(V(VSS)+V(nlin)+sqrt((V(nlin)-V(VSS))*(V(nlin)-V(VSS))+(1e-4*(V(VDD)-V(VSS)))*(1e-4*(V(VDD)-V(VSS)))+1e-12)))-sqrt((V(VDD)-(0.5*(V(VSS)+V(nlin)+sqrt((V(nlin)-V(VSS))*(V(nlin)-V(VSS))+(1e-4*(V(VDD)-V(VSS)))*(1e-4*(V(VDD)-V(VSS)))+1e-12))))*(V(VDD)-(0.5*(V(VSS)+V(nlin)+sqrt((V(nlin)-V(VSS))*(V(nlin)-V(VSS))+(1e-4*(V(VDD)-V(VSS)))*(1e-4*(V(VDD)-V(VSS)))+1e-12))))+(1e-4*(V(VDD)-V(VSS)))*(1e-4*(V(VDD)-V(VSS)))+1e-12))}
.ends icm_opamp_vdd_vss

.subckt dut Vref VSS Vout b3 b3_bar b2 b2_bar b1 b1_bar
M1 net10 b3 net3 VSS nch l=0.15 w=1 nf=1 m=1
M10 net9 b2_bar net12 VSS nch l=0.15 w=1 nf=1 m=1
M11 net13 b2 net6 VSS nch l=0.15 w=1 nf=1 m=1
M12 net4 b2_bar net6 VSS nch l=0.15 w=1 nf=1 m=1
M13 net12 b1 net1 VSS nch l=0.15 w=1 nf=1 m=1
M14 net6 b1_bar net1 VSS nch l=0.15 w=1 nf=1 m=1
M2 net11 b3_bar net3 VSS nch l=0.15 w=1 nf=1 m=1
M3 net7 b3 net9 VSS nch l=0.15 w=1 nf=1 m=1
M4 net0 b3_bar net9 VSS nch l=0.15 w=1 nf=1 m=1
M5 net2 b3 net13 VSS nch l=0.15 w=1 nf=1 m=1
M6 net8 b3_bar net13 VSS nch l=0.15 w=1 nf=1 m=1
M7 net5 b3 net4 VSS nch l=0.15 w=1 nf=1 m=1
M8 VSS b3_bar net4 VSS nch l=0.15 w=1 nf=1 m=1
M9 net3 b2 net12 VSS nch l=0.15 w=1 nf=1 m=1
R1 Vref net10 1k
R2 net10 net11 1k
R3 net11 net7 1k
R4 net7 net0 1k
R5 net0 net2 1k
R6 net2 net8 1k
R7 net8 net5 1k
R8 net5 VSS 1k
X1 Vref VSS net1 Vout Vout icm_opamp_vdd_vss gain=1e6
.ends dut
