* official Analog Canvas netlist; PDK X cards rewritten by convert.py
.model nch nmos
.model pch pmos
.model qnpn npn

.subckt dut VDD VSS Vout
M1 VQ2 net1 VDD VDD pch l=0.15 w=1 nf=1 m=1
M10 VB1 VB1 VDD VDD pch l=0.15 w=1 nf=1 m=1
M11 VB1 net3 VSS VSS nch l=0.15 w=1 nf=1 m=1
M12 net3 VB2 VDD VDD pch l=0.15 w=1 nf=1 m=1
M13 net3 net3 VSS VSS nch l=0.15 w=1 nf=1 m=1
M14 VB2 VB2 VDD VDD pch l=0.15 w=1 nf=1 m=1
M15 VB2 net3 net4 VSS nch l=0.15 w=1 nf=1 m=1
M16 VB3 VB1 VDD VDD pch l=0.15 w=1 nf=1 m=1
M17 VB3 VB3 VSS VSS nch l=0.15 w=1 nf=1 m=1
M2 net1 net1 VDD VDD pch l=0.15 w=1 nf=1 m=1
M3 net0 net0 VDD VDD pch l=0.15 w=1 nf=1 m=1
M4 Vout net0 VDD VDD pch l=0.15 w=1 nf=1 m=1
M5 VQ2 VQ2 VSS VSS nch l=0.15 w=1 nf=1 m=1
M6 net1 Y net2 VSS nch l=0.15 w=1 nf=1 m=1
M7 net0 X net2 VSS nch l=0.15 w=1 nf=1 m=1
M8 Vout VQ2 VSS VSS nch l=0.15 w=1 nf=1 m=1
M9 net2 VB3 VSS VSS nch l=0.15 w=1 nf=1 m=1
Q1 X X VSS VSS qnpn m=1
Q2 VQ2 VQ2 VSS VSS qnpn m=1
R1 Vout X 1k
R2 Vout Y 1k
R3 Y VQ2 1k
R4 net4 VSS 1k
.ends dut
