* official Analog Canvas netlist; PDK X cards rewritten by convert.py
.model nch nmos
.model pch pmos
.model qnpn npn

.subckt dut VDD VSS Vout
M1 net4 net4 VDD VDD pch l=0.15 w=1 nf=1 m=1
M10 net0 net0 net1 VSS nch l=0.15 w=1 nf=1 m=1
M11 VB1 net0 VSS VSS nch l=0.15 w=1 nf=1 m=1
M12 VB1 VB1 VDD VDD pch l=0.15 w=1 nf=1 m=1
M13 VB2 VB1 VDD VDD pch l=0.15 w=1 nf=1 m=1
M14 VB2 VB2 VSS VSS nch l=0.15 w=1 nf=1 m=1
M2 net2 net2 VDD VDD pch l=0.15 w=1 nf=1 m=1
M3 net2 Y net3 VSS nch l=0.15 w=1 nf=1 m=1
M4 net4 X net3 VSS nch l=0.15 w=1 nf=1 m=1
M5 Vout net4 VDD VDD pch l=0.15 w=1 nf=1 m=1
M6 VZ net2 VDD VDD pch l=0.15 w=1 nf=1 m=1
M7 VZ VZ VSS VSS nch l=0.15 w=1 nf=1 m=1
M8 net3 VB2 VSS VSS nch l=0.15 w=1 nf=1 m=1
M9 Vout VZ VSS VSS nch l=0.15 w=1 nf=1 m=1
Q1 X X VSS VSS qnpn m=1
Q2 VZ VZ VSS VSS qnpn m=1
R1 Vout X 1k
R2 Vout Y 1k
R3 Y VZ 1k
R4 VDD net0 1k
R5 net1 VSS 1k
.ends dut
