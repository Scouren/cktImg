* official Analog Canvas netlist; PDK X cards rewritten by convert.py
.model nch nmos
.model pch pmos

.subckt dut VDD VSS vinp vinn VBIAS vout
Cc net3 vout 1p
M1 net0 vinn net5 VDD pch l=0.15 w=1 nf=1 m=1
M10 net2 net2 VDD VDD pch l=0.15 w=1 nf=1 m=1
M11 net2 VBIAS VSS VSS nch l=0.15 w=1 nf=1 m=1
M2 net3 vinp net5 VDD pch l=0.15 w=1 nf=1 m=1
M3 net1 net1 VSS VSS nch l=0.15 w=1 nf=1 m=1
M4 net4 net1 VSS VSS nch l=0.15 w=1 nf=1 m=1
M5 net5 net2 VDD VDD pch l=0.15 w=1 nf=1 m=1
M6 vout net4 VSS VSS nch l=0.15 w=1 nf=1 m=1
M7 vout net2 VDD VDD pch l=0.15 w=1 nf=1 m=1
M8 net1 VBIAS net0 VDD pch l=0.15 w=1 nf=1 m=1
M9 net4 VBIAS net3 VDD pch l=0.15 w=1 nf=1 m=1
.ends dut
