* official Analog Canvas netlist; PDK X cards rewritten by convert.py
.model nch nmos
.model pch pmos

.subckt opamp VDD VSS INN INP OUT VX
M10 VB2 VB2 VDD VDD pch l=0.15 w=1 nf=1 m=1
M11 VC VC VB2 VDD pch l=0.15 w=1 nf=1 m=1
M12 VC net0 VSS VSS nch l=0.15 w=1 nf=1 m=1
M13 net0 net0 VSS VSS nch l=0.15 w=1 nf=1 m=1
M14 net2 net0 VSS VSS nch l=0.15 w=1 nf=1 m=1
M3 net1 INN VX VSS nch l=0.15 w=1 nf=1 m=1
M4 OUT INP VX VSS nch l=0.15 w=1 nf=1 m=1
M5 net3 net1 VDD VDD pch l=0.15 w=1 nf=1 m=1
M6 net4 net1 VDD VDD pch l=0.15 w=1 nf=1 m=1
M7 net1 VC net3 VDD pch l=0.15 w=1 nf=1 m=1
M8 OUT VC net4 VDD pch l=0.15 w=1 nf=1 m=1
M9 VX VB1 VSS VSS nch l=0.15 w=1 nf=1 m=1
R1 VDD net0 1k
R2 VDD net2 1k
R3 net0 net2 1k
.ends opamp

.subckt dut VDD VSS vci phi1 phi2 vco
C1 vcx VSS 1p
C2 net0 vco 1p
M1 vci phi1 vcx VSS nch l=0.15 w=1 nf=1 m=1
M2 vcx phi2 net0 VSS nch l=0.15 w=1 nf=1 m=1
X1 VDD VSS net0 VSS vco vcx opamp
.ends dut
