* official Analog Canvas netlist; PDK X cards rewritten by convert.py
.model nch nmos
.model pch pmos

.subckt bias VDD VSS VBN
M22 VB2 net0 VDD VDD pch l=0.15 w=1 nf=1 m=1
M23 VB2 VB2 VSS VSS nch l=0.15 w=1 nf=1 m=1
M24 net0 net0 VDD VDD pch l=0.15 w=1 nf=1 m=1
M25 net0 VB2 VSS VSS nch l=0.15 w=1 nf=1 m=1
M26 VBN net0 VDD VDD pch l=0.15 w=1 nf=1 m=1
M27 VBN VBN VSS VSS nch l=0.15 w=1 nf=1 m=1
M28 VB1 VB1 VDD VDD pch l=0.15 w=1 nf=1 m=1
M29 VB1 VBN VSS VSS nch l=0.15 w=1 nf=1 m=1
.ends bias

.subckt dut VDD VSS VREF VB4 IBUF VIN VOUT
CL VOUT net4 1p
M1 net2 net2 VDD VDD pch l=0.15 w=1 nf=1 m=1
M10 EAO net3 VDD VDD pch l=0.15 w=1 nf=1 m=1
M13 net1 VB4 VDD VDD pch l=0.15 w=1 nf=1 m=1
M14 VX EAO net1 VDD pch l=0.15 w=1 nf=1 m=1
M15 VX VX VSS VSS nch l=0.15 w=1 nf=1 m=1
M16 GATE VX VSS VSS nch l=0.15 w=1 nf=1 m=1
M17 VDD net1 GATE VSS nch l=0.15 w=1 nf=1 m=1
M18 net0 EAO IBUF VSS nch l=0.15 w=1 nf=1 m=1
M19 net0 net0 VDD VDD pch l=0.15 w=1 nf=1 m=1
M2 net3 net3 VDD VDD pch l=0.15 w=1 nf=1 m=1
M20 GATE net0 VDD VDD pch l=0.15 w=1 nf=1 m=1
M21 VSS IBUF GATE VDD pch l=0.15 w=1 nf=1 m=1
M3 net3 VREF VX VSS nch l=0.15 w=1 nf=1 m=1
M4 net2 FB VX VSS nch l=0.15 w=1 nf=1 m=1
M5 VX VBN VSS VSS nch l=0.15 w=1 nf=1 m=1
M7 net5 net5 VSS VSS nch l=0.15 w=1 nf=1 m=1
M8 EAO net5 VSS VSS nch l=0.15 w=1 nf=1 m=1
M9 net5 net2 VDD VDD pch l=0.15 w=1 nf=1 m=1
MNP VIN GATE VOUT VSS nch l=0.15 w=1 nf=1 m=1
R1 FB VSS 1k
R2 VOUT FB 1k
RESR net4 VSS 1k
RL VOUT VSS 1k
X1 VDD VSS VBN bias
.ends dut
