* official Analog Canvas netlist; PDK X cards rewritten by convert.py
.model nch nmos
.model pch pmos

.subckt dut VDD VSS IB1 VB1 IB2 IB3
L0 net1 net0 1n
L1 net1 net2 1n
L2 net2 net0 1n
M0 net1 IB1 VDD VDD pch l=0.15 w=1 nf=1 m=1
M1 IB1 IB1 VDD VDD pch l=0.15 w=1 nf=1 m=1
M2 VB1 net2 VB1 VSS nch l=0.15 w=1 nf=1 m=1
M3 VB1 net0 VB1 VSS nch l=0.15 w=1 nf=1 m=1
M4 net2 net0 VSS VSS nch l=0.15 w=1 nf=1 m=1
M5 net0 net2 VSS VSS nch l=0.15 w=1 nf=1 m=1
M6 IB2 net0 VSS VSS nch l=0.15 w=1 nf=1 m=1
M7 IB3 net2 VSS VSS nch l=0.15 w=1 nf=1 m=1
.ends dut
