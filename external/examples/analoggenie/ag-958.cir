* official Analog Canvas netlist; PDK X cards rewritten by convert.py
.model nch nmos
.model pch pmos

.subckt dut VDD VSS i1 i2 iO
VB1 net2 VSS DC 1
VB2 net1 VSS DC 1
M1 net0 net2 i1 VSS nch l=0.15 w=1 nf=1 m=1
M2 iO net2 i2 VSS nch l=0.15 w=1 nf=1 m=1
M3 net0 net0 VDD VDD pch l=0.15 w=1 nf=1 m=1
M4 iO net0 VDD VDD pch l=0.15 w=1 nf=1 m=1
M5 i1 net1 VSS VSS nch l=0.15 w=1 nf=1 m=1
M6 i2 net1 VSS VSS nch l=0.15 w=1 nf=1 m=1
.ends dut
