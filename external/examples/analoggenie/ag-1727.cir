* official Analog Canvas netlist; PDK X cards rewritten by convert.py
.model nch nmos
.model pch pmos
.model qpnp pnp

.subckt A1 VDD VSS INN INP OUT
M1 net5 net5 VDD VDD pch l=0.15 w=1 nf=1 m=1
M10 VB1 VB3 VSS VSS nch l=0.15 w=1 nf=1 m=1
M11 VB3 net0 VDD VDD pch l=0.15 w=1 nf=1 m=1
M12 VB3 VB3 VSS VSS nch l=0.15 w=1 nf=1 m=1
M13 net0 net0 VDD VDD pch l=0.15 w=1 nf=1 m=1
M14 net0 VB2 VSS VSS nch l=0.15 w=1 nf=1 m=1
M15 VB2 net0 VDD VDD pch l=0.15 w=1 nf=1 m=1
M16 net1 VB2 VSS VSS nch l=0.15 w=1 nf=1 m=1
M17 net3 VB3 VSS VSS nch l=0.15 w=1 nf=1 m=1
M2 net4 net4 VDD VDD pch l=0.15 w=1 nf=1 m=1
M3 net4 INN net3 VSS nch l=0.15 w=1 nf=1 m=1
M4 net5 INP net3 VSS nch l=0.15 w=1 nf=1 m=1
M5 OUT net5 VDD VDD pch l=0.15 w=1 nf=1 m=1
M6 net2 net4 VDD VDD pch l=0.15 w=1 nf=1 m=1
M7 OUT net2 VSS VSS nch l=0.15 w=1 nf=1 m=1
M8 net2 net2 VSS VSS nch l=0.15 w=1 nf=1 m=1
M9 VB1 VB1 VDD VDD pch l=0.15 w=1 nf=1 m=1
R1 VB2 net1 1k
.ends A1

.subckt dut VDD VSS Vout
Q1 VSS VSS net0 qpnp m=1
Q2 net0 net0 X qpnp m=1
Q3 VSS VSS net2 qpnp m=1
Q4 net2 net2 net1 qpnp m=1
R1 Vout X 1k
R2 Vout Y 1k
R3 Y net1 1k
X1 VDD VSS Y X Vout A1
.ends dut
