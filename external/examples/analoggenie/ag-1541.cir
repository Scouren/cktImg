* official Analog Canvas netlist; PDK X cards rewritten by convert.py
.model nch nmos
.model pch pmos
.model qnpn npn

.subckt opamp VDD VSS INN INP OUT VX
M1 net3 net3 VDD VDD pch l=0.15 w=1 nf=1 m=1
M10 VB2 VB2 VDD VDD pch l=0.15 w=1 nf=1 m=1
M11 net2 VB2 VDD VDD pch l=0.15 w=1 nf=1 m=1
M12 net0 net0 VDD VDD pch l=0.15 w=1 nf=1 m=1
M13 VB3 net0 VDD VDD pch l=0.15 w=1 nf=1 m=1
M14 VB1 VB1 VDD VDD pch l=0.15 w=1 nf=1 m=1
M15 VB2 net2 net5 VSS nch l=0.15 w=1 nf=1 m=1
M16 net2 net2 VSS VSS nch l=0.15 w=1 nf=1 m=1
M17 net0 net2 VSS VSS nch l=0.15 w=1 nf=1 m=1
M18 VB3 VB3 VSS VSS nch l=0.15 w=1 nf=1 m=1
M19 VB1 VB3 VSS VSS nch l=0.15 w=1 nf=1 m=1
M2 net1 net1 VDD VDD pch l=0.15 w=1 nf=1 m=1
M3 net1 INN net4 VSS nch l=0.15 w=1 nf=1 m=1
M4 net3 INP net4 VSS nch l=0.15 w=1 nf=1 m=1
M5 OUT net3 VDD VDD pch l=0.15 w=1 nf=1 m=1
M6 VX net1 VDD VDD pch l=0.15 w=1 nf=1 m=1
M7 net4 VB3 VSS VSS nch l=0.15 w=1 nf=1 m=1
M8 VX VX VSS VSS nch l=0.15 w=1 nf=1 m=1
M9 OUT VX VSS VSS nch l=0.15 w=1 nf=1 m=1
R4 net5 VSS 1k
.ends opamp

.subckt dut VDD VSS Vout
Q1 X X VSS VSS qnpn m=1
Q2 net0 net0 VSS VSS qnpn m=1
R1 Vout X 1k
R2 Vout Y 1k
R3 Y net0 1k
X1 VDD VSS Y X Vout net0 opamp
.ends dut
