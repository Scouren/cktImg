* official Analog Canvas netlist; PDK X cards rewritten by convert.py
.model nch nmos
.model pch pmos
.model qpnp pnp

.global VDD

.subckt A1 VSS INN INP OUT
M10 net10 net5 VDD VDD pch l=0.15 w=1 nf=1 m=1
M11 net5 VB1 net10 VDD pch l=0.15 w=1 nf=1 m=1
M12 net5 INP net0 VSS nch l=0.15 w=1 nf=1 m=1
M13 net0 VB2 VSS VSS nch l=0.15 w=1 nf=1 m=1
M14 net11 net5 VDD VDD pch l=0.15 w=1 nf=1 m=1
M15 OUT VB1 net11 VDD pch l=0.15 w=1 nf=1 m=1
M16 OUT VB4 net8 VSS nch l=0.15 w=1 nf=1 m=1
M17 net8 VX VSS VSS nch l=0.15 w=1 nf=1 m=1
M18 VB4 VB5 VDD VDD pch l=0.15 w=1 nf=1 m=1
M19 VB4 VB4 net1 VSS nch l=0.15 w=1 nf=1 m=1
M20 net1 VB4 VSS VSS nch l=0.15 w=1 nf=1 m=1
M21 VB5 VB5 VDD VDD pch l=0.15 w=1 nf=1 m=1
M22 VB5 net6 VSS VSS nch l=0.15 w=1 nf=1 m=1
M23 net12 VB5 VDD VDD pch l=0.15 w=1 nf=1 m=1
M24 net12 net12 net6 VSS nch l=0.15 w=1 nf=1 m=1
M25 net6 net12 net13 VSS nch l=0.15 w=1 nf=1 m=1
M26 net13 net9 VB3 VSS nch l=0.15 w=1 nf=1 m=1
M27 VB3 VB3 VSS VSS nch l=0.15 w=1 nf=1 m=1
M28 net9 VB5 VDD VDD pch l=0.15 w=1 nf=1 m=1
M29 net9 net9 net13 VSS nch l=0.15 w=1 nf=1 m=1
M3 net7 net4 VDD VDD pch l=0.15 w=1 nf=1 m=1
M30 VB3 VB5 VDD VDD pch l=0.15 w=1 nf=1 m=1
M4 VX VB1 net7 VDD pch l=0.15 w=1 nf=1 m=1
M5 VX VB4 net2 VSS nch l=0.15 w=1 nf=1 m=1
M6 net2 VX VSS VSS nch l=0.15 w=1 nf=1 m=1
M7 net3 net4 VDD VDD pch l=0.15 w=1 nf=1 m=1
M8 net4 VB1 net3 VDD pch l=0.15 w=1 nf=1 m=1
M9 net4 INN net0 VSS nch l=0.15 w=1 nf=1 m=1
.ends A1

.subckt dut VSS Vout
Q1 VSS VSS X qpnp m=1
Q2 VSS VSS net0 qpnp m=1
R1 Vout X 1k
R2 Vout Y 1k
R3 Y net0 1k
X1 VSS Y X Vout A1
.ends dut
