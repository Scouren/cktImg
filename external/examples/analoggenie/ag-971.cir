* official Analog Canvas netlist; PDK X cards rewritten by convert.py
.model nch nmos

.subckt dut VDD VSS Iout
I1 VDD net0 DC 100uA
I2 VDD Iout DC 100uA
Iin VSS net0 DC 1m
M1 net0 net0 VSS VSS nch l=0.15 w=1 nf=1 m=1
M2 Iout net0 VSS VSS nch l=0.15 w=1 nf=1 m=1
RL Iout VSS 0Ω
.ends dut
