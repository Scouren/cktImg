* official Analog Canvas netlist; PDK X cards rewritten by convert.py
.model qnpn npn

.subckt dut VCC VSS
I1 net0 VSS DC 1mA
I2 VCC net2 DC 50uA
I3 VCC net1 DC 50uA
Q1 net2 net2 VSS VSS qnpn m=1
Q2 VCC net2 net0 VSS qnpn m=1
Q3 VCC net1 net0 VSS qnpn m=1
Q4 net1 net1 VSS VSS qnpn m=1
.ends dut
