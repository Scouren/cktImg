* official Analog Canvas netlist; PDK X cards rewritten by convert.py
.model nch nmos
.model pch pmos

.subckt bias VDD VSS VIN VBN
M31 VBN net0 VIN VDD pch l=0.15 w=1 nf=1 m=1
M32 net0 net0 VIN VDD pch l=0.15 w=1 nf=1 m=1
M33 net3 net1 VIN VDD pch l=0.15 w=1 nf=1 m=1
M34 net1 net1 VIN VDD pch l=0.15 w=1 nf=1 m=1
M35 VBN VBN VSS VSS nch l=0.15 w=1 nf=1 m=1
M36 net0 net3 VSS VSS nch l=0.15 w=1 nf=1 m=1
M37 net3 net3 VSS VSS nch l=0.15 w=1 nf=1 m=1
M38 net1 net3 net2 VSS nch l=0.15 w=1 nf=1 m=1
R3 net2 VSS 1k
.ends bias

.subckt dut VDD VSS VREF VB4 VB3 VB5 VIN VOUT
CF1 VOUT VFB 1p
Cm1 VO1 VOUT 1p
Cm2 VZ VO1 1p
M11 net4 VBN VSS VSS nch l=0.15 w=1 nf=1 m=1
M12 VY VFB net4 VSS nch l=0.15 w=1 nf=1 m=1
M13 VX VREF net4 VSS nch l=0.15 w=1 nf=1 m=1
M14 VY VY VIN VDD pch l=0.15 w=1 nf=1 m=1
M15 VX VX VIN VDD pch l=0.15 w=1 nf=1 m=1
M16 VX VB4 VIN VDD pch l=0.15 w=1 nf=1 m=1
M17 VX VX VSS VSS nch l=0.15 w=1 nf=1 m=1
M18 VX VO1 VSS VSS nch l=0.15 w=1 nf=1 m=1
M21 net2 VO1 VSS VSS nch l=0.15 w=1 nf=1 m=1
M22 net3 VX VSS VSS nch l=0.15 w=1 nf=1 m=1
M23 net2 net2 VIN VDD pch l=0.15 w=1 nf=1 m=1
M24 net3 net2 VIN VDD pch l=0.15 w=1 nf=1 m=1
M25 VO1 VY VIN VDD pch l=0.15 w=1 nf=1 m=1
M26 net1 VX VIN VDD pch l=0.15 w=1 nf=1 m=1
M27 VO1 net1 VSS VSS nch l=0.15 w=1 nf=1 m=1
M28 net1 net1 VSS VSS nch l=0.15 w=1 nf=1 m=1
MD1 VZ VO1 VSS VSS nch l=0.15 w=1 nf=1 m=1
MD2 net0 VB5 VSS VSS nch l=0.15 w=1 nf=1 m=1
MD3 net5 VZ net0 VSS nch l=0.15 w=1 nf=1 m=1
MD4 VY VB3 net0 VSS nch l=0.15 w=1 nf=1 m=1
MD5 VZ VY VIN VDD pch l=0.15 w=1 nf=1 m=1
MD6 VY VY VIN VDD pch l=0.15 w=1 nf=1 m=1
MD7 net5 net5 VIN VDD pch l=0.15 w=1 nf=1 m=1
MPT VOUT net3 VIN VDD pch l=0.15 w=1 nf=1 m=1
RF1 VOUT VFB 1k
RF2 VFB VSS 1k
X1 VDD VSS VIN VBN bias
.ends dut
