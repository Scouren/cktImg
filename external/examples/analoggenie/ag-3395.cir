* official Analog Canvas netlist; PDK X cards rewritten by convert.py
.model nch nmos
.model pch pmos

.subckt dut VDD VSS vci phi1 phi2 vco
C1 net3 net2 1p
C2 net5 vco 1p
M1 vci phi1 net3 VSS nch l=0.15 w=1 nf=1 m=1
M10 net1 VB4 net9 VDD pch l=0.15 w=1 nf=1 m=1
M11 vco VB4 net8 VDD pch l=0.15 w=1 nf=1 m=1
M12 VB5 VB5 VDD VDD pch l=0.15 w=1 nf=1 m=1
M13 net7 VB5 VDD VDD pch l=0.15 w=1 nf=1 m=1
M14 VB2 VB5 VDD VDD pch l=0.15 w=1 nf=1 m=1
M15 VB3 VB5 VDD VDD pch l=0.15 w=1 nf=1 m=1
M16 net0 net0 VDD VDD pch l=0.15 w=1 nf=1 m=1
M17 VB5 VB2 net4 VSS nch l=0.15 w=1 nf=1 m=1
M18 net4 net7 VSS VSS nch l=0.15 w=1 nf=1 m=1
M19 net7 net7 VSS VSS nch l=0.15 w=1 nf=1 m=1
M2 net3 phi2 VSS VSS nch l=0.15 w=1 nf=1 m=1
M20 VB2 VB2 VSS VSS nch l=0.15 w=1 nf=1 m=1
M21 VB3 VB3 VSS VSS nch l=0.15 w=1 nf=1 m=1
M22 net0 VB3 VSS VSS nch l=0.15 w=1 nf=1 m=1
M3 net2 phi1 VSS VSS nch l=0.15 w=1 nf=1 m=1
M4 net2 phi2 net5 VSS nch l=0.15 w=1 nf=1 m=1
M5 net1 net5 net6 VSS nch l=0.15 w=1 nf=1 m=1
M6 vco VSS net6 VSS nch l=0.15 w=1 nf=1 m=1
M7 net6 VB3 VSS VSS nch l=0.15 w=1 nf=1 m=1
M8 net9 net1 VDD VDD pch l=0.15 w=1 nf=1 m=1
M9 net8 net1 VDD VDD pch l=0.15 w=1 nf=1 m=1
.ends dut
