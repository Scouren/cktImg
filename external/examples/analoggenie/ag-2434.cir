* official Analog Canvas netlist; PDK X cards rewritten by convert.py
.model nch nmos
.model pch pmos

.subckt AEA VDD VSS VREF OUT
M10 net6 net0 VSS VSS nch l=0.15 w=1 nf=1 m=1
M11 OUT OUT VSS VSS nch l=0.15 w=1 nf=1 m=1
M12 OUT OUT VSS VSS nch l=0.15 w=1 nf=1 m=1
M13 net0 net4 VDD VDD pch l=0.15 w=1 nf=1 m=1
M14 net0 net0 VSS VSS nch l=0.15 w=1 nf=1 m=1
M15 net4 net4 VDD VDD pch l=0.15 w=1 nf=1 m=1
M16 net4 net2 VSS VSS nch l=0.15 w=1 nf=1 m=1
M17 net2 net2 net3 VSS nch l=0.15 w=1 nf=1 m=1
M4 OUT net1 VDD VDD pch l=0.15 w=1 nf=1 m=1
M5 net1 net1 VDD VDD pch l=0.15 w=1 nf=1 m=1
M6 net5 net5 VDD VDD pch l=0.15 w=1 nf=1 m=1
M7 OUT net5 VDD VDD pch l=0.15 w=1 nf=1 m=1
M8 net1 VREF net6 VSS nch l=0.15 w=1 nf=1 m=1
M9 net5 OUT net6 VSS nch l=0.15 w=1 nf=1 m=1
R1 VDD net2 1k
R2 net3 VSS 1k
.ends AEA

.subckt dut VDD VSS VIN VOUT VERR VREF
M1 net3 net2 VIN VDD pch l=0.15 w=1 nf=1 m=1
M2 net1 net1 net3 VDD pch l=0.15 w=1 nf=1 m=1
M3 net1 nb VSS VSS nch l=0.15 w=1 nf=1 m=1
MBIAS VERR nb VSS VSS nch l=0.15 w=1 nf=1 m=1
MCHG net4 pb VIN VDD pch l=0.15 w=1 nf=1 m=1
MCTRL VERR net1 VOUT VDD pch l=0.15 w=1 nf=1 m=1
MGEN net0 net0 VSS VSS nch l=0.15 w=1 nf=1 m=1
MINJ VERR net0 VSS VSS nch l=0.15 w=1 nf=1 m=1
MRES VOUT VERR VIN VDD pch l=0.15 w=1 nf=1 m=1
MSEN net0 net2 net4 VDD pch l=0.15 w=1 nf=1 m=1
X1 VDD VSS VREF net2 AEA
.ends dut
