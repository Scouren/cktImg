* official Analog Canvas netlist; PDK X cards rewritten by convert.py
.model nch nmos

.subckt dut VDD VSS Iout
Iin VSS net0 DC 1m
M1 X net0 VSS VSS nch l=0.15 w=1 nf=1 m=1
M2 Iout X Y VSS nch l=0.15 w=1 nf=1 m=1
RD VDD X 1k
RF net0 Y 1k
RS Y VSS 1k
.ends dut
