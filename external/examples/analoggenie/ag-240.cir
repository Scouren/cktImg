* official Analog Canvas netlist; PDK X cards rewritten by convert.py
.model nch nmos

.subckt dut VDD VSS IOUT1 IIN1 VB1
M1 net0 VB1 IIN1 VSS nch l=0.15 w=1 nf=1 m=1
M2 IOUT1 net0 VSS VSS nch l=0.15 w=1 nf=1 m=1
RD VDD net0 1k
.ends dut
