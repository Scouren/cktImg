* official Analog Canvas netlist; PDK X cards rewritten by convert.py
.model nch nmos
.model pch pmos

.subckt Opamp VDD VSS INN INP VB1 VB2 OUT
M1 net7 net0 VDD VDD pch l=0.15 w=1 nf=1 m=1
M10 OUT VB1 net2 VDD pch l=0.15 w=1 nf=1 m=1
M11 net0 VB1 net7 VDD pch l=0.15 w=1 nf=1 m=1
M12 net6 VB1 net5 VDD pch l=0.15 w=1 nf=1 m=1
M13 OUT VBN net8 VSS nch l=0.15 w=1 nf=1 m=1
M14 OUT VBN net4 VSS nch l=0.15 w=1 nf=1 m=1
M15 net4 OUT VSS VSS nch l=0.15 w=1 nf=1 m=1
M16 VBN net1 VDD VDD pch l=0.15 w=1 nf=1 m=1
M17 net1 net1 VDD VDD pch l=0.15 w=1 nf=1 m=1
M18 VB3 net1 VDD VDD pch l=0.15 w=1 nf=1 m=1
M19 VBN VBN net10 VSS nch l=0.15 w=1 nf=1 m=1
M2 net5 net6 VDD VDD pch l=0.15 w=1 nf=1 m=1
M20 net10 VBN VSS VSS nch l=0.15 w=1 nf=1 m=1
M21 net1 VB3 net11 VSS nch l=0.15 w=1 nf=1 m=1
M22 VB3 VB3 VSS VSS nch l=0.15 w=1 nf=1 m=1
M3 net6 INN net3 VSS nch l=0.15 w=1 nf=1 m=1
M4 net0 INP net3 VSS nch l=0.15 w=1 nf=1 m=1
M5 net9 net0 VDD VDD pch l=0.15 w=1 nf=1 m=1
M6 net2 net6 VDD VDD pch l=0.15 w=1 nf=1 m=1
M7 net3 VB2 VSS VSS nch l=0.15 w=1 nf=1 m=1
M8 net8 OUT VSS VSS nch l=0.15 w=1 nf=1 m=1
M9 OUT VB1 net9 VDD pch l=0.15 w=1 nf=1 m=1
R4 net11 VSS 1k
.ends Opamp

.subckt dut VDD VSS VIN VOUT Vref VB1 VB2
CL VOUT net1 1p
MNP VIN net0 VOUT VSS nch l=0.15 w=1 nf=1 m=1
R1 VOUT FB 1k
R2 FB VSS 1k
R3 net1 VSS 1k
X1 VDD VSS FB Vref VB1 VB2 net0 Opamp
.ends dut
