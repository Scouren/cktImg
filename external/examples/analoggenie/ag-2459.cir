* official Analog Canvas netlist; PDK X cards rewritten by convert.py
.model nch nmos
.model pch pmos

.subckt dut VDD VSS VIN VB1 VREF VB2 VB6 VB7 VB5 VOUT
CF1 VOUT VFB 1p
Cm1 VOUT VO1 1p
Cm2 VS VO1 1p
M1 net6 net1 VIN VDD pch l=0.15 w=1 nf=1 m=1
M10 net1 VREF VS VSS nch l=0.15 w=1 nf=1 m=1
M11 net8 VFB VS VSS nch l=0.15 w=1 nf=1 m=1
M12 VO1 VCN net2 VSS nch l=0.15 w=1 nf=1 m=1
M13 net0 VX VSS VSS nch l=0.15 w=1 nf=1 m=1
M14 VS VB2 VSS VSS nch l=0.15 w=1 nf=1 m=1
M15 net2 VX VSS VSS nch l=0.15 w=1 nf=1 m=1
M16 net5 VP VIN VDD pch l=0.15 w=1 nf=1 m=1
M17 VP VP VIN VDD pch l=0.15 w=1 nf=1 m=1
M18 VB4 VP VIN VDD pch l=0.15 w=1 nf=1 m=1
M19 VCN VP VIN VDD pch l=0.15 w=1 nf=1 m=1
M2 net10 net1 VIN VDD pch l=0.15 w=1 nf=1 m=1
M20 VP VB4 VB3 VSS nch l=0.15 w=1 nf=1 m=1
M21 VCN VCN net7 VSS nch l=0.15 w=1 nf=1 m=1
M22 net5 net5 VSS VSS nch l=0.15 w=1 nf=1 m=1
M23 VB3 net5 VSS VSS nch l=0.15 w=1 nf=1 m=1
M24 VB4 VB3 VSS VSS nch l=0.15 w=1 nf=1 m=1
M25 net7 VCN VSS VSS nch l=0.15 w=1 nf=1 m=1
M26 net9 net9 VIN VDD pch l=0.15 w=1 nf=1 m=1
M27 net9 VS net11 VSS nch l=0.15 w=1 nf=1 m=1
M28 net3 net3 VIN VDD pch l=0.15 w=1 nf=1 m=1
M29 VS net3 VIN VDD pch l=0.15 w=1 nf=1 m=1
M3 VG net8 VIN VDD pch l=0.15 w=1 nf=1 m=1
M30 net3 VB7 net11 VSS nch l=0.15 w=1 nf=1 m=1
M31 VS VO1 VSS VSS nch l=0.15 w=1 nf=1 m=1
M32 net11 VB6 VSS VSS nch l=0.15 w=1 nf=1 m=1
M33 VY VY VIN VDD pch l=0.15 w=1 nf=1 m=1
M34 VG VY VIN VDD pch l=0.15 w=1 nf=1 m=1
M35 VY VO1 VSS VSS nch l=0.15 w=1 nf=1 m=1
M36 VG net4 VSS VSS nch l=0.15 w=1 nf=1 m=1
M37 net4 VB5 VIN VDD pch l=0.15 w=1 nf=1 m=1
M38 net4 net4 VSS VSS nch l=0.15 w=1 nf=1 m=1
M39 net4 VO1 VSS VSS nch l=0.15 w=1 nf=1 m=1
M4 VY net8 VIN VDD pch l=0.15 w=1 nf=1 m=1
M40 VOUT VG VIN VDD pch l=0.15 w=1 nf=1 m=1
M5 VX VB1 net6 VDD pch l=0.15 w=1 nf=1 m=1
M6 net1 VB1 net10 VDD pch l=0.15 w=1 nf=1 m=1
M7 net8 VB1 VG VDD pch l=0.15 w=1 nf=1 m=1
M8 VO1 VB1 VY VDD pch l=0.15 w=1 nf=1 m=1
M9 VX VCN net0 VSS nch l=0.15 w=1 nf=1 m=1
RF1 VOUT VFB 1k
RF2 VFB VSS 1k
.ends dut
