* official Analog Canvas netlist; PDK X cards rewritten by convert.py
.model nch nmos

.subckt dut VDD VSS VIN1 VIN2 VOUT
IIN1 VDD VIN1 DC 1m
IIN2 VDD VIN2 DC 1m
M1 net1 VIN2 VSS VSS nch l=0.15 w=1 nf=1 m=1
M2 VOUT VIN1 net1 VSS nch l=0.15 w=1 nf=1 m=1
M3 net0 VIN2 VSS VSS nch l=0.15 w=1 nf=1 m=1
M4 VIN2 VIN1 net0 VSS nch l=0.15 w=1 nf=1 m=1
M5 net2 VIN1 VSS VSS nch l=0.15 w=1 nf=1 m=1
M6 VIN1 VIN1 net2 VSS nch l=0.15 w=1 nf=1 m=1
.ends dut
