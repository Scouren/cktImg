* official Analog Canvas netlist; PDK X cards rewritten by convert.py
.model nch nmos
.model pch pmos

.subckt dut VDD VSS VSTO VCONT1 VCONT2 VCONT3 VOUT VB2 VB1
CL VOUT VSS 1p
CSTO VSTO VSS 1p
LRX VX1 VX2 1n
M10 net2 VB1 net7 VDD pch l=0.15 w=1 nf=1 m=1
M11 VX1 VB1 net10 VDD pch l=0.15 w=1 nf=1 m=1
M12 VC VB1 net3 VDD pch l=0.15 w=1 nf=1 m=1
M13 VX1 VB3 net4 VSS nch l=0.15 w=1 nf=1 m=1
M14 VC VB3 net1 VSS nch l=0.15 w=1 nf=1 m=1
M15 net4 VX1 VSS VSS nch l=0.15 w=1 nf=1 m=1
M16 net5 VB2 VSS VSS nch l=0.15 w=1 nf=1 m=1
M17 net1 VX1 VSS VSS nch l=0.15 w=1 nf=1 m=1
M18 net0 net0 VDD VDD pch l=0.15 w=1 nf=1 m=1
M19 VB3 net0 VDD VDD pch l=0.15 w=1 nf=1 m=1
M20 VB3 VB3 net9 VSS nch l=0.15 w=1 nf=1 m=1
M21 net9 VB3 VSS VSS nch l=0.15 w=1 nf=1 m=1
M3 net6 VX2 net5 VSS nch l=0.15 w=1 nf=1 m=1
M4 net2 VC net5 VSS nch l=0.15 w=1 nf=1 m=1
M5 net8 net6 VDD VDD pch l=0.15 w=1 nf=1 m=1
M6 net7 net2 VDD VDD pch l=0.15 w=1 nf=1 m=1
M7 net10 net6 VDD VDD pch l=0.15 w=1 nf=1 m=1
M8 net3 net2 VDD VDD pch l=0.15 w=1 nf=1 m=1
M9 net6 VB1 net8 VDD pch l=0.15 w=1 nf=1 m=1
MN1 VX1 VCONT2 VSS VSS nch l=0.15 w=1 nf=1 m=1
MN2 VX2 VCONT3 VSS VSS nch l=0.15 w=1 nf=1 m=1
MP2 VX2 VC VOUT VDD pch l=0.15 w=1 nf=1 m=1
MP3 VX1 VCONT1 VSTO VDD pch l=0.15 w=1 nf=1 m=1
R1 net0 VSS 1k
.ends dut
