* official Analog Canvas netlist; PDK X cards rewritten by convert.py
.model qnpn npn

.subckt dut VP VSS
I1 VP net0 DC 50uA
Q1 net0 net0 VSS VSS qnpn m=1
Q2 VP net0 VSS VSS qnpn m=1
.ends dut
