* official Analog Canvas netlist; PDK X cards rewritten by convert.py
.model nch nmos
.model pch pmos

.subckt opamp VDD VSS INP INN VB1 VB2 VB3 OUT
M1 net8 INP net1 VDD pch l=0.15 w=1 nf=1 m=1
M10 OUT VB5 net10 VSS nch l=0.15 w=1 nf=1 m=1
M11 net8 VB2 VSS VSS nch l=0.15 w=1 nf=1 m=1
M12 net10 VB2 VSS VSS nch l=0.15 w=1 nf=1 m=1
M13 net1 VB1 VDD VDD pch l=0.15 w=1 nf=1 m=1
M14 VB6 VB6 VDD VDD pch l=0.15 w=1 nf=1 m=1
M15 net6 VB6 VDD VDD pch l=0.15 w=1 nf=1 m=1
M16 net4 VB6 VDD VDD pch l=0.15 w=1 nf=1 m=1
M17 VB4 VB6 VDD VDD pch l=0.15 w=1 nf=1 m=1
M18 VB5 VB6 VDD VDD pch l=0.15 w=1 nf=1 m=1
M19 VB6 net3 VSS VSS nch l=0.15 w=1 nf=1 m=1
M2 net10 INN net1 VDD pch l=0.15 w=1 nf=1 m=1
M20 net6 net6 net3 VSS nch l=0.15 w=1 nf=1 m=1
M21 net3 net6 net5 VSS nch l=0.15 w=1 nf=1 m=1
M22 net4 net4 net5 VSS nch l=0.15 w=1 nf=1 m=1
M23 net5 net4 VB4 VSS nch l=0.15 w=1 nf=1 m=1
M24 VB4 VB4 VSS VSS nch l=0.15 w=1 nf=1 m=1
M25 VB5 VB5 net7 VSS nch l=0.15 w=1 nf=1 m=1
M26 net7 VB5 VSS VSS nch l=0.15 w=1 nf=1 m=1
M5 net0 net2 VDD VDD pch l=0.15 w=1 nf=1 m=1
M6 net9 net2 VDD VDD pch l=0.15 w=1 nf=1 m=1
M7 net2 VB3 net0 VDD pch l=0.15 w=1 nf=1 m=1
M8 OUT VB3 net9 VDD pch l=0.15 w=1 nf=1 m=1
M9 net2 VB5 net8 VSS nch l=0.15 w=1 nf=1 m=1
.ends opamp

.subckt dut VDD VSS Vref VIN VOUT VB1 VB2 VB3
CL VOUT net0 1p
M1 VIN net1 VOUT VSS nch l=0.15 w=1 nf=1 m=1
R1 VOUT FB 1k
R2 FB VSS 1k
R3 net0 VSS 1k
X1 VDD VSS Vref FB VB1 VB2 VB3 net1 opamp
.ends dut
