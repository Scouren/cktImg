* official Analog Canvas netlist; PDK X cards rewritten by convert.py
.model nch nmos
.model pch pmos

.subckt AEA VDD VSS VREF INP OUT VX
M10 net0 VX VSS VSS nch l=0.15 w=1 nf=1 m=1
M11 net4 VX VSS VSS nch l=0.15 w=1 nf=1 m=1
M12 net6 VREF net3 VSS nch l=0.15 w=1 nf=1 m=1
M13 net1 INP net3 VSS nch l=0.15 w=1 nf=1 m=1
M14 net3 VTN VSS VSS nch l=0.15 w=1 nf=1 m=1
M15 VCN net5 VDD VDD pch l=0.15 w=1 nf=1 m=1
M16 VCN VCN VTN VSS nch l=0.15 w=1 nf=1 m=1
M17 VTN VTN VSS VSS nch l=0.15 w=1 nf=1 m=1
M18 net5 net5 VDD VDD pch l=0.15 w=1 nf=1 m=1
M19 net5 VB3 net2 VSS nch l=0.15 w=1 nf=1 m=1
M20 VB3 net5 VDD VDD pch l=0.15 w=1 nf=1 m=1
M21 VB3 VB3 VSS VSS nch l=0.15 w=1 nf=1 m=1
M4 net6 VB1 VDD VDD pch l=0.15 w=1 nf=1 m=1
M5 net1 VB1 VDD VDD pch l=0.15 w=1 nf=1 m=1
M6 OUT VB2 net6 VDD pch l=0.15 w=1 nf=1 m=1
M7 VX VB2 net1 VDD pch l=0.15 w=1 nf=1 m=1
M8 OUT VCN net0 VSS nch l=0.15 w=1 nf=1 m=1
M9 VX VCN net4 VSS nch l=0.15 w=1 nf=1 m=1
R1 net2 VSS 1k
.ends AEA

.subckt dut VDD VSS VIN VREF VOUT VERR pb nb
M1 net2 VEA VIN VDD pch l=0.15 w=1 nf=1 m=1
M2 net0 net0 net2 VDD pch l=0.15 w=1 nf=1 m=1
M3 net0 nb VSS VSS nch l=0.15 w=1 nf=1 m=1
MBIAS VERR nb VSS VSS nch l=0.15 w=1 nf=1 m=1
MCHG net3 pb VIN VDD pch l=0.15 w=1 nf=1 m=1
MCTRL VERR net0 VOUT VDD pch l=0.15 w=1 nf=1 m=1
MGEN net1 net1 VSS VSS nch l=0.15 w=1 nf=1 m=1
MINJ VERR net1 VSS VSS nch l=0.15 w=1 nf=1 m=1
MRES VOUT VERR VIN VDD pch l=0.15 w=1 nf=1 m=1
MSEN net1 VEA net3 VDD pch l=0.15 w=1 nf=1 m=1
X1 VDD VSS VREF VEA VEA net0 AEA
.ends dut
