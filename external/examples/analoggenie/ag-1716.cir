* official Analog Canvas netlist; PDK X cards rewritten by convert.py
.model nch nmos
.model pch pmos
.model qpnp pnp

.subckt opamp VDD VSS INN INP OUT VB1
M1 net2 INN net6 VSS nch l=0.15 w=1 nf=1 m=1
M10 VB1 VB1 VDD VDD pch l=0.15 w=1 nf=1 m=1
M11 VB1 VB2 VSS VSS nch l=0.15 w=1 nf=1 m=1
M12 VB2 net0 VDD VDD pch l=0.15 w=1 nf=1 m=1
M13 VB2 VB2 VSS VSS nch l=0.15 w=1 nf=1 m=1
M14 net0 net0 VDD VDD pch l=0.15 w=1 nf=1 m=1
M15 net0 net4 VSS VSS nch l=0.15 w=1 nf=1 m=1
M16 net4 net4 VSS VSS nch l=0.15 w=1 nf=1 m=1
M17 net4 net1 VDD VDD pch l=0.15 w=1 nf=1 m=1
M18 net1 net4 VSS VSS nch l=0.15 w=1 nf=1 m=1
M2 net5 INP net6 VSS nch l=0.15 w=1 nf=1 m=1
M3 net2 net2 VDD VDD pch l=0.15 w=1 nf=1 m=1
M4 net5 net5 VDD VDD pch l=0.15 w=1 nf=1 m=1
M5 net3 net2 VDD VDD pch l=0.15 w=1 nf=1 m=1
M6 OUT net5 VDD VDD pch l=0.15 w=1 nf=1 m=1
M7 net3 net3 VSS VSS nch l=0.15 w=1 nf=1 m=1
M8 OUT net3 VSS VSS nch l=0.15 w=1 nf=1 m=1
M9 net6 VB2 VSS VSS nch l=0.15 w=1 nf=1 m=1
R4 VDD net4 1k
R5 VDD net1 1k
.ends opamp

.subckt dut VDD VSS Vout VB1
Q1 VSS VSS net4 qpnp m=1
Q2 net4 net4 net0 qpnp m=1
Q3 VSS VSS net3 qpnp m=1
Q4 net3 net3 net2 qpnp m=1
R1 Vout net0 1k
R2 Vout net1 1k
R3 net1 net2 1k
X1 VDD VSS net1 net0 Vout VB1 opamp
.ends dut
