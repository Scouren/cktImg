* official Analog Canvas netlist; PDK X cards rewritten by convert.py
.model nch nmos
.model pch pmos
.model qpnp pnp

.subckt opamp VDD VSS INN INP OUT VB1 VB2 VB3
M1 net2 INN net7 VSS nch l=0.15 w=1 nf=1 m=1
M10 net4 net3 VSS VSS nch l=0.15 w=1 nf=1 m=1
M11 net0 net3 VSS VSS nch l=0.15 w=1 nf=1 m=1
M12 net5 net5 VDD VDD pch l=0.15 w=1 nf=1 m=1
M13 VB4 net5 VDD VDD pch l=0.15 w=1 nf=1 m=1
M14 VB4 VB4 net6 VSS nch l=0.15 w=1 nf=1 m=1
M15 net6 VB4 VSS VSS nch l=0.15 w=1 nf=1 m=1
M2 net1 INP net7 VSS nch l=0.15 w=1 nf=1 m=1
M3 net7 VB2 VSS VSS nch l=0.15 w=1 nf=1 m=1
M4 net2 VB1 VDD VDD pch l=0.15 w=1 nf=1 m=1
M5 net1 VB1 VDD VDD pch l=0.15 w=1 nf=1 m=1
M6 net3 VB3 net2 VDD pch l=0.15 w=1 nf=1 m=1
M7 OUT VB3 net1 VDD pch l=0.15 w=1 nf=1 m=1
M8 net3 VB4 net4 VSS nch l=0.15 w=1 nf=1 m=1
M9 OUT VB4 net0 VSS nch l=0.15 w=1 nf=1 m=1
R4 net5 VSS 1k
.ends opamp

.subckt dut VDD VSS Vout VB1 VB2 VB3
Q1 VSS VSS X qpnp m=1
Q2 VSS VSS net0 qpnp m=1
R1 Vout X 1k
R2 Vout Y 1k
R3 Y net0 1k
X1 VDD VSS Y X Vout VB1 VB2 VB3 opamp
.ends dut
