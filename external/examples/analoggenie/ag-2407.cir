* official Analog Canvas netlist; PDK X cards rewritten by convert.py
.model nch nmos
.model pch pmos

.subckt opamp VDD VSS VREF VEAOUT VX1 VX2 VX3 VX4
M10 VX4 VX5 VDD VDD pch l=0.15 w=1 nf=1 m=1
M11 VX5 VB3 VX4 VDD pch l=0.15 w=1 nf=1 m=1
M12 VX5 VCAS VX3 VSS nch l=0.15 w=1 nf=1 m=1
M13 VX3 VB2 VSS VSS nch l=0.15 w=1 nf=1 m=1
M14 net1 VX5 VDD VDD pch l=0.15 w=1 nf=1 m=1
M15 VEAOUT VB3 net1 VDD pch l=0.15 w=1 nf=1 m=1
M16 VEAOUT VCAS VX2 VSS nch l=0.15 w=1 nf=1 m=1
M17 VX2 VB2 VSS VSS nch l=0.15 w=1 nf=1 m=1
M18 VX1 VB1 VDD VDD pch l=0.15 w=1 nf=1 m=1
M19 VX3 VREF VX1 VDD pch l=0.15 w=1 nf=1 m=1
M20 VX2 VEAOUT VX1 VDD pch l=0.15 w=1 nf=1 m=1
M21 VCAS VP VDD VDD pch l=0.15 w=1 nf=1 m=1
M22 VCAS VCAS VEAOUT VSS nch l=0.15 w=1 nf=1 m=1
M23 VEAOUT VCAS VSS VSS nch l=0.15 w=1 nf=1 m=1
M24 VP VP VDD VDD pch l=0.15 w=1 nf=1 m=1
M25 VB4 VP VDD VDD pch l=0.15 w=1 nf=1 m=1
M26 VP VB4 VSS VSS nch l=0.15 w=1 nf=1 m=1
M27 net0 VB4 VSS VSS nch l=0.15 w=1 nf=1 m=1
R1 VB4 net0 1k
.ends opamp

.subckt dut VDD VSS VOUT VERR pb nb VREF VIN
M0 net0 VEAOUT VIN VDD pch l=0.15 w=1 nf=1 m=1
M1 VX1 VX1 net0 VDD pch l=0.15 w=1 nf=1 m=1
M2 VX1 nb VSS VSS nch l=0.15 w=1 nf=1 m=1
M3 VX2 pb VIN VDD pch l=0.15 w=1 nf=1 m=1
M4 VX4 VEAOUT VX2 VDD pch l=0.15 w=1 nf=1 m=1
M5 VX4 VX4 VSS VSS nch l=0.15 w=1 nf=1 m=1
M6 VOUT VERR VIN VDD pch l=0.15 w=1 nf=1 m=1
M7 VERR VX1 VOUT VDD pch l=0.15 w=1 nf=1 m=1
M8 VERR nb VSS VSS nch l=0.15 w=1 nf=1 m=1
M9 VERR VX4 VSS VSS nch l=0.15 w=1 nf=1 m=1
X1 VDD VSS VREF VEAOUT VX1 VX2 net0 VX4 opamp
.ends dut
