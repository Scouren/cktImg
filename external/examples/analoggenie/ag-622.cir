* official Analog Canvas netlist; PDK X cards rewritten by convert.py
.model qnpn npn

.subckt dut VDD VSS IOUT1
Q1 IOUT1 net0 net4 VSS qnpn m=1
Q2 net0 net0 net1 VSS qnpn m=1
Q3 net1 net1 VSS VSS qnpn m=1
R1 net4 VSS 40kΩ
R2 VDD net0 40kΩ
.ends dut
