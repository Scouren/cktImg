* official Analog Canvas netlist; PDK X cards rewritten by convert.py
.model nch nmos
.model pch pmos

.subckt dut VDD VSS vin vout
IBIAS net2 VSS DC 1m
M1 net0 net0 VSS VSS nch l=0.15 w=1 nf=1 m=1
M2 net3 net0 VSS VSS nch l=0.15 w=1 nf=1 m=1
M3 VDD net3 vout VSS nch l=0.15 w=1 nf=1 m=1
M4 net2 net2 VDD VDD pch l=0.15 w=1 nf=1 m=1
M5 net0 net2 VDD VDD pch l=0.15 w=1 nf=1 m=1
M6 net3 net2 VDD VDD pch l=0.15 w=1 nf=1 m=1
M7 net1 net2 VDD VDD pch l=0.15 w=1 nf=1 m=1
M8 net1 net1 VSS VSS nch l=0.15 w=1 nf=1 m=1
M9 vout net1 VSS VSS nch l=0.15 w=1 nf=1 m=1
R1 vin net0 1k
R2 net0 net3 1k
.ends dut
