* official Analog Canvas netlist; PDK X cards rewritten by convert.py
.model nch nmos
.model pch pmos
.model qnpn npn

.subckt opamp VDD VSS INN INP OUT VZ VB2
M1 net1 INN net0 VSS nch l=0.15 w=1 nf=1 m=1
M2 net1 net1 VDD VDD pch l=0.15 w=1 nf=1 m=1
M3 net2 net2 VDD VDD pch l=0.15 w=1 nf=1 m=1
M4 net2 INP net0 VSS nch l=0.15 w=1 nf=1 m=1
M5 OUT net2 VDD VDD pch l=0.15 w=1 nf=1 m=1
M6 VZ net1 VDD VDD pch l=0.15 w=1 nf=1 m=1
M7 net0 VB2 VSS VSS nch l=0.15 w=1 nf=1 m=1
M8 VZ VZ VSS VSS nch l=0.15 w=1 nf=1 m=1
M9 OUT VZ VSS VSS nch l=0.15 w=1 nf=1 m=1
.ends opamp

.subckt dut VDD VSS Vout
M10 net2 net2 net0 VDD pch l=0.15 w=1 nf=1 m=1
M11 VB2 net2 VDD VDD pch l=0.15 w=1 nf=1 m=1
M12 VB2 VB2 VSS VSS nch l=0.15 w=1 nf=1 m=1
M13 VB1 VB2 VSS VSS nch l=0.15 w=1 nf=1 m=1
M14 VB1 VB1 VDD VDD pch l=0.15 w=1 nf=1 m=1
Q1 X X VSS VSS qnpn m=1
Q2 net1 net1 VSS VSS qnpn m=1
R1 Vout X 1k
R2 Vout Y 1k
R3 Y net1 1k
R4 VDD net0 1k
R5 net2 VSS 1k
X1 VDD VSS Y X Vout net1 VB2 opamp
.ends dut
