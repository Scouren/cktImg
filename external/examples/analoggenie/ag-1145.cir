* official Analog Canvas netlist; PDK X cards rewritten by convert.py
.model nch nmos
.model pch pmos

.subckt dut VDD VSS LO- LO+ Vtune Vb
C1 net2 Vtune 1p
C2 net0 Vtune 1p
C3 LO- net3 1p
C4 LO+ net1 1p
L net2 net0 1n
L1 net3 Vb 1n
L2 net1 Vb 1n
M1 net2 net0 VDD VDD pch l=0.15 w=1 nf=1 m=1
M2 net0 net2 VDD VDD pch l=0.15 w=1 nf=1 m=1
M3 net2 net0 VSS VSS nch l=0.15 w=1 nf=1 m=1
M4 net0 net2 VSS VSS nch l=0.15 w=1 nf=1 m=1
M5 VDD net2 net3 VSS nch l=0.15 w=1 nf=1 m=1
M6 VDD net0 net1 VSS nch l=0.15 w=1 nf=1 m=1
.ends dut
