* official Analog Canvas netlist; PDK X cards rewritten by convert.py
.model nch nmos
.model pch pmos

.subckt dut VDD VSS VSTO VCONT1 VCONT2 VCONT3 VOUT VB1 VB2 VB3
CL VOUT VSS 1p
CSTO VSTO VSS 1p
LRX VX1 VX2 1n
M10 VG VB4 net0 VSS nch l=0.15 w=1 nf=1 m=1
M11 net4 VC VSS VSS nch l=0.15 w=1 nf=1 m=1
M12 net0 VC VSS VSS nch l=0.15 w=1 nf=1 m=1
M13 net5 VX2 VX1 VSS nch l=0.15 w=1 nf=1 m=1
M14 net1 VG VX1 VSS nch l=0.15 w=1 nf=1 m=1
M15 VX1 VB5 VSS VSS nch l=0.15 w=1 nf=1 m=1
M16 VB4 VBP VDD VDD pch l=0.15 w=1 nf=1 m=1
M17 VB4 VB4 VB5 VSS nch l=0.15 w=1 nf=1 m=1
M18 VB5 VB5 VSS VSS nch l=0.15 w=1 nf=1 m=1
M19 net3 VBP VDD VDD pch l=0.15 w=1 nf=1 m=1
M20 net3 net3 VSS VSS nch l=0.15 w=1 nf=1 m=1
M21 VBP VBP VDD VDD pch l=0.15 w=1 nf=1 m=1
M22 VBP VB3 net2 VSS nch l=0.15 w=1 nf=1 m=1
M23 net2 net3 VSS VSS nch l=0.15 w=1 nf=1 m=1
M24 VB3 VBP VDD VDD pch l=0.15 w=1 nf=1 m=1
M25 VB3 VB3 VSS VSS nch l=0.15 w=1 nf=1 m=1
M5 net5 VB1 VDD VDD pch l=0.15 w=1 nf=1 m=1
M6 net1 VB1 VDD VDD pch l=0.15 w=1 nf=1 m=1
M7 VC VB2 net5 VDD pch l=0.15 w=1 nf=1 m=1
M8 VG VB2 net1 VDD pch l=0.15 w=1 nf=1 m=1
M9 VC VB4 net4 VSS nch l=0.15 w=1 nf=1 m=1
MN1 VX1 VCONT2 VSS VSS nch l=0.15 w=1 nf=1 m=1
MN2 VX2 VCONT3 VSS VSS nch l=0.15 w=1 nf=1 m=1
MP2 VX2 VG VOUT VDD pch l=0.15 w=1 nf=1 m=1
MP3 VX1 VCONT1 VSTO VDD pch l=0.15 w=1 nf=1 m=1
.ends dut
