* official Analog Canvas netlist; PDK X cards rewritten by convert.py
.model nch nmos

.subckt dut VSS Ic Vg2
M1 Vg2 Vg2 VSS VSS nch l=0.15 w=1 nf=1 m=1
M2 Ic Vg2 VSS VSS nch l=0.15 w=1 nf=1 m=1
.ends dut
