* official Analog Canvas netlist; PDK X cards rewritten by convert.py
.model nch nmos
.model pch pmos

.subckt dut VDD VSS VCONT1 VIN VCONT2 VCONT3 VCONT4 VCONT5 VP VB3
.model DIODE D(IS=1e-14 N=1)
CFLY VX1 VX2 1p
CO VP VN 1p
COP VP VSS 1p
D1 VN VX2 DIODE
L1 VX1 VX3 1n
M1 VX1 VCONT2 VIN VDD pch l=0.15 w=1 nf=1 m=1
M2 VX2 VCONT3 VIN VDD pch l=0.15 w=1 nf=1 m=1
M3 VX3 VCONT5 VP VDD pch l=0.15 w=1 nf=1 m=1
M4 VX3 VCONT4 VSS VSS nch l=0.15 w=1 nf=1 m=1
M5 VS5 VCONT1 VIN VDD pch l=0.15 w=1 nf=1 m=1
MN1 net4 net4 VSS VSS nch l=0.15 w=1 nf=1 m=1
MN10 VB5 net5 VX2 VSS nch l=0.15 w=1 nf=1 m=1
MN11 net5 net5 VSS VSS nch l=0.15 w=1 nf=1 m=1
MN12 VS5 VS5 VSS VSS nch l=0.15 w=1 nf=1 m=1
MN13 VX2 VS5 VSS VSS nch l=0.15 w=1 nf=1 m=1
MN2 VX2 VX2 VSS VSS nch l=0.15 w=1 nf=1 m=1
MN3 VCTRL net4 VSS VSS nch l=0.15 w=1 nf=1 m=1
MN4 net1 VX2 VSS VSS nch l=0.15 w=1 nf=1 m=1
MN5 net3 VB3 VSS VSS nch l=0.15 w=1 nf=1 m=1
MN6 VG net3 VSS VSS nch l=0.15 w=1 nf=1 m=1
MN7 net3 net3 VSS VSS nch l=0.15 w=1 nf=1 m=1
MN8 VB4 net2 VSS VSS nch l=0.15 w=1 nf=1 m=1
MN9 net2 net2 VSS VSS nch l=0.15 w=1 nf=1 m=1
MP1 net1 net1 VDD VDD pch l=0.15 w=1 nf=1 m=1
MP10 net2 VB5 VDD VDD pch l=0.15 w=1 nf=1 m=1
MP11 VB5 VB5 VDD VDD pch l=0.15 w=1 nf=1 m=1
MP12 net5 VB5 VDD VDD pch l=0.15 w=1 nf=1 m=1
MP13 VS5 VB5 VDD VDD pch l=0.15 w=1 nf=1 m=1
MP2 net0 VB4 VDD VDD pch l=0.15 w=1 nf=1 m=1
MP3 VCTRL net1 VDD VDD pch l=0.15 w=1 nf=1 m=1
MP4 VG VG VS5 VDD pch l=0.15 w=1 nf=1 m=1
MP5 VX1 VG VS5 VDD pch l=0.15 w=1 nf=1 m=1
MP6 net3 VCTRL VS5 VDD pch l=0.15 w=1 nf=1 m=1
MP7 VX2 VREF net0 VDD pch l=0.15 w=1 nf=1 m=1
MP8 net4 VFP1 net0 VDD pch l=0.15 w=1 nf=1 m=1
MP9 VB4 VB4 VDD VDD pch l=0.15 w=1 nf=1 m=1
R1 VP VFP1 1k
R2 VFP1 VSS 1k
.ends dut
