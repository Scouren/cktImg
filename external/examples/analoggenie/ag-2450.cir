* official Analog Canvas netlist; PDK X cards rewritten by convert.py
.model nch nmos
.model pch pmos

.subckt dut VDD VSS VIN pb nb VOUT VERR VREF VB1
M1 net3 net0 VIN VDD pch l=0.15 w=1 nf=1 m=1
M10 net5 VREF net7 VSS nch l=0.15 w=1 nf=1 m=1
M11 net2 net0 net7 VSS nch l=0.15 w=1 nf=1 m=1
M12 net7 VBN VSS VSS nch l=0.15 w=1 nf=1 m=1
M13 VCTRL net4 VDD VDD pch l=0.15 w=1 nf=1 m=1
M14 net4 net4 VDD VDD pch l=0.15 w=1 nf=1 m=1
M15 VBN net4 VDD VDD pch l=0.15 w=1 nf=1 m=1
M16 VB1 VB1 VDD VDD pch l=0.15 w=1 nf=1 m=1
M17 VCTRL VB2 VSS VSS nch l=0.15 w=1 nf=1 m=1
M18 net4 VCTRL VB2 VSS nch l=0.15 w=1 nf=1 m=1
M19 VBN VBN VSS VSS nch l=0.15 w=1 nf=1 m=1
M2 VCTRL VCTRL net3 VDD pch l=0.15 w=1 nf=1 m=1
M20 VB1 VBN VSS VSS nch l=0.15 w=1 nf=1 m=1
M3 VCTRL nb VSS VSS nch l=0.15 w=1 nf=1 m=1
M4 net5 net5 VDD VDD pch l=0.15 w=1 nf=1 m=1
M5 net0 net5 VDD VDD pch l=0.15 w=1 nf=1 m=1
M6 net0 net2 VDD VDD pch l=0.15 w=1 nf=1 m=1
M7 net2 net2 VDD VDD pch l=0.15 w=1 nf=1 m=1
M8 net0 net0 VSS VSS nch l=0.15 w=1 nf=1 m=1
M9 net0 net0 VSS VSS nch l=0.15 w=1 nf=1 m=1
MBIAS VERR nb VSS VSS nch l=0.15 w=1 nf=1 m=1
MCHG net1 pb VIN VDD pch l=0.15 w=1 nf=1 m=1
MCTRL VERR VCTRL VOUT VDD pch l=0.15 w=1 nf=1 m=1
MGEN net6 net6 VSS VSS nch l=0.15 w=1 nf=1 m=1
MINJ VERR net6 VSS VSS nch l=0.15 w=1 nf=1 m=1
MRES VOUT VERR VIN VDD pch l=0.15 w=1 nf=1 m=1
MSEN net6 net0 net1 VDD pch l=0.15 w=1 nf=1 m=1
R1 VB2 VSS 1k
.ends dut
