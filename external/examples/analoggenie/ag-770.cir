* official Analog Canvas netlist; PDK X cards rewritten by convert.py
.model nch nmos
.model pch pmos

.subckt dut VDD VSS vi+ Iout1 VC vi- Iout2
I1 VDD net2 DC 1m
I2 net0 VSS DC 1m
I3 VDD net3 DC 1m
I4 net1 VSS DC 1m
M1 net0 vi+ net2 VDD pch l=0.15 w=1 nf=1 m=1
M2 net1 vi- net3 VDD pch l=0.15 w=1 nf=1 m=1
M3 net2 net0 VSS VSS nch l=0.15 w=1 nf=1 m=1
M4 net3 net1 VSS VSS nch l=0.15 w=1 nf=1 m=1
M5 Iout1 net0 VSS VSS nch l=0.15 w=1 nf=1 m=1
M6 Iout2 net1 VSS VSS nch l=0.15 w=1 nf=1 m=1
M7 net3 VC net2 VDD pch l=0.15 w=1 nf=1 m=1
.ends dut
