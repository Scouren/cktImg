* official Analog Canvas netlist; PDK X cards rewritten by convert.py
.model nch nmos
.model pch pmos

.subckt dut VDD VSS Vreg
C1 net0 net5 0.1pF
Cext Vreg net1 10uF
I1 VDD net6 DC 20uA
M1 net6 net6 VSS VSS nch l=1 w=10 nf=1 m=1
M2 net3 net4 net7 VSS nch l=1 w=1 nf=1 m=1
M3 net7 net6 VSS VSS nch l=1 w=10 nf=1 m=1
M4 net5 net2 net7 VSS nch l=1 w=1 nf=1 m=1
M5 net3 net3 VDD VDD pch l=1 w=20 nf=1 m=1
M6 net5 net3 VDD VDD pch l=1 w=20 nf=1 m=1
M7 net0 net5 VDD VDD pch l=1 w=20 nf=1 m=1
M8 net0 net6 VSS VSS nch l=1 w=10 nf=1 m=1
M9 Vreg net0 VDD VDD pch l=0.5 w=20 nf=1 m=20
R1 Vreg net2 10kΩ
R2 net2 VSS 20kΩ
Rext net1 VSS 1Ω
Vref net4 VSS DC 1.2V
.ends dut
