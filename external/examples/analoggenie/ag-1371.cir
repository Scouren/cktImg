* official Analog Canvas netlist; PDK X cards rewritten by convert.py
.model nch nmos
.model pch pmos

.subckt comparator VDD VSS IN VB2 VB1 OUT
M1 net8 VX VDD VDD pch l=0.15 w=1 nf=1 m=1
M10 net0 VBN net6 VSS nch l=0.15 w=1 nf=1 m=1
M11 net6 net0 VSS VSS nch l=0.15 w=1 nf=1 m=1
M12 VX VBN net5 VSS nch l=0.15 w=1 nf=1 m=1
M13 net5 net0 VSS VSS nch l=0.15 w=1 nf=1 m=1
M14 net10 VX VDD VDD pch l=0.15 w=1 nf=1 m=1
M15 VX VB1 net10 VDD pch l=0.15 w=1 nf=1 m=1
M16 net7 VBP VDD VDD pch l=0.15 w=1 nf=1 m=1
M17 net7 net7 VSS VSS nch l=0.15 w=1 nf=1 m=1
M18 VBP VBP VDD VDD pch l=0.15 w=1 nf=1 m=1
M19 VBP VB4 net2 VSS nch l=0.15 w=1 nf=1 m=1
M2 OUT VB1 net8 VDD pch l=0.15 w=1 nf=1 m=1
M20 net2 net7 VSS VSS nch l=0.15 w=1 nf=1 m=1
M21 VB4 VBP VDD VDD pch l=0.15 w=1 nf=1 m=1
M22 VB4 net2 VSS VSS nch l=0.15 w=1 nf=1 m=1
M23 VBN VBP VDD VDD pch l=0.15 w=1 nf=1 m=1
M24 VBN VBN net1 VSS nch l=0.15 w=1 nf=1 m=1
M25 net1 VBN VSS VSS nch l=0.15 w=1 nf=1 m=1
M3 OUT VBN net4 VSS nch l=0.15 w=1 nf=1 m=1
M4 net4 net3 VSS VSS nch l=0.15 w=1 nf=1 m=1
M5 net9 VB2 VDD VDD pch l=0.15 w=1 nf=1 m=1
M6 net3 IN net9 VDD pch l=0.15 w=1 nf=1 m=1
M7 net0 OUT net9 VDD pch l=0.15 w=1 nf=1 m=1
M8 net3 VBN net11 VSS nch l=0.15 w=1 nf=1 m=1
M9 net11 net3 VSS VSS nch l=0.15 w=1 nf=1 m=1
.ends comparator

.subckt dut VDD VSS VSTO VCONT1 VCONT2 VCONT3 VOUT VB1 VB2
CL VOUT VSS 1p
CSTO VSTO VSS 1p
LRX net1 net2 1n
MN1 net1 VCONT2 VSS VSS nch l=0.15 w=1 nf=1 m=1
MN2 net2 VCONT3 VSS VSS nch l=0.15 w=1 nf=1 m=1
MP2 net2 net0 VOUT VDD pch l=0.15 w=1 nf=1 m=1
MP3 net1 VCONT1 VSTO VDD pch l=0.15 w=1 nf=1 m=1
X1 VDD VSS net2 VB2 VB1 net0 comparator
.ends dut
