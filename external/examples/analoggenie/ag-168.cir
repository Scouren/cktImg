* official Analog Canvas netlist; PDK X cards rewritten by convert.py
.model nch nmos

.subckt dut VDD VSS Vin Vout
I1 VDD net0 DC 1m
I2 VDD Vout DC 1m
M1 net0 net1 VSS VSS nch l=0.15 w=1 nf=1 m=1
M2 Vout net0 VSS VSS nch l=0.15 w=1 nf=1 m=1
RS Vin net1 1k
.ends dut
