* official Analog Canvas netlist; PDK X cards rewritten by convert.py
.model nch nmos
.model pch pmos

.subckt dut VDD VSS VB3 VB2 VB1 VREF VB4 VB6 VB5 VOUT VIN
CF1 VOUT VFB 1p
Cm1 VOUT VO1 1p
Cm2 net2 VO1 1p
M11 net6 VB1 VIN VDD pch l=0.15 w=1 nf=1 m=1
M12 net12 VFB net6 VDD pch l=0.15 w=1 nf=1 m=1
M13 net10 VREF net6 VDD pch l=0.15 w=1 nf=1 m=1
M14 net12 VB2 VSS VSS nch l=0.15 w=1 nf=1 m=1
M15 net10 VB2 VSS VSS nch l=0.15 w=1 nf=1 m=1
M16 VG VB4 VIN VDD pch l=0.15 w=1 nf=1 m=1
M17 VG VO1 VSS VSS nch l=0.15 w=1 nf=1 m=1
M18 VG VG VSS VSS nch l=0.15 w=1 nf=1 m=1
M19 net5 VBN net12 VSS nch l=0.15 w=1 nf=1 m=1
M20 VO1 VBN net10 VSS nch l=0.15 w=1 nf=1 m=1
M21 net0 VO1 VSS VSS nch l=0.15 w=1 nf=1 m=1
M22 net4 VG VSS VSS nch l=0.15 w=1 nf=1 m=1
M23 net0 net0 VIN VDD pch l=0.15 w=1 nf=1 m=1
M24 net4 net0 VIN VDD pch l=0.15 w=1 nf=1 m=1
M25 net5 VB3 VT VDD pch l=0.15 w=1 nf=1 m=1
M26 VO1 VB3 net1 VDD pch l=0.15 w=1 nf=1 m=1
M27 VT net5 VIN VDD pch l=0.15 w=1 nf=1 m=1
M28 net1 net5 VIN VDD pch l=0.15 w=1 nf=1 m=1
MB1 VBN net11 VIN VDD pch l=0.15 w=1 nf=1 m=1
MB2 VBN VBN net9 VSS nch l=0.15 w=1 nf=1 m=1
MB3 net9 VBN VSS VSS nch l=0.15 w=1 nf=1 m=1
MB4 net11 net11 net3 VDD pch l=0.15 w=1 nf=1 m=1
MD1 net2 VO1 VSS VSS nch l=0.15 w=1 nf=1 m=1
MD2 VT VB5 VSS VSS nch l=0.15 w=1 nf=1 m=1
MD3 net8 net2 VT VSS nch l=0.15 w=1 nf=1 m=1
MD4 net7 VB6 VT VSS nch l=0.15 w=1 nf=1 m=1
MD5 net2 net7 VIN VDD pch l=0.15 w=1 nf=1 m=1
MD6 net7 net7 VIN VDD pch l=0.15 w=1 nf=1 m=1
MD7 net8 net8 VIN VDD pch l=0.15 w=1 nf=1 m=1
MPT VOUT net4 VIN VDD pch l=0.15 w=1 nf=1 m=1
RB1 VIN net3 1k
RB2 net11 VSS 1k
RF1 VOUT VFB 1k
RF2 VFB VSS 1k
.ends dut
