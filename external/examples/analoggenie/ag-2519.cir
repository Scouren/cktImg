* official Analog Canvas netlist; PDK X cards rewritten by convert.py
.model nch nmos
.model pch pmos

.subckt bias VDD VSS VIN VBN
M29 VBN net1 VIN VDD pch l=0.15 w=1 nf=1 m=1
M30 VBN VBN VSS VSS nch l=0.15 w=1 nf=1 m=1
M31 net1 net1 VIN VDD pch l=0.15 w=1 nf=1 m=1
M32 net1 net3 VSS VSS nch l=0.15 w=1 nf=1 m=1
M33 net0 net0 VIN VDD pch l=0.15 w=1 nf=1 m=1
M34 net0 net2 net3 VSS nch l=0.15 w=1 nf=1 m=1
M35 net2 net0 VIN VDD pch l=0.15 w=1 nf=1 m=1
M36 net2 net3 VSS VSS nch l=0.15 w=1 nf=1 m=1
R1 net3 VSS 1k
.ends bias

.subckt dut VDD VSS VREF VB4 VB3 VB5 VOUT VIN
CF1 VOUT VFB 1p
Cm1 net0 VOUT 1p
Cm2 net0 net5 1p
M11 net4 VBN VSS VSS nch l=0.15 w=1 nf=1 m=1
M12 VX VFB net4 VSS nch l=0.15 w=1 nf=1 m=1
M13 VY VREF net4 VSS nch l=0.15 w=1 nf=1 m=1
M14 VX VX VIN VDD pch l=0.15 w=1 nf=1 m=1
M15 VY VY VIN VDD pch l=0.15 w=1 nf=1 m=1
M16 VY VB4 VIN VDD pch l=0.15 w=1 nf=1 m=1
M17 VY net0 VSS VSS nch l=0.15 w=1 nf=1 m=1
M18 VY VY VSS VSS nch l=0.15 w=1 nf=1 m=1
M21 net2 net0 VSS VSS nch l=0.15 w=1 nf=1 m=1
M22 net3 VY VSS VSS nch l=0.15 w=1 nf=1 m=1
M23 net2 net2 VIN VDD pch l=0.15 w=1 nf=1 m=1
M24 net3 net2 VIN VDD pch l=0.15 w=1 nf=1 m=1
M25 net0 VX VIN VDD pch l=0.15 w=1 nf=1 m=1
M26 net1 VY VIN VDD pch l=0.15 w=1 nf=1 m=1
M27 net0 net1 VSS VSS nch l=0.15 w=1 nf=1 m=1
M28 net1 net1 VSS VSS nch l=0.15 w=1 nf=1 m=1
MD1 net5 net0 VSS VSS nch l=0.15 w=1 nf=1 m=1
MD2 net7 VB5 VSS VSS nch l=0.15 w=1 nf=1 m=1
MD3 net6 net5 net7 VSS nch l=0.15 w=1 nf=1 m=1
MD4 VX VB3 net7 VSS nch l=0.15 w=1 nf=1 m=1
MD5 net5 VX VIN VDD pch l=0.15 w=1 nf=1 m=1
MD6 VX VX VIN VDD pch l=0.15 w=1 nf=1 m=1
MD7 net6 net6 VIN VDD pch l=0.15 w=1 nf=1 m=1
MPT VOUT net3 VIN VDD pch l=0.15 w=1 nf=1 m=1
RF1 VOUT VFB 1k
RF2 VFB VSS 1k
X1 VDD VSS VIN VBN bias
.ends dut
