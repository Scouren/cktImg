* official Analog Canvas netlist; PDK X cards rewritten by convert.py
.model nch nmos

.subckt dut VDD VSS Vout
CL Vout VSS 1p
Ibias1 VDD net0 DC 1m
Ibias2 VDD net1 DC 1m
Ibias3 VDD Vout DC 1m
Is VSS net2 DC 1m
M1 net0 net2 VSS VSS nch l=0.15 w=1 nf=1 m=1
M2 net1 net0 VSS VSS nch l=0.15 w=1 nf=1 m=1
M3 Vout net1 VSS VSS nch l=0.15 w=1 nf=1 m=1
Rf net2 Vout 1k
Rs net2 VSS 1k
.ends dut
