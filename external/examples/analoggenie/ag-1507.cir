* official Analog Canvas netlist; PDK X cards rewritten by convert.py
.model nch nmos
.model pch pmos
.model qnpn npn

.subckt opamp VDD VSS INP INN OUT VB1 VB3 VB5 VB2
M1 net2 VB1 VDD VDD pch l=0.15 w=1 nf=1 m=1
M10 net1 VB2 VSS VSS nch l=0.15 w=1 nf=1 m=1
M11 net4 VB2 VSS VSS nch l=0.15 w=1 nf=1 m=1
M2 net3 net0 VDD VDD pch l=0.15 w=1 nf=1 m=1
M3 net5 net0 VDD VDD pch l=0.15 w=1 nf=1 m=1
M4 net4 INP net2 VDD pch l=0.15 w=1 nf=1 m=1
M5 net1 INN net2 VDD pch l=0.15 w=1 nf=1 m=1
M6 OUT VB3 net3 VDD pch l=0.15 w=1 nf=1 m=1
M7 net0 VB3 net5 VDD pch l=0.15 w=1 nf=1 m=1
M8 OUT VB5 net1 VSS nch l=0.15 w=1 nf=1 m=1
M9 net0 VB5 net4 VSS nch l=0.15 w=1 nf=1 m=1
.ends opamp

.subckt dut VDD VSS Vout VB1 VB3 VB2 VB4
M12 VB5 net1 VDD VDD pch l=0.15 w=1 nf=1 m=1
M13 VB5 VB5 VZ VSS nch l=0.15 w=1 nf=1 m=1
M14 VZ VB5 VSS VSS nch l=0.15 w=1 nf=1 m=1
M15 net1 net1 VDD VDD pch l=0.15 w=1 nf=1 m=1
M16 net1 VB4 VSS VSS nch l=0.15 w=1 nf=1 m=1
M17 VB4 net1 VDD VDD pch l=0.15 w=1 nf=1 m=1
M18 net2 VB4 VSS VSS nch l=0.15 w=1 nf=1 m=1
Q1 X X VSS VSS qnpn m=1
Q2 VZ VZ VSS VSS qnpn m=1
R1 Vout X 1k
R2 Vout Y 1k
R3 Y VZ 1k
R4 VB4 net2 1k
X1 VDD VSS X Y Vout VB1 VB3 VB5 VB2 opamp
.ends dut
