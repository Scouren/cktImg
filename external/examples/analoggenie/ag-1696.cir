* official Analog Canvas netlist; PDK X cards rewritten by convert.py
.model nch nmos
.model pch pmos
.model qpnp pnp

.subckt opamp VDD VSS INN INP OUT
M10 VX VX VSS VSS nch l=0.15 w=1 nf=1 m=1
M11 OUT VX VSS VSS nch l=0.15 w=1 nf=1 m=1
M12 VB2 net1 VDD VDD pch l=0.15 w=1 nf=1 m=1
M13 net1 net1 VDD VDD pch l=0.15 w=1 nf=1 m=1
M14 VB1 net1 VDD VDD pch l=0.15 w=1 nf=1 m=1
M15 VB2 VB2 VSS VSS nch l=0.15 w=1 nf=1 m=1
M16 net1 VB1 VSS VSS nch l=0.15 w=1 nf=1 m=1
M17 net4 VB1 VSS VSS nch l=0.15 w=1 nf=1 m=1
M3 VX net0 VDD VDD pch l=0.15 w=1 nf=1 m=1
M4 net0 net0 VDD VDD pch l=0.15 w=1 nf=1 m=1
M5 net2 net2 VDD VDD pch l=0.15 w=1 nf=1 m=1
M6 OUT net2 VDD VDD pch l=0.15 w=1 nf=1 m=1
M7 net0 INN net3 VSS nch l=0.15 w=1 nf=1 m=1
M8 net2 INP net3 VSS nch l=0.15 w=1 nf=1 m=1
M9 net3 VB2 VSS VSS nch l=0.15 w=1 nf=1 m=1
R4 VB1 net4 1k
.ends opamp

.subckt dut VDD VSS Vout
Q1 VSS VSS net0 qpnp m=1
Q2 net0 net0 net2 qpnp m=1
Q3 VSS VSS net1 qpnp m=1
Q4 net1 net1 Y qpnp m=1
R1 Vout X 1k
R2 Vout Y 1k
R3 X net2 1k
X1 VDD VSS X Y Vout opamp
.ends dut
