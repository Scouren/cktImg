* official Analog Canvas netlist; PDK X cards rewritten by convert.py
.model nch nmos
.model pch pmos
.model qpnp pnp

.subckt opamp VDD VSS INN INP OUT
M1 net0 net0 VDD VDD pch l=0.15 w=1 nf=1 m=1
M10 VB3 VB4 VDD VDD pch l=0.15 w=1 nf=1 m=1
M11 VB4 VB4 VDD VDD pch l=0.15 w=1 nf=1 m=1
M12 VB2 VB4 VDD VDD pch l=0.15 w=1 nf=1 m=1
M13 net3 VB4 VDD VDD pch l=0.15 w=1 nf=1 m=1
M14 VB3 VB3 VSS VSS nch l=0.15 w=1 nf=1 m=1
M15 VB4 VB2 VB1 VSS nch l=0.15 w=1 nf=1 m=1
M16 VB1 net3 VSS VSS nch l=0.15 w=1 nf=1 m=1
M17 VB2 VB1 VSS VSS nch l=0.15 w=1 nf=1 m=1
M18 net3 net3 VSS VSS nch l=0.15 w=1 nf=1 m=1
M2 net2 net2 VDD VDD pch l=0.15 w=1 nf=1 m=1
M3 net2 INN net4 VSS nch l=0.15 w=1 nf=1 m=1
M4 net0 INP net4 VSS nch l=0.15 w=1 nf=1 m=1
M5 OUT net0 VDD VDD pch l=0.15 w=1 nf=1 m=1
M6 net1 net2 VDD VDD pch l=0.15 w=1 nf=1 m=1
M7 net4 VB3 VSS VSS nch l=0.15 w=1 nf=1 m=1
M8 net1 net1 VSS VSS nch l=0.15 w=1 nf=1 m=1
M9 OUT net1 VSS VSS nch l=0.15 w=1 nf=1 m=1
.ends opamp

.subckt dut VDD VSS Vout
Q1 VSS VSS X qpnp m=1
Q2 VSS VSS net0 qpnp m=1
R1 Vout X 1k
R2 Vout Y 1k
R3 Y net0 1k
X1 VDD VSS Y X Vout opamp
.ends dut
