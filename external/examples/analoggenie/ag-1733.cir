* official Analog Canvas netlist; PDK X cards rewritten by convert.py
.model nch nmos
.model pch pmos
.model qpnp pnp

.subckt opamp VDD VSS INN INP Z OUT
M10 Z VB1 net4 VDD pch l=0.15 w=1 nf=1 m=1
M11 Z INN net7 VSS nch l=0.15 w=1 nf=1 m=1
M12 net8 net2 VDD VDD pch l=0.15 w=1 nf=1 m=1
M13 net2 VB1 net8 VDD pch l=0.15 w=1 nf=1 m=1
M14 net2 INP net7 VSS nch l=0.15 w=1 nf=1 m=1
M15 net5 net2 VDD VDD pch l=0.15 w=1 nf=1 m=1
M16 OUT VB1 net5 VDD pch l=0.15 w=1 nf=1 m=1
M17 OUT VB3 net9 VSS nch l=0.15 w=1 nf=1 m=1
M18 net9 INP VSS VSS nch l=0.15 w=1 nf=1 m=1
M19 net7 VB2 VSS VSS nch l=0.15 w=1 nf=1 m=1
M20 net0 net0 VDD VDD pch l=0.15 w=1 nf=1 m=1
M21 VB3 net0 VDD VDD pch l=0.15 w=1 nf=1 m=1
M22 VB3 VB3 net1 VSS nch l=0.15 w=1 nf=1 m=1
M23 net1 VB3 VSS VSS nch l=0.15 w=1 nf=1 m=1
M5 net6 Z VDD VDD pch l=0.15 w=1 nf=1 m=1
M6 INP VB1 net6 VDD pch l=0.15 w=1 nf=1 m=1
M7 INP VB3 net3 VSS nch l=0.15 w=1 nf=1 m=1
M8 net3 INP VSS VSS nch l=0.15 w=1 nf=1 m=1
M9 net4 Z VDD VDD pch l=0.15 w=1 nf=1 m=1
R1 net0 VSS 1k
.ends opamp

.subckt dut VDD VSS Vout
M1 X net1 VDD VDD pch l=0.15 w=1 nf=1 m=1
M2 Vout net1 VDD VDD pch l=0.15 w=1 nf=1 m=1
M3 net2 net1 VDD VDD pch l=0.15 w=1 nf=1 m=1
M4 Z net1 VDD VDD pch l=0.15 w=1 nf=1 m=1
Q1 VSS VSS net2 qpnp m=1
Q2 VSS net2 X qpnp m=1
Q3 VSS VSS Z qpnp m=1
Q4 VSS Z net0 qpnp m=1
R1 Y net0 1k
R2 Vout Y 1k
X1 VDD VSS X Y Z net1 opamp
.ends dut
