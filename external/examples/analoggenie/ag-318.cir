* official Analog Canvas netlist; PDK X cards rewritten by convert.py
.model nch nmos
.model pch pmos

.subckt dut VDD VSS Vb1 Vb2 Vb3 Vin1 Vin2 Vout1 Vout2
I1 net5 VSS DC 1m
M1 net3 Vin1 net4 VSS nch l=0.15 w=1 nf=1 m=1
M10 net4 Y VSS VSS nch l=0.15 w=1 nf=1 m=1
M11 Vout1 X VDD VDD pch l=0.15 w=1 nf=1 m=1
M12 Vout2 Y VDD VDD pch l=0.15 w=1 nf=1 m=1
M13 Vout1 net5 VSS VSS nch l=0.15 w=1 nf=1 m=1
M14 Vout2 net5 VSS VSS nch l=0.15 w=1 nf=1 m=1
M2 net0 Vin2 net4 VSS nch l=0.15 w=1 nf=1 m=1
M3 X Vb3 net3 VSS nch l=0.15 w=1 nf=1 m=1
M4 Y Vb3 net0 VSS nch l=0.15 w=1 nf=1 m=1
M5 X Vb2 net1 VDD pch l=0.15 w=1 nf=1 m=1
M6 Y Vb2 net2 VDD pch l=0.15 w=1 nf=1 m=1
M7 net1 Vb1 VDD VDD pch l=0.15 w=1 nf=1 m=1
M8 net2 Vb1 VDD VDD pch l=0.15 w=1 nf=1 m=1
M9 net4 X VSS VSS nch l=0.15 w=1 nf=1 m=1
R1 Vout1 net5 1k
R2 net5 Vout2 1k
.ends dut
