* official Analog Canvas netlist; PDK X cards rewritten by convert.py
.model nch nmos
.model pch pmos
.model qnpn npn

.subckt opamp VDD VSS INN INP OUT VC
M1 VC net3 VDD VDD pch l=0.15 w=1 nf=1 m=1
M10 net8 VB2 VDD VDD pch l=0.15 w=1 nf=1 m=1
M11 net2 VB2 VDD VDD pch l=0.15 w=1 nf=1 m=1
M12 net8 net8 net4 VSS nch l=0.15 w=1 nf=1 m=1
M13 net4 net8 VB4 VSS nch l=0.15 w=1 nf=1 m=1
M14 VB4 VB4 VSS VSS nch l=0.15 w=1 nf=1 m=1
M15 net2 net2 net1 VSS nch l=0.15 w=1 nf=1 m=1
M16 net1 net2 net4 VSS nch l=0.15 w=1 nf=1 m=1
M17 VB2 VB2 VDD VDD pch l=0.15 w=1 nf=1 m=1
M18 VB4 VB2 VDD VDD pch l=0.15 w=1 nf=1 m=1
M19 VB2 net1 VSS VSS nch l=0.15 w=1 nf=1 m=1
M2 net3 net3 VDD VDD pch l=0.15 w=1 nf=1 m=1
M20 net5 net5 VDD VDD pch l=0.15 w=1 nf=1 m=1
M21 VB3 net5 VDD VDD pch l=0.15 w=1 nf=1 m=1
M22 net5 VB4 VSS VSS nch l=0.15 w=1 nf=1 m=1
M23 VB3 VB3 VSS VSS nch l=0.15 w=1 nf=1 m=1
M24 net6 VB3 VSS VSS nch l=0.15 w=1 nf=1 m=1
M25 net6 net6 VDD VDD pch l=0.15 w=1 nf=1 m=1
M3 net0 net0 VDD VDD pch l=0.15 w=1 nf=1 m=1
M4 OUT net0 VDD VDD pch l=0.15 w=1 nf=1 m=1
M5 VC VC VSS VSS nch l=0.15 w=1 nf=1 m=1
M6 net3 INN net7 VSS nch l=0.15 w=1 nf=1 m=1
M7 net0 INP net7 VSS nch l=0.15 w=1 nf=1 m=1
M8 OUT VC VSS VSS nch l=0.15 w=1 nf=1 m=1
M9 net7 VB3 VSS VSS nch l=0.15 w=1 nf=1 m=1
.ends opamp

.subckt dut VDD VSS Vout
Q1 X X VSS VSS qnpn m=1
Q2 net0 net0 VSS VSS qnpn m=1
R1 Vout X 1k
R2 Vout Y 1k
R3 Y net0 1k
X1 VDD VSS Y X Vout net0 opamp
.ends dut
