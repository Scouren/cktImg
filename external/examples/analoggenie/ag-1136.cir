* official Analog Canvas netlist; PDK X cards rewritten by convert.py
.model nch nmos
.model pch pmos

.subckt dut VDD VSS Vbias_n
C1 V1 V2 1p
C2 V1 net0 1p
C3 V2 net1 1p
Ctail net2 VSS 1p
Ibias net2 VSS DC 1m
L1 V1 V2 1n
M1 V1 V2 VDD VDD pch l=0.15 w=1 nf=1 m=1
M2 V2 V1 VDD VDD pch l=0.15 w=1 nf=1 m=1
M3 V1 net1 net2 VSS nch l=0.15 w=1 nf=1 m=1
M4 V2 net0 net2 VSS nch l=0.15 w=1 nf=1 m=1
R1 net1 Vbias_n 1k
R2 net0 Vbias_n 1k
.ends dut
