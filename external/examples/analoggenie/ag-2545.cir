* official Analog Canvas netlist; PDK X cards rewritten by convert.py
.model nch nmos
.model pch pmos

.subckt AMP1 VDD VSS VB1 INN INP VB2 OUT n3 VB3
M0 n3 INN net5 VSS nch l=0.15 w=1 nf=1 m=1
M1 net4 net0 VDD VDD pch l=0.15 w=1 nf=1 m=1
M10 VX VB1 net3 VDD pch l=0.15 w=1 nf=1 m=1
M11 net0 VB1 net4 VDD pch l=0.15 w=1 nf=1 m=1
M12 n3 VB1 net6 VDD pch l=0.15 w=1 nf=1 m=1
M13 OUT VBN net7 VSS nch l=0.15 w=1 nf=1 m=1
M14 VX VBN net9 VSS nch l=0.15 w=1 nf=1 m=1
M15 n3 net8 VDD VDD pch l=0.15 w=1 nf=1 m=1
M16 net8 net8 VDD VDD pch l=0.15 w=1 nf=1 m=1
M17 net8 n3 VB3 VSS nch l=0.15 w=1 nf=1 m=1
M18 n3 VB3 VSS VSS nch l=0.15 w=1 nf=1 m=1
M19 VBN net8 VDD VDD pch l=0.15 w=1 nf=1 m=1
M2 net6 n3 VDD VDD pch l=0.15 w=1 nf=1 m=1
M20 VBN VBN net1 VSS nch l=0.15 w=1 nf=1 m=1
M21 net1 VBN VSS VSS nch l=0.15 w=1 nf=1 m=1
M3 net0 INP net5 VSS nch l=0.15 w=1 nf=1 m=1
M4 net5 VB2 VSS VSS nch l=0.15 w=1 nf=1 m=1
M5 net2 net0 VDD VDD pch l=0.15 w=1 nf=1 m=1
M6 net3 n3 VDD VDD pch l=0.15 w=1 nf=1 m=1
M7 net7 VX VSS VSS nch l=0.15 w=1 nf=1 m=1
M8 net9 VX VSS VSS nch l=0.15 w=1 nf=1 m=1
M9 OUT VB1 net2 VDD pch l=0.15 w=1 nf=1 m=1
R1 VB3 VSS 1k
.ends AMP1

.subckt dut VDD VSS Vref Vout biasp biascas biasn VB1 VB2 VB3
C1 Vset VSS 1p
C2 n3 Vout 1p
M1 Vout n3 VDD VDD pch l=0.15 w=1 nf=1 m=1
M2 n1 Vset Vout VDD pch l=0.15 w=1 nf=1 m=1
M3 n1 biasn VSS VSS nch l=0.15 w=1 nf=1 m=1
M4 n3 biasp VDD VDD pch l=0.15 w=1 nf=1 m=1
M5 n3 biascas n1 VSS nch l=0.15 w=1 nf=1 m=1
R1 fb VSS 1k
R2 Vout fb 1k
X1 VDD VSS VB1 fb Vref VB2 Vset n3 VB3 AMP1
.ends dut
