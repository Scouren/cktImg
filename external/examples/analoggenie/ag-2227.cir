* official Analog Canvas netlist; PDK X cards rewritten by convert.py
.model nch nmos
.model pch pmos

.subckt opamp VDD VSS INP INN OUT
M1 net2 INP net1 VDD pch l=0.15 w=1 nf=1 m=1
M10 net4 net3 VDD VDD pch l=0.15 w=1 nf=1 m=1
M11 net7 net3 VDD VDD pch l=0.15 w=1 nf=1 m=1
M12 VBN net0 VDD VDD pch l=0.15 w=1 nf=1 m=1
M13 VBN VBN net9 VSS nch l=0.15 w=1 nf=1 m=1
M14 net9 VBN VSS VSS nch l=0.15 w=1 nf=1 m=1
M15 net0 net0 VDD VDD pch l=0.15 w=1 nf=1 m=1
M16 net8 net0 VDD VDD pch l=0.15 w=1 nf=1 m=1
M17 net0 net8 VSS VSS nch l=0.15 w=1 nf=1 m=1
M18 net6 net8 VSS VSS nch l=0.15 w=1 nf=1 m=1
M2 net5 INN net1 VDD pch l=0.15 w=1 nf=1 m=1
M3 net1 VB1 VDD VDD pch l=0.15 w=1 nf=1 m=1
M4 net2 VB2 VSS VSS nch l=0.15 w=1 nf=1 m=1
M5 net5 VB2 VSS VSS nch l=0.15 w=1 nf=1 m=1
M6 net3 VBN net2 VSS nch l=0.15 w=1 nf=1 m=1
M7 OUT VBN net5 VSS nch l=0.15 w=1 nf=1 m=1
M8 net3 VB3 net4 VDD pch l=0.15 w=1 nf=1 m=1
M9 OUT VB3 net7 VDD pch l=0.15 w=1 nf=1 m=1
R1 net8 net6 1k
.ends opamp

.subckt dut VDD VSS Vref VIN VOUT
CL VOUT net0 1p
MNP VIN net1 VOUT VSS nch l=0.15 w=1 nf=1 m=1
R1 VOUT FB 1k
R2 FB VSS 1k
R3 net0 VSS 1k
X1 VDD VSS Vref FB net1 opamp
.ends dut
