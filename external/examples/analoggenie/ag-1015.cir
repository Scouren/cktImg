* official Analog Canvas netlist; PDK X cards rewritten by convert.py
.model nch nmos
.model pch pmos

.subckt dut VDD VSS vi2 vi1 VBIAS VX
M1 VX vi2 net4 VSS nch l=0.15 w=1 nf=1 m=1
M18 net2 VX VDD VDD pch l=0.15 w=1 nf=1 m=1
M19 net1 net5 VDD VDD pch l=0.15 w=1 nf=1 m=1
M2 net5 vi1 net4 VSS nch l=0.15 w=1 nf=1 m=1
M20 net0 VX VDD VDD pch l=0.15 w=1 nf=1 m=1
M21 net3 net5 VDD VDD pch l=0.15 w=1 nf=1 m=1
M22 net0 net0 VSS VSS nch l=0.15 w=1 nf=1 m=1
M23 net3 net3 VSS VSS nch l=0.15 w=1 nf=1 m=1
M24 net1 net0 VSS VSS nch l=0.15 w=1 nf=1 m=1
M25 net2 net3 VSS VSS nch l=0.15 w=1 nf=1 m=1
M26 net1 net1 VSS VSS nch l=0.15 w=1 nf=1 m=1
M27 net2 net2 VSS VSS nch l=0.15 w=1 nf=1 m=1
M28 net4 net1 VSS VSS nch l=0.15 w=1 nf=1 m=1
M29 net4 net2 VSS VSS nch l=0.15 w=1 nf=1 m=1
M3 VX VX VDD VDD pch l=0.15 w=1 nf=1 m=1
M4 net5 net5 VDD VDD pch l=0.15 w=1 nf=1 m=1
M5 net4 VBIAS VSS VSS nch l=0.15 w=1 nf=1 m=1
.ends dut
