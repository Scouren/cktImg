* official Analog Canvas netlist; PDK X cards rewritten by convert.py
.model nch nmos
.model pch pmos

* Ideal nand-gate: switches at V(VDD,VSS)/2; vt sets the step width, td the delay
.subckt nand_gate VDD VSS A B Y params: vt=10m td=10p
BhA hA 0 V={0.5*(1+tanh((V(A,VSS)-0.5*V(VDD,VSS))/vt))}
BhB hB 0 V={0.5*(1+tanh((V(B,VSS)-0.5*V(VDD,VSS))/vt))}
Bf nfn VSS V={V(VDD,VSS)*(1-V(hA)*V(hB))}
Rd nfn ndl 1k
Cd ndl VSS {td/1000}
BY Y VSS V={V(ndl,VSS)}
.ends nand_gate

.subckt dut VDD VSS VOUT OUT RESETN
M1 net3 net8 VDD VDD pch l=0.15 w=1 nf=1 m=1
M10 A net6 VDD VDD pch l=0.15 w=1 nf=1 m=1
M11 A VOUT net0 VSS nch l=0.15 w=1 nf=1 m=1
M12 net0 net6 VSS VSS nch l=0.15 w=1 nf=1 m=1
M13 net5 A VDD VDD pch l=0.15 w=1 nf=1 m=1
M14 B A net5 VDD pch l=0.15 w=1 nf=1 m=1
M15 B A net2 VSS nch l=0.15 w=1 nf=1 m=1
M16 net2 A VSS VSS nch l=0.15 w=1 nf=1 m=1
M17 C B VDD VDD pch l=0.15 w=1 nf=1 m=1
M18 C B VSS VSS nch l=0.15 w=1 nf=1 m=1
M19 net4 C VDD VDD pch l=0.15 w=1 nf=1 m=1
M2 net3 VOUT net9 VSS nch l=0.15 w=1 nf=1 m=1
M20 net4 C VSS VSS nch l=0.15 w=1 nf=1 m=1
M21 OUT net4 VDD VDD pch l=0.15 w=1 nf=1 m=1
M22 OUT net4 VSS VSS nch l=0.15 w=1 nf=1 m=1
M3 net9 net8 VSS VSS nch l=0.15 w=1 nf=1 m=1
M4 net7 net3 VDD VDD pch l=0.15 w=1 nf=1 m=1
M5 net7 VOUT net10 VSS nch l=0.15 w=1 nf=1 m=1
M6 net10 net3 VSS VSS nch l=0.15 w=1 nf=1 m=1
M7 net6 net7 VDD VDD pch l=0.15 w=1 nf=1 m=1
M8 net6 VOUT net1 VSS nch l=0.15 w=1 nf=1 m=1
M9 net1 net7 VSS VSS nch l=0.15 w=1 nf=1 m=1
X1 VDD VSS RESETN OUT net8 nand_gate td=10p vt=10m
.ends dut
