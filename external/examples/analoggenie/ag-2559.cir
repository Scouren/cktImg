* official Analog Canvas netlist; PDK X cards rewritten by convert.py
.model nch nmos
.model pch pmos

.subckt dut VDD VSS VB1 VB2 Vref biasp biascas biasn Vout
C1 net2 VSS 1p
C2 n3 Vout 1p
M1 Vout n3 VDD VDD pch l=0.15 w=1 nf=1 m=1
M10 VY net4 VDD VDD pch l=0.15 w=1 nf=1 m=1
M11 VY VY VX VSS nch l=0.15 w=1 nf=1 m=1
M12 VX VX VSS VSS nch l=0.15 w=1 nf=1 m=1
M13 net5 VB1 VDD VDD pch l=0.15 w=1 nf=1 m=1
M14 net0 VB1 VDD VDD pch l=0.15 w=1 nf=1 m=1
M15 n3 VB2 net5 VDD pch l=0.15 w=1 nf=1 m=1
M16 net2 VB2 net0 VDD pch l=0.15 w=1 nf=1 m=1
M17 net5 fb net3 VSS nch l=0.15 w=1 nf=1 m=1
M18 net0 Vref net3 VSS nch l=0.15 w=1 nf=1 m=1
M19 net3 VX VSS VSS nch l=0.15 w=1 nf=1 m=1
M2 n1 net2 Vout VDD pch l=0.15 w=1 nf=1 m=1
M20 n3 VY net1 VSS nch l=0.15 w=1 nf=1 m=1
M21 net2 VY n1 VSS nch l=0.15 w=1 nf=1 m=1
M22 net1 n3 VSS VSS nch l=0.15 w=1 nf=1 m=1
M23 n1 n3 VSS VSS nch l=0.15 w=1 nf=1 m=1
M3 n1 biasn VSS VSS nch l=0.15 w=1 nf=1 m=1
M4 n3 biasp VDD VDD pch l=0.15 w=1 nf=1 m=1
M5 n3 biascas n1 VSS nch l=0.15 w=1 nf=1 m=1
M6 VB3 net4 VDD VDD pch l=0.15 w=1 nf=1 m=1
M7 VB3 VB3 VSS VSS nch l=0.15 w=1 nf=1 m=1
M8 net4 net4 VDD VDD pch l=0.15 w=1 nf=1 m=1
M9 net4 VB3 VSS VSS nch l=0.15 w=1 nf=1 m=1
R1 fb VSS 1k
R2 Vout fb 1k
.ends dut
