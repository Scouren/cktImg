* official Analog Canvas netlist; PDK X cards rewritten by convert.py
.model nch nmos
.model pch pmos

.subckt EA VDD VSS VREF VFB VO VX2
MN1 net2 net2 VSS VSS nch l=0.15 w=1 nf=1 m=1
MN2 VX2 VX2 VSS VSS nch l=0.15 w=1 nf=1 m=1
MN3 VO net2 VSS VSS nch l=0.15 w=1 nf=1 m=1
MN4 net1 VX2 VSS VSS nch l=0.15 w=1 nf=1 m=1
MN5 VB2 net0 VSS VSS nch l=0.15 w=1 nf=1 m=1
MN6 net0 net0 net3 VSS nch l=0.15 w=1 nf=1 m=1
MP1 net2 VFB net4 VDD pch l=0.15 w=1 nf=1 m=1
MP2 VX2 VREF net4 VDD pch l=0.15 w=1 nf=1 m=1
MP3 net4 VB2 VDD VDD pch l=0.15 w=1 nf=1 m=1
MP4 net1 net1 VDD VDD pch l=0.15 w=1 nf=1 m=1
MP5 VO net1 VDD VDD pch l=0.15 w=1 nf=1 m=1
MP6 VB2 VB2 VDD VDD pch l=0.15 w=1 nf=1 m=1
RBIAS VDD net0 1k
RS net3 VSS 1k
.ends EA

.subckt ISR VDD VSS VS IOUT VCTRL VB1
MN6 net1 net0 VSS VSS nch l=0.15 w=1 nf=1 m=1
MN7 net0 net0 VSS VSS nch l=0.15 w=1 nf=1 m=1
MN8 net0 VB1 VSS VSS nch l=0.15 w=1 nf=1 m=1
MP4 net1 net1 VS VDD pch l=0.15 w=1 nf=1 m=1
MP5 IOUT net1 VS VDD pch l=0.15 w=1 nf=1 m=1
MP6 net0 VCTRL VS VDD pch l=0.15 w=1 nf=1 m=1
.ends ISR

.subckt dut VDD VSS VIN VS5 VB1 VS1 VS2 VS4 VS3 VP VREF
.model DIODE D(IS=1e-14 N=1)
CFLY VX1 VX2 1p
CO VP VN 1p
COP VP VSS 1p
D1 VN VX2 DIODE
L1 VX1 VX3 1n
M1 VX1 VS1 VIN VDD pch l=0.15 w=1 nf=1 m=1
M2 VX2 VS2 VIN VDD pch l=0.15 w=1 nf=1 m=1
M3 VP VS3 VX3 VDD pch l=0.15 w=1 nf=1 m=1
M4 VX3 VS4 VSS VSS nch l=0.15 w=1 nf=1 m=1
M5 net1 VS5 VIN VDD pch l=0.15 w=1 nf=1 m=1
R1 VP VFP1 1k
R2 VFP1 VSS 1k
X1 VDD VSS net1 VX1 net0 VB1 ISR
X2 VDD VSS VREF VFP1 net0 VX2 EA
.ends dut
