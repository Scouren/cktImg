* official Analog Canvas netlist; PDK X cards rewritten by convert.py
.model nch nmos
.model pch pmos

.subckt AMP1 VDD VSS INN INP VB2 VB1 OUT
M10 net9 net0 VDD VDD pch l=0.15 w=1 nf=1 m=1
M11 net0 VB1 net4 VDD pch l=0.15 w=1 nf=1 m=1
M12 OUT VB1 net9 VDD pch l=0.15 w=1 nf=1 m=1
M13 VX VC net5 VSS nch l=0.15 w=1 nf=1 m=1
M14 net1 VC net7 VSS nch l=0.15 w=1 nf=1 m=1
M15 net0 VC net10 VSS nch l=0.15 w=1 nf=1 m=1
M16 OUT VC net6 VSS nch l=0.15 w=1 nf=1 m=1
M17 net5 VX VSS VSS nch l=0.15 w=1 nf=1 m=1
M18 net7 net1 VSS VSS nch l=0.15 w=1 nf=1 m=1
M19 net10 net1 VSS VSS nch l=0.15 w=1 nf=1 m=1
M20 net6 VX VSS VSS nch l=0.15 w=1 nf=1 m=1
M21 net3 net3 VDD VDD pch l=0.15 w=1 nf=1 m=1
M22 VC net3 VDD VDD pch l=0.15 w=1 nf=1 m=1
M23 VC VC net2 VSS nch l=0.15 w=1 nf=1 m=1
M24 net2 VC VSS VSS nch l=0.15 w=1 nf=1 m=1
M6 net8 VB2 VDD VDD pch l=0.15 w=1 nf=1 m=1
M7 VX INN net8 VDD pch l=0.15 w=1 nf=1 m=1
M8 net1 INP net8 VDD pch l=0.15 w=1 nf=1 m=1
M9 net4 net0 VDD VDD pch l=0.15 w=1 nf=1 m=1
R3 net3 VSS 1k
.ends AMP1

.subckt dut VDD VSS Vref Vout biasp biascas biasn VB1 VB2
C1 Vset VSS 1p
C2 n3 Vout 1p
M1 Vout n3 VDD VDD pch l=0.15 w=1 nf=1 m=1
M2 n1 Vset Vout VDD pch l=0.15 w=1 nf=1 m=1
M3 n1 biasn VSS VSS nch l=0.15 w=1 nf=1 m=1
M4 n3 biasp VDD VDD pch l=0.15 w=1 nf=1 m=1
M5 n3 biascas n1 VSS nch l=0.15 w=1 nf=1 m=1
R1 fb VSS 1k
R2 Vout fb 1k
X1 VDD VSS fb Vref VB2 VB1 Vset AMP1
.ends dut
