* official Analog Canvas netlist; PDK X cards rewritten by convert.py
.model nch nmos
.model pch pmos
.model qnpn npn

.subckt dut VDD VSS Vout VB1
M1 net3 X net6 VSS nch l=0.15 w=1 nf=1 m=1
M10 VB2 VB2 VSS VSS nch l=0.15 w=1 nf=1 m=1
M11 VB2 VB3 VDD VDD pch l=0.15 w=1 nf=1 m=1
M12 VB3 VB3 VDD VDD pch l=0.15 w=1 nf=1 m=1
M13 VB3 net1 VSS VSS nch l=0.15 w=1 nf=1 m=1
M14 net2 VB3 VDD VDD pch l=0.15 w=1 nf=1 m=1
M15 net2 net2 net1 VSS nch l=0.15 w=1 nf=1 m=1
M16 net1 net2 net4 VSS nch l=0.15 w=1 nf=1 m=1
M17 net5 VB3 VDD VDD pch l=0.15 w=1 nf=1 m=1
M18 net5 net5 net4 VSS nch l=0.15 w=1 nf=1 m=1
M19 net4 net5 VB1 VSS nch l=0.15 w=1 nf=1 m=1
M2 net0 Y net6 VSS nch l=0.15 w=1 nf=1 m=1
M20 VB1 VB1 VSS VSS nch l=0.15 w=1 nf=1 m=1
M21 VB1 VB3 VDD VDD pch l=0.15 w=1 nf=1 m=1
M3 net3 net3 VDD VDD pch l=0.15 w=1 nf=1 m=1
M4 net0 net0 VDD VDD pch l=0.15 w=1 nf=1 m=1
M5 net6 VB2 VSS VSS nch l=0.15 w=1 nf=1 m=1
M6 Vout net3 VDD VDD pch l=0.15 w=1 nf=1 m=1
M7 Z net0 VDD VDD pch l=0.15 w=1 nf=1 m=1
M8 Vout Z VSS VSS nch l=0.15 w=1 nf=1 m=1
M9 Z Z VSS VSS nch l=0.15 w=1 nf=1 m=1
Q1 X X VSS VSS qnpn m=1
Q2 Z Z VSS VSS qnpn m=1
R1 Vout X 1k
R2 Vout Y 1k
R3 Y Z 1k
.ends dut
