* official Analog Canvas netlist; PDK X cards rewritten by convert.py
.model nch nmos
.model pch pmos

.subckt dut VDD VSS VB3 VB6 VB2 VB4 VIN VB1 VOUT
CF1 VOUT VFB 1p
Cm1 VOUT V1 1p
Cm2 V1 net6 1p
M11 net10 VB5 VSS VSS nch l=0.15 w=1 nf=1 m=1
M12 net5 VFB net10 VSS nch l=0.15 w=1 nf=1 m=1
M13 VX VREF net10 VSS nch l=0.15 w=1 nf=1 m=1
M14 net12 net2 VSS VSS nch l=0.15 w=1 nf=1 m=1
M15 net1 net2 VSS VSS nch l=0.15 w=1 nf=1 m=1
M16 VA VB1 VIN VDD pch l=0.15 w=1 nf=1 m=1
M17 VA V1 VSS VSS nch l=0.15 w=1 nf=1 m=1
M18 VA VA VSS VSS nch l=0.15 w=1 nf=1 m=1
M21 net0 V1 VSS VSS nch l=0.15 w=1 nf=1 m=1
M22 net8 VA VSS VSS nch l=0.15 w=1 nf=1 m=1
M23 net0 net0 VIN VDD pch l=0.15 w=1 nf=1 m=1
M24 net8 net0 VIN VDD pch l=0.15 w=1 nf=1 m=1
M25 VX VB3 VIN VDD pch l=0.15 w=1 nf=1 m=1
M26 net2 VB6 VX VDD pch l=0.15 w=1 nf=1 m=1
M27 net2 VBN net1 VSS nch l=0.15 w=1 nf=1 m=1
M28 net5 VB3 VIN VDD pch l=0.15 w=1 nf=1 m=1
M29 V1 VB6 net5 VDD pch l=0.15 w=1 nf=1 m=1
M30 V1 VBN net12 VSS nch l=0.15 w=1 nf=1 m=1
M31 VBN net7 VIN VDD pch l=0.15 w=1 nf=1 m=1
M32 VBN VBN net9 VSS nch l=0.15 w=1 nf=1 m=1
M33 net9 VBN VSS VSS nch l=0.15 w=1 nf=1 m=1
M34 net7 net7 VIN VDD pch l=0.15 w=1 nf=1 m=1
M35 net7 net3 VSS VSS nch l=0.15 w=1 nf=1 m=1
M36 net3 net7 VIN VDD pch l=0.15 w=1 nf=1 m=1
M37 net3 net3 VSS VSS nch l=0.15 w=1 nf=1 m=1
MD1 net6 V1 VSS VSS nch l=0.15 w=1 nf=1 m=1
MD2 net11 VB2 VSS VSS nch l=0.15 w=1 nf=1 m=1
MD3 VX net6 net11 VSS nch l=0.15 w=1 nf=1 m=1
MD4 net4 VB4 net11 VSS nch l=0.15 w=1 nf=1 m=1
MD5 net6 net4 VIN VDD pch l=0.15 w=1 nf=1 m=1
MD6 net4 net4 VIN VDD pch l=0.15 w=1 nf=1 m=1
MD7 VX VX VIN VDD pch l=0.15 w=1 nf=1 m=1
MPT VOUT net8 VIN VDD pch l=0.15 w=1 nf=1 m=1
RF1 VOUT VFB 1k
RF2 VFB VSS 1k
.ends dut
