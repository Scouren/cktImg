* official Analog Canvas netlist; PDK X cards rewritten by convert.py
.model nch nmos
.model pch pmos

.subckt dut VDD VSS VB1 VREF VIN nb pb VOUT VERR
M1 VX1 VEAOUT VIN VDD pch l=0.15 w=1 nf=1 m=1
M10 VX1 VB6 VSS VSS nch l=0.15 w=1 nf=1 m=1
M11 net2 net1 VDD VDD pch l=0.15 w=1 nf=1 m=1
M12 VEAOUT VB2 net2 VDD pch l=0.15 w=1 nf=1 m=1
M13 VEAOUT VB5 VX3 VSS nch l=0.15 w=1 nf=1 m=1
M14 VX3 VB6 VSS VSS nch l=0.15 w=1 nf=1 m=1
M15 net0 net0 VDD VDD pch l=0.15 w=1 nf=1 m=1
M16 VB5 net0 VDD VDD pch l=0.15 w=1 nf=1 m=1
M17 VB5 VB5 VB6 VSS nch l=0.15 w=1 nf=1 m=1
M18 VB6 VB6 VSS VSS nch l=0.15 w=1 nf=1 m=1
M2 VX2 VX2 VX1 VDD pch l=0.15 w=1 nf=1 m=1
M3 VX2 nb VSS VSS nch l=0.15 w=1 nf=1 m=1
M4 VX2 VB1 VDD VDD pch l=0.15 w=1 nf=1 m=1
M5 VX1 VREF VX2 VDD pch l=0.15 w=1 nf=1 m=1
M6 VX3 VEAOUT VX2 VDD pch l=0.15 w=1 nf=1 m=1
M7 VX4 net1 VDD VDD pch l=0.15 w=1 nf=1 m=1
M8 net1 VB2 VX4 VDD pch l=0.15 w=1 nf=1 m=1
M9 net1 VB5 VX1 VSS nch l=0.15 w=1 nf=1 m=1
MBIAS VERR nb VSS VSS nch l=0.15 w=1 nf=1 m=1
MCHG VX3 pb VIN VDD pch l=0.15 w=1 nf=1 m=1
MCTRL VERR VX2 VOUT VDD pch l=0.15 w=1 nf=1 m=1
MGEN VX4 VX4 VSS VSS nch l=0.15 w=1 nf=1 m=1
MINJ VERR VX4 VSS VSS nch l=0.15 w=1 nf=1 m=1
MRES VOUT VERR VIN VDD pch l=0.15 w=1 nf=1 m=1
MSEN VX4 VEAOUT VX3 VDD pch l=0.15 w=1 nf=1 m=1
R1 net0 VSS 1k
.ends dut
