* official Analog Canvas netlist; PDK X cards rewritten by convert.py
.model nch nmos
.model pch pmos

.subckt bias VDD VSS VB1 VB5 VX2 VB2 VB3
MN10 net0 net0 VSS VSS nch l=0.15 w=1 nf=1 m=1
MN11 VX2 VX2 VSS VSS nch l=0.15 w=1 nf=1 m=1
MN12 VB6 VB3 VB2 VSS nch l=0.15 w=1 nf=1 m=1
MN13 VB2 VX2 VSS VSS nch l=0.15 w=1 nf=1 m=1
MN14 VB3 VB2 VSS VSS nch l=0.15 w=1 nf=1 m=1
MN8 VB1 VB1 VSS VSS nch l=0.15 w=1 nf=1 m=1
MN9 VB5 net0 VSS VSS nch l=0.15 w=1 nf=1 m=1
MP10 VB5 VB5 VDD VDD pch l=0.15 w=1 nf=1 m=1
MP11 net0 VB6 VDD VDD pch l=0.15 w=1 nf=1 m=1
MP12 VX2 VB6 VDD VDD pch l=0.15 w=1 nf=1 m=1
MP13 VB6 VB6 VDD VDD pch l=0.15 w=1 nf=1 m=1
MP14 VB3 VB6 VDD VDD pch l=0.15 w=1 nf=1 m=1
MP9 VB1 VB5 VDD VDD pch l=0.15 w=1 nf=1 m=1
.ends bias

.subckt dut VDD VSS VIN VCONT1 VB4 VREF VCONT2 VCONT3 VCONT4 VCONT5 VP VB1 VB2 VB3
.model DIODE D(IS=1e-14 N=1)
CFLY VX1 VX2 1p
CO VP VN 1p
COP VP VSS 1p
D1 VN VX2 DIODE
L1 VX1 VX3 1n
M1 VX1 VCONT2 VIN VDD pch l=0.15 w=1 nf=1 m=1
M2 VX2 VCONT3 VIN VDD pch l=0.15 w=1 nf=1 m=1
M3 VX3 VCONT5 VP VDD pch l=0.15 w=1 nf=1 m=1
M4 VX3 VCONT4 VSS VSS nch l=0.15 w=1 nf=1 m=1
M5 net3 VCONT1 VIN VDD pch l=0.15 w=1 nf=1 m=1
MN1 net2 net2 VSS VSS nch l=0.15 w=1 nf=1 m=1
MN2 VX2 VX2 VSS VSS nch l=0.15 w=1 nf=1 m=1
MN3 net0 net2 VSS VSS nch l=0.15 w=1 nf=1 m=1
MN4 VA VX2 VSS VSS nch l=0.15 w=1 nf=1 m=1
MN5 net4 VB4 VSS VSS nch l=0.15 w=1 nf=1 m=1
MN6 net5 net4 VSS VSS nch l=0.15 w=1 nf=1 m=1
MN7 net4 net4 VSS VSS nch l=0.15 w=1 nf=1 m=1
MP1 VA VA VDD VDD pch l=0.15 w=1 nf=1 m=1
MP2 net0 VA VDD VDD pch l=0.15 w=1 nf=1 m=1
MP3 net4 net0 net3 VDD pch l=0.15 w=1 nf=1 m=1
MP4 net5 net5 net3 VDD pch l=0.15 w=1 nf=1 m=1
MP5 VX1 net5 net3 VDD pch l=0.15 w=1 nf=1 m=1
MP6 net2 VFP1 net1 VDD pch l=0.15 w=1 nf=1 m=1
MP7 VX2 VREF net1 VDD pch l=0.15 w=1 nf=1 m=1
MP8 net1 VB5 VDD VDD pch l=0.15 w=1 nf=1 m=1
R1 VP VFP1 1k
R2 VFP1 VSS 1k
X1 VDD VSS VB1 VB5 VX2 VB2 VB3 bias
.ends dut
