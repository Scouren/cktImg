* official Analog Canvas netlist; PDK X cards rewritten by convert.py
.model nch nmos
.model pch pmos

.subckt dut VDD VSS VSTO VCONT1 VCONT2 VCONT3 VOUT
CL VOUT VSS 1p
CSTO VSTO VSS 1p
LRX VX VY 1n
M10 net7 net4 VSS VSS nch l=0.15 w=1 nf=1 m=1
M11 net5 VY VX VSS nch l=0.15 w=1 nf=1 m=1
M12 VX VB2 VSS VSS nch l=0.15 w=1 nf=1 m=1
M13 net2 VG VX VSS nch l=0.15 w=1 nf=1 m=1
M14 VB4 net6 VDD VDD pch l=0.15 w=1 nf=1 m=1
M15 net0 VB4 VSS VSS nch l=0.15 w=1 nf=1 m=1
M16 net6 net6 VDD VDD pch l=0.15 w=1 nf=1 m=1
M17 net6 VB4 VSS VSS nch l=0.15 w=1 nf=1 m=1
M18 VC net6 VDD VDD pch l=0.15 w=1 nf=1 m=1
M19 VC VC net3 VSS nch l=0.15 w=1 nf=1 m=1
M20 net3 VC VSS VSS nch l=0.15 w=1 nf=1 m=1
M3 net5 VB1 VDD VDD pch l=0.15 w=1 nf=1 m=1
M4 net2 VB1 VDD VDD pch l=0.15 w=1 nf=1 m=1
M5 net4 VB3 net5 VDD pch l=0.15 w=1 nf=1 m=1
M6 VG VB3 net2 VDD pch l=0.15 w=1 nf=1 m=1
M7 net4 VC net1 VSS nch l=0.15 w=1 nf=1 m=1
M8 VG VC net7 VSS nch l=0.15 w=1 nf=1 m=1
M9 net1 net4 VSS VSS nch l=0.15 w=1 nf=1 m=1
MN1 VX VCONT2 VSS VSS nch l=0.15 w=1 nf=1 m=1
MN2 VY VCONT3 VSS VSS nch l=0.15 w=1 nf=1 m=1
MP2 VY VG VOUT VDD pch l=0.15 w=1 nf=1 m=1
MP3 VX VCONT1 VSTO VDD pch l=0.15 w=1 nf=1 m=1
R1 VB4 net0 1k
.ends dut
