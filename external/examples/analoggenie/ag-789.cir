* official Analog Canvas netlist; PDK X cards rewritten by convert.py
.model nch nmos
.model pch pmos

.subckt opamp VDD VSS INP INN OUT
M10 net3 net1 VSS VSS nch l=0.15 w=1 nf=1 m=1
M11 net0 INP IB VSS nch l=0.15 w=1 nf=1 m=1
M12 net2 INN IB VSS nch l=0.15 w=1 nf=1 m=1
M3 net0 VB3 VDD VDD pch l=0.15 w=1 nf=1 m=1
M4 net2 VB3 VDD VDD pch l=0.15 w=1 nf=1 m=1
M5 net1 VB1 net0 VDD pch l=0.15 w=1 nf=1 m=1
M6 OUT VB1 net2 VDD pch l=0.15 w=1 nf=1 m=1
M7 net1 VB2 net4 VSS nch l=0.15 w=1 nf=1 m=1
M8 OUT VB2 net3 VSS nch l=0.15 w=1 nf=1 m=1
M9 net4 net1 VSS VSS nch l=0.15 w=1 nf=1 m=1
.ends opamp

.subckt dut VDD VSS vci phi1 phi2 vco
C1 vcx VSS 1p
C2 net0 vco 1p
M1 vci phi1 vcx VSS nch l=0.15 w=1 nf=1 m=1
M2 vcx phi2 net0 VSS nch l=0.15 w=1 nf=1 m=1
X1 VDD VSS VSS net0 vco opamp
.ends dut
