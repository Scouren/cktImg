* official Analog Canvas netlist; PDK X cards rewritten by convert.py
.model nch nmos
.model pch pmos

.subckt opamp VDD VSS INN INP OUT
C3 net5 OUT 1p
M10 net0 net6 VDD VDD pch l=0.15 w=1 nf=1 m=1
M11 net6 net6 net0 VDD pch l=0.15 w=1 nf=1 m=1
M12 net0 net0 VSS VSS nch l=0.15 w=1 nf=1 m=1
M13 net4 net0 VSS VSS nch l=0.15 w=1 nf=1 m=1
M14 net4 net4 VDD VDD pch l=0.15 w=1 nf=1 m=1
M15 net3 net4 VDD VDD pch l=0.15 w=1 nf=1 m=1
M16 net3 net3 VSS VSS nch l=0.15 w=1 nf=1 m=1
M3 net1 INN net2 VSS nch l=0.15 w=1 nf=1 m=1
M4 net5 INP net2 VSS nch l=0.15 w=1 nf=1 m=1
M5 net1 net1 VDD VDD pch l=0.15 w=1 nf=1 m=1
M6 net5 net1 VDD VDD pch l=0.15 w=1 nf=1 m=1
M7 net2 net3 VSS VSS nch l=0.15 w=1 nf=1 m=1
M8 OUT net5 VDD VDD pch l=0.15 w=1 nf=1 m=1
M9 OUT net3 VSS VSS nch l=0.15 w=1 nf=1 m=1
R1 VDD net0 1k
R2 net6 VSS 1k
.ends opamp

.subckt dut VDD VSS vci phi1 phi2 vco
C1 net0 VSS 1p
C2 net1 vco 1p
M1 vci phi1 net0 VSS nch l=0.15 w=1 nf=1 m=1
M2 net0 phi2 net1 VSS nch l=0.15 w=1 nf=1 m=1
X1 VDD VSS net1 VSS vco opamp
.ends dut
