* official Analog Canvas netlist; PDK X cards rewritten by convert.py
.model nch nmos

.subckt dut VDD VSS Vout1 Vout2
C1 Vout1 VSS 1p
C2 Vout2 VSS 1p
L1 VDD Vout1 1n
L2 VDD Vout2 1n
M1 Vout1 Vout2 VSS VSS nch l=0.15 w=1 nf=1 m=1
M2 Vout2 Vout1 VSS VSS nch l=0.15 w=1 nf=1 m=1
.ends dut
