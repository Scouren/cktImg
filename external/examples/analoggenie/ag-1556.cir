* official Analog Canvas netlist; PDK X cards rewritten by convert.py
.model nch nmos
.model pch pmos
.model qpnp pnp

.global VDD

.subckt opamp VSS INN INP OUT VB1 VB2
M1 net5 net1 VDD VDD pch l=0.15 w=1 nf=1 m=1
M10 net8 INP net7 VSS nch l=0.15 w=1 nf=1 m=1
M11 net11 net8 VDD VDD pch l=0.15 w=1 nf=1 m=1
M12 OUT VB1 net11 VDD pch l=0.15 w=1 nf=1 m=1
M13 OUT VB4 net10 VSS nch l=0.15 w=1 nf=1 m=1
M14 net10 VN VSS VSS nch l=0.15 w=1 nf=1 m=1
M15 net7 VB2 VSS VSS nch l=0.15 w=1 nf=1 m=1
M16 VB3 net2 VDD VDD pch l=0.15 w=1 nf=1 m=1
M17 VB3 VB3 VSS VSS nch l=0.15 w=1 nf=1 m=1
M18 net2 net2 VDD VDD pch l=0.15 w=1 nf=1 m=1
M19 net2 VB3 net4 VSS nch l=0.15 w=1 nf=1 m=1
M2 VN VB1 net5 VDD pch l=0.15 w=1 nf=1 m=1
M20 VB4 net2 VDD VDD pch l=0.15 w=1 nf=1 m=1
M21 VB4 VB4 net6 VSS nch l=0.15 w=1 nf=1 m=1
M22 net6 VB4 VSS VSS nch l=0.15 w=1 nf=1 m=1
M3 VN VB4 net9 VSS nch l=0.15 w=1 nf=1 m=1
M4 net9 VN VSS VSS nch l=0.15 w=1 nf=1 m=1
M5 net0 net1 VDD VDD pch l=0.15 w=1 nf=1 m=1
M6 net1 VB1 net0 VDD pch l=0.15 w=1 nf=1 m=1
M7 net1 INN net7 VSS nch l=0.15 w=1 nf=1 m=1
M8 net3 net8 VDD VDD pch l=0.15 w=1 nf=1 m=1
M9 net8 VB1 net3 VDD pch l=0.15 w=1 nf=1 m=1
R4 net4 VSS 1k
.ends opamp

.subckt dut VSS Vout VB1 VB2
Q1 VSS VSS net0 qpnp m=1
Q2 VSS VSS net1 qpnp m=1
R1 Vout net0 1k
R2 Vout net2 1k
R3 net2 net1 1k
X1 VSS net2 net0 Vout VB1 VB2 opamp
.ends dut
