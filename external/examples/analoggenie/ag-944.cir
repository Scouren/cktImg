* official Analog Canvas netlist; PDK X cards rewritten by convert.py
.model nch nmos
.model pch pmos
.model qnpn npn

.subckt dut VDD VSS Iout
IPTAT VDD net1 DC 1m
M2 net0 net1 VSS VSS nch l=0.15 w=1 nf=1 m=1
M3 net0 net0 VDD VDD pch l=0.15 w=1 nf=1 m=1
M4 net2 net0 VDD VDD pch l=0.15 w=1 nf=1 m=1
M5 Iout net0 VDD VDD pch l=0.15 w=1 nf=1 m=1
Q1 net1 net2 VSS VSS qnpn m=1
R net2 VSS 1k
.ends dut
