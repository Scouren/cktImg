* official Analog Canvas netlist; PDK X cards rewritten by convert.py
.model nch nmos
.model pch pmos

.subckt dut VDD VSS VOUTN VINP VOUTP VINN VCONT
GSS net0 VSS VCONT VSS 1m
M1 VOUTN VINP net0 VSS nch l=0.15 w=1 nf=1 m=1
M2 VOUTP VINN net0 VSS nch l=0.15 w=1 nf=1 m=1
M3 VOUTN VOUTN VDD VDD pch l=0.15 w=1 nf=1 m=1
M4 VOUTP VOUTP VDD VDD pch l=0.15 w=1 nf=1 m=1
M5 VOUTN VINP VDD VDD pch l=0.15 w=1 nf=1 m=1
M6 VOUTP VINN VDD VDD pch l=0.15 w=1 nf=1 m=1
.ends dut
