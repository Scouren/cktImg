* official Analog Canvas netlist; PDK X cards rewritten by convert.py
.model nch nmos

.subckt dut VDD VSS Outp Outn Vtune
C1 net1 Outp 1p
C2 net3 Outn 1p
Cbp net0 VSS 1p
Cf net2 VSS 1p
CV1 Vtune net4 1p
CV2 Vtune net6 1p
Iref VDD net5 DC 1m
L1 VDD net4 0.7nH
L2 VDD net6 0.7nH
L3 VDD net1 1n
L4 VDD net3 1n
M1 net4 net6 net0 VSS nch l=0.15 w=1 nf=1 m=1
M2 net6 net4 net0 VSS nch l=0.15 w=1 nf=1 m=1
M3 net0 net2 VSS VSS nch l=0.15 w=1 nf=1 m=1
M4 net5 net5 VSS VSS nch l=0.15 w=1 nf=1 m=1
M5 net1 net4 VSS VSS nch l=0.15 w=1 nf=1 m=1
M6 net3 net6 VSS VSS nch l=0.15 w=1 nf=1 m=1
R1 net5 net2 140kΩ
.ends dut
