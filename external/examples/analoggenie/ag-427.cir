* official Analog Canvas netlist; PDK X cards rewritten by convert.py
.model nch nmos

.subckt dut VDD VSS Vb
C1 net1 VSS 1p
C2 net0 net1 1p
I1 net1 VSS DC 1m
L1 VDD net0 1n
M1 net0 Vb net1 VSS nch l=0.15 w=1 nf=1 m=1
.ends dut
