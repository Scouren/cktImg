* official Analog Canvas netlist; PDK X cards rewritten by convert.py
.model nch nmos
.model pch pmos
.model qpnp pnp

.subckt opamp VDD VSS VB1 VB2 INP INN OUT
M1 net3 VX VDD VDD pch l=0.15 w=1 nf=1 m=1
M10 net1 VB3 net11 VSS nch l=0.15 w=1 nf=1 m=1
M11 net11 net1 VSS VSS nch l=0.15 w=1 nf=1 m=1
M12 net4 VX VDD VDD pch l=0.15 w=1 nf=1 m=1
M13 OUT VB1 net4 VDD pch l=0.15 w=1 nf=1 m=1
M14 OUT VB3 net8 VSS nch l=0.15 w=1 nf=1 m=1
M15 net8 net1 VSS VSS nch l=0.15 w=1 nf=1 m=1
M16 net2 net2 net7 VDD pch l=0.15 w=1 nf=1 m=1
M17 VB3 net2 VDD VDD pch l=0.15 w=1 nf=1 m=1
M18 VB3 VB3 net6 VSS nch l=0.15 w=1 nf=1 m=1
M19 net6 VB3 VSS VSS nch l=0.15 w=1 nf=1 m=1
M2 VX VB1 net3 VDD pch l=0.15 w=1 nf=1 m=1
M3 VX VB3 net5 VSS nch l=0.15 w=1 nf=1 m=1
M4 net5 net0 VSS VSS nch l=0.15 w=1 nf=1 m=1
M5 net10 VB2 VDD VDD pch l=0.15 w=1 nf=1 m=1
M6 net0 INP net10 VDD pch l=0.15 w=1 nf=1 m=1
M7 net0 VB3 net9 VSS nch l=0.15 w=1 nf=1 m=1
M8 net9 net0 VSS VSS nch l=0.15 w=1 nf=1 m=1
M9 net1 INN net10 VDD pch l=0.15 w=1 nf=1 m=1
R1 VDD net7 1k
R2 net2 VSS 1k
.ends opamp

.subckt dut VDD VSS Vout VB1 VB2
Q1 VSS VSS X qpnp m=1
Q2 VSS VSS net0 qpnp m=1
R1 Vout X 1k
R2 Vout Y 1k
R3 Y net0 1k
X1 VDD VSS VB1 VB2 X Y Vout opamp
.ends dut
