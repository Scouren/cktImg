* official Analog Canvas netlist; PDK X cards rewritten by convert.py
.model nch nmos
.model pch pmos

.subckt EA VDD VSS VFP1 VREF VX2 OUT
MN1 VX VX VSS VSS nch l=0.15 w=1 nf=1 m=1
MN2 VX2 VX2 VSS VSS nch l=0.15 w=1 nf=1 m=1
MN3 net1 VX2 VSS VSS nch l=0.15 w=1 nf=1 m=1
MN4 OUT VX VSS VSS nch l=0.15 w=1 nf=1 m=1
MN5 net3 net2 VSS VSS nch l=0.15 w=1 nf=1 m=1
MN6 net2 net2 VSS VSS nch l=0.15 w=1 nf=1 m=1
MN7 net4 net2 VSS VSS nch l=0.15 w=1 nf=1 m=1
MP1 VX VFP1 net0 VDD pch l=0.15 w=1 nf=1 m=1
MP2 VX2 VREF net0 VDD pch l=0.15 w=1 nf=1 m=1
MP3 net0 net3 VDD VDD pch l=0.15 w=1 nf=1 m=1
MP4 net1 net1 VDD VDD pch l=0.15 w=1 nf=1 m=1
MP5 OUT net1 VDD VDD pch l=0.15 w=1 nf=1 m=1
MP6 net3 net3 VDD VDD pch l=0.15 w=1 nf=1 m=1
MP7 net2 net4 VDD VDD pch l=0.15 w=1 nf=1 m=1
R3 VDD net4 1k
RBIAS VDD net2 1k
.ends EA

.subckt ISR VDD VSS IN VB1 VS VX1
MN1 net1 net1 VSS VSS nch l=0.15 w=1 nf=1 m=1
MN2 net0 net1 VSS VSS nch l=0.15 w=1 nf=1 m=1
MN3 net1 VB1 VSS VSS nch l=0.15 w=1 nf=1 m=1
MP1 net1 IN VS VDD pch l=0.15 w=1 nf=1 m=1
MP2 net0 net0 VS VDD pch l=0.15 w=1 nf=1 m=1
MP3 VX1 net0 VS VDD pch l=0.15 w=1 nf=1 m=1
.ends ISR

.subckt dut VDD VSS VCONT2 VCONT4 VCONT5 VREF VP VCONT3 VIN VCONT1 VB1
.model DIODE D(IS=1e-14 N=1)
CFLY VX1 VX2 1p
CO VP VN 1p
COP VP VSS 1p
D1 VN VX2 DIODE
L1 VX1 VX3 1n
M1 VX1 VCONT2 VIN VDD pch l=0.15 w=1 nf=1 m=1
M2 VX2 VCONT3 VIN VDD pch l=0.15 w=1 nf=1 m=1
M3 VP VCONT5 VX3 VDD pch l=0.15 w=1 nf=1 m=1
M4 VX3 VCONT4 VSS VSS nch l=0.15 w=1 nf=1 m=1
M5 net1 VCONT1 VIN VDD pch l=0.15 w=1 nf=1 m=1
R1 VP VFP1 1k
R2 VFP1 VSS 1k
X1 VDD VSS VFP1 VREF VX2 net0 EA
X2 VDD VSS net0 VB1 net1 VX1 ISR
.ends dut
