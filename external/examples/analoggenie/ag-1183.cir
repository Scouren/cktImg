* official Analog Canvas netlist; PDK X cards rewritten by convert.py
.model nch nmos

.subckt dut VDD VSS VBias VC S1 S2
.model ideal_switch SW(RON=1 ROFF=1e12 VT=0.5 VH=0)
C1 VC net1 1p
C2 VC net2 1p
CAC net5 net0 1p
I1 VDD net3 DC 1m
L1 VDD net1 1n
L2 VDD net2 1n
M1 net0 net3 VSS VSS nch l=0.15 w=1 nf=1 m=1
M2 VDD net4 net3 VSS nch l=0.15 w=1 nf=1 m=1
M3 net3 net3 VSS VSS nch l=0.15 w=1 nf=1 m=1
M4 net1 net2 net0 VSS nch l=0.15 w=1 nf=1 m=1
M5 net2 net1 net0 VSS nch l=0.15 w=1 nf=1 m=1
R1 VDD net0 1k
RAC VBias net4 1k
S1 net4 VSS S1 VSS ideal_switch
S2 net4 net5 S2 VSS ideal_switch
.ends dut
