* official Analog Canvas netlist; PDK X cards rewritten by convert.py
.model nch nmos
.model pch pmos

.subckt opamp VDD VSS VIP VIN VOUT params: gain=1e6 vhigh=5 vlow=-5
Blin nlin 0 V={gain*(V(VIP)-V(VIN))}
Bcore VOUT 0 V={0.5*(vhigh+(0.5*(vlow+V(nlin)+sqrt((V(nlin)-vlow)*(V(nlin)-vlow)+(1e-4*(vhigh-vlow))*(1e-4*(vhigh-vlow))+1e-12)))-sqrt((vhigh-(0.5*(vlow+V(nlin)+sqrt((V(nlin)-vlow)*(V(nlin)-vlow)+(1e-4*(vhigh-vlow))*(1e-4*(vhigh-vlow))+1e-12))))*(vhigh-(0.5*(vlow+V(nlin)+sqrt((V(nlin)-vlow)*(V(nlin)-vlow)+(1e-4*(vhigh-vlow))*(1e-4*(vhigh-vlow))+1e-12))))+(1e-4*(vhigh-vlow))*(1e-4*(vhigh-vlow))+1e-12))}
.ends opamp

.subckt dut VDD VSS GND BIAS V1 Vi Vo
M1 VDD net2 Vo VSS nch l=0.15 w=1 nf=1 m=1
M11 Vo net0 VDD VDD pch l=0.15 w=1 nf=1 m=1
M12 Vo net1 VSS VSS nch l=0.15 w=1 nf=1 m=1
M2 VSS net3 Vo VDD pch l=0.15 w=1 nf=1 m=1
M3 net2 BIAS VDD VDD pch l=0.15 w=1 nf=1 m=1
M4 net2 net2 V1 VSS nch l=0.15 w=1 nf=1 m=1
M5 net3 net3 V1 VDD pch l=0.15 w=1 nf=1 m=1
M6 net3 Vi VSS VSS nch l=0.15 w=1 nf=1 m=1
M7 V1 BIAS VDD VDD pch l=0.15 w=1 nf=1 m=1
M8 V1 Vi VSS VSS nch l=0.15 w=1 nf=1 m=1
RL Vo GND 1k
VOS1 V1 net4 DC 1
VOS2 net5 V1 DC 1
X1 0 0 Vo net4 net0 opamp gain=1e6
X2 0 0 Vo net5 net1 opamp gain=1e6
.ends dut
