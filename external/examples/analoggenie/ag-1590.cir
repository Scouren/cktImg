* official Analog Canvas netlist; PDK X cards rewritten by convert.py
.model nch nmos
.model pch pmos
.model qpnp pnp

.subckt opamp VDD VSS INP INN out VB1 VB2
M1 net6 VB1 VDD VDD pch l=0.15 w=1 nf=1 m=1
M10 net4 VB2 net3 VDD pch l=0.15 w=1 nf=1 m=1
M11 out VB2 net2 VDD pch l=0.15 w=1 nf=1 m=1
M12 net0 net0 net5 VDD pch l=0.15 w=1 nf=1 m=1
M13 VB3 net0 VDD VDD pch l=0.15 w=1 nf=1 m=1
M14 VB3 VB3 VB4 VSS nch l=0.15 w=1 nf=1 m=1
M15 VB4 VB4 VSS VSS nch l=0.15 w=1 nf=1 m=1
M2 net1 INP net6 VDD pch l=0.15 w=1 nf=1 m=1
M3 net7 INN net6 VDD pch l=0.15 w=1 nf=1 m=1
M4 net1 VB4 VSS VSS nch l=0.15 w=1 nf=1 m=1
M5 net7 VB4 VSS VSS nch l=0.15 w=1 nf=1 m=1
M6 net4 VB3 net1 VSS nch l=0.15 w=1 nf=1 m=1
M7 out VB3 net7 VSS nch l=0.15 w=1 nf=1 m=1
M8 net3 net4 VDD VDD pch l=0.15 w=1 nf=1 m=1
M9 net2 net4 VDD VDD pch l=0.15 w=1 nf=1 m=1
R4 VDD net5 1k
R5 net0 VSS 1k
.ends opamp

.subckt dut VDD VSS VB1 VB2 Vout
Q1 VSS VSS X qpnp m=1
Q2 VSS VSS net0 qpnp m=1
R1 Vout X 1k
R2 Vout Y 1k
R3 Y net0 1k
X1 VDD VSS X Y Vout VB1 VB2 opamp
.ends dut
