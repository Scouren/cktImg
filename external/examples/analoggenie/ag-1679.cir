* official Analog Canvas netlist; PDK X cards rewritten by convert.py
.model nch nmos
.model pch pmos
.model qpnp pnp

.subckt opamp VDD VSS VB1 INP VA VB2 INN OUT
M1 VA INN net2 VDD pch l=0.15 w=1 nf=1 m=1
M10 VA VB4 VSS VSS nch l=0.15 w=1 nf=1 m=1
M11 VB4 VB4 VSS VSS nch l=0.15 w=1 nf=1 m=1
M12 VB3 VB3 VB4 VSS nch l=0.15 w=1 nf=1 m=1
M13 VB3 net1 VDD VDD pch l=0.15 w=1 nf=1 m=1
M14 net1 net1 VDD VDD pch l=0.15 w=1 nf=1 m=1
M15 VF VB4 VSS VSS nch l=0.15 w=1 nf=1 m=1
M2 VF INP net2 VDD pch l=0.15 w=1 nf=1 m=1
M3 INN net0 VDD VDD pch l=0.15 w=1 nf=1 m=1
M4 OUT VB2 INN VDD pch l=0.15 w=1 nf=1 m=1
M5 net2 VB1 VDD VDD pch l=0.15 w=1 nf=1 m=1
M6 OUT VB3 VF VSS nch l=0.15 w=1 nf=1 m=1
M7 net3 net0 VDD VDD pch l=0.15 w=1 nf=1 m=1
M8 net0 VB2 net3 VDD pch l=0.15 w=1 nf=1 m=1
M9 net0 VB3 VA VSS nch l=0.15 w=1 nf=1 m=1
R4 net1 VSS 1k
.ends opamp

.subckt dut VDD VSS Vout VB1 VB2
Q1 VSS VSS net1 qpnp m=1
Q2 net1 net1 net0 qpnp m=1
Q3 VSS VSS VA qpnp m=1
Q4 VA VA Y qpnp m=1
R1 Vout X 1k
R2 Vout Y 1k
R3 X net0 1k
X1 VDD VSS VB1 X VA VB2 Y Vout opamp
.ends dut
