* official Analog Canvas netlist; PDK X cards rewritten by convert.py
.model nch nmos
.model pch pmos

.subckt dut VDD VSS VSTO VCONT1 VCONT2 VCONT3 VOUT VB1 VB2 VB4
CL VOUT VSS 1p
CSTO VSTO VSS 1p
LRX net3 VX 1n
M1 net7 VB1 VDD VDD pch l=0.15 w=1 nf=1 m=1
M10 net6 VB2 VSS VSS nch l=0.15 w=1 nf=1 m=1
M11 VY VB2 VSS VSS nch l=0.15 w=1 nf=1 m=1
M12 VB5 net1 VDD VDD pch l=0.15 w=1 nf=1 m=1
M13 VB5 VB5 net2 VSS nch l=0.15 w=1 nf=1 m=1
M14 net2 VB5 VSS VSS nch l=0.15 w=1 nf=1 m=1
M15 net1 net1 VDD VDD pch l=0.15 w=1 nf=1 m=1
M16 net1 VB4 VSS VSS nch l=0.15 w=1 nf=1 m=1
M17 VB4 net1 VDD VDD pch l=0.15 w=1 nf=1 m=1
M18 VB4 VB4 VSS VSS nch l=0.15 w=1 nf=1 m=1
M2 net6 VG net7 net5 pch l=0.15 w=1 nf=1 m=1
M3 VY VX net7 net5 pch l=0.15 w=1 nf=1 m=1
M4 net8 net0 VDD VDD pch l=0.15 w=1 nf=1 m=1
M5 net4 net0 VDD VDD pch l=0.15 w=1 nf=1 m=1
M6 net0 VB3 net8 VDD pch l=0.15 w=1 nf=1 m=1
M7 VG VB3 net4 VDD pch l=0.15 w=1 nf=1 m=1
M8 net0 VB5 net6 VSS nch l=0.15 w=1 nf=1 m=1
M9 VG VB5 VY VSS nch l=0.15 w=1 nf=1 m=1
MN1 net3 VCONT2 VSS VSS nch l=0.15 w=1 nf=1 m=1
MN2 VX VCONT3 VSS VSS nch l=0.15 w=1 nf=1 m=1
MP2 VX VG VOUT VOUT pch l=0.15 w=1 nf=1 m=1
MP3 net3 VCONT1 VSTO VSTO pch l=0.15 w=1 nf=1 m=1
.ends dut
