* official Analog Canvas netlist; PDK X cards rewritten by convert.py
.model nch nmos
.model pch pmos

.subckt dut VDD VSS VSTO VCONT1 VCONT2 VCONT3 VOUT VB2 VB1
CL VOUT VSS 1p
CSTO VSTO VSS 1p
LRX net2 net6 1n
M1 net0 net0 VDD VDD pch l=0.15 w=1 nf=1 m=1
M10 VB2 VB2 VDD VDD pch l=0.15 w=1 nf=1 m=1
M11 net7 VB2 VDD VDD pch l=0.15 w=1 nf=1 m=1
M12 VB1 VB1 VDD VDD pch l=0.15 w=1 nf=1 m=1
M13 net4 VB1 VDD VDD pch l=0.15 w=1 nf=1 m=1
M14 VB2 net7 VSS VSS nch l=0.15 w=1 nf=1 m=1
M15 net7 net7 VSS VSS nch l=0.15 w=1 nf=1 m=1
M16 VB1 net7 VSS VSS nch l=0.15 w=1 nf=1 m=1
M17 net4 net4 VSS VSS nch l=0.15 w=1 nf=1 m=1
M2 net1 net0 VDD VDD pch l=0.15 w=1 nf=1 m=1
M3 net3 net3 VDD VDD pch l=0.15 w=1 nf=1 m=1
M4 net3 net3 VDD VDD pch l=0.15 w=1 nf=1 m=1
M5 net1 net1 VSS VSS nch l=0.15 w=1 nf=1 m=1
M6 net3 net1 VSS VSS nch l=0.15 w=1 nf=1 m=1
M7 net0 net6 net5 VSS nch l=0.15 w=1 nf=1 m=1
M8 net3 net3 net5 VSS nch l=0.15 w=1 nf=1 m=1
M9 net5 net4 VSS VSS nch l=0.15 w=1 nf=1 m=1
MN1 net2 VCONT2 VSS VSS nch l=0.15 w=1 nf=1 m=1
MN2 net6 VCONT3 VSS VSS nch l=0.15 w=1 nf=1 m=1
MP2 net6 net3 VOUT VDD pch l=0.15 w=1 nf=1 m=1
MP3 net2 VCONT1 VSTO VDD pch l=0.15 w=1 nf=1 m=1
.ends dut
