* official Analog Canvas netlist; PDK X cards rewritten by convert.py
.model nch nmos
.model pch pmos

.subckt dut VDD VSS VOUT VERR VIN
M1 net1 VEA VIN VDD pch l=0.15 w=1 nf=1 m=1
M10 VEA VY net6 VSS nch l=0.15 w=1 nf=1 m=1
M11 VX VY net7 VSS nch l=0.15 w=1 nf=1 m=1
M12 net6 VX VSS VSS nch l=0.15 w=1 nf=1 m=1
M13 net0 VB2 VSS VSS nch l=0.15 w=1 nf=1 m=1
M14 VEA VY VSS VSS nch l=0.15 w=1 nf=1 m=1
M15 VY VY VEA VSS nch l=0.15 w=1 nf=1 m=1
M16 VY net5 VDD VDD pch l=0.15 w=1 nf=1 m=1
M17 net5 net5 net4 VDD pch l=0.15 w=1 nf=1 m=1
M18 net7 VX VSS VSS nch l=0.15 w=1 nf=1 m=1
M2 VX VX net1 VDD pch l=0.15 w=1 nf=1 m=1
M3 VX nb VSS VSS nch l=0.15 w=1 nf=1 m=1
M4 net8 VB1 VDD VDD pch l=0.15 w=1 nf=1 m=1
M5 net2 VB1 VDD VDD pch l=0.15 w=1 nf=1 m=1
M6 VEA VB3 net8 VDD pch l=0.15 w=1 nf=1 m=1
M7 VX VB3 net2 VDD pch l=0.15 w=1 nf=1 m=1
M8 net8 VREF net0 VSS nch l=0.15 w=1 nf=1 m=1
M9 net2 VEA net0 VSS nch l=0.15 w=1 nf=1 m=1
MBIAS VERR nb VSS VSS nch l=0.15 w=1 nf=1 m=1
MCHG net9 pb VIN VDD pch l=0.15 w=1 nf=1 m=1
MCTRL VERR VX VOUT VDD pch l=0.15 w=1 nf=1 m=1
MGEN net3 net3 VSS VSS nch l=0.15 w=1 nf=1 m=1
MINJ VERR net3 VSS VSS nch l=0.15 w=1 nf=1 m=1
MRES VOUT VERR VIN VDD pch l=0.15 w=1 nf=1 m=1
MSEN net3 VEA net9 VDD pch l=0.15 w=1 nf=1 m=1
R1 VDD net4 1k
R2 net5 VSS 1k
.ends dut
