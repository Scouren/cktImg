* official Analog Canvas netlist; PDK X cards rewritten by convert.py
.model nch nmos
.model pch pmos

.subckt dut VDD VSS vci phi1 phi2 vco VB1
C1 net3 VSS 1p
C2 VX vco 1p
M1 vci phi1 net3 VSS nch l=0.15 w=1 nf=1 m=1
M10 VB1 VB1 VDD VDD pch l=0.15 w=1 nf=1 m=1
M11 VX VB1 VDD VDD pch l=0.15 w=1 nf=1 m=1
M12 VB1 VX VB3 VSS nch l=0.15 w=1 nf=1 m=1
M13 VX VB3 VSS VSS nch l=0.15 w=1 nf=1 m=1
M14 net2 net2 VDD VDD pch l=0.15 w=1 nf=1 m=1
M15 VB2 net2 VDD VDD pch l=0.15 w=1 nf=1 m=1
M16 net2 VB3 VSS VSS nch l=0.15 w=1 nf=1 m=1
M17 VB2 VB2 VSS VSS nch l=0.15 w=1 nf=1 m=1
M2 net3 phi2 VX VSS nch l=0.15 w=1 nf=1 m=1
M3 net1 VX net0 VSS nch l=0.15 w=1 nf=1 m=1
M4 vco VSS net0 VSS nch l=0.15 w=1 nf=1 m=1
M5 net0 VB2 VSS VSS nch l=0.15 w=1 nf=1 m=1
M6 net1 net1 VDD VDD pch l=0.15 w=1 nf=1 m=1
M7 vco net1 VDD VDD pch l=0.15 w=1 nf=1 m=1
M8 net1 net1 VDD VDD pch l=0.15 w=1 nf=1 m=1
M9 net1 VB2 VSS VSS nch l=0.15 w=1 nf=1 m=1
R1 VB3 VSS 1k
.ends dut
