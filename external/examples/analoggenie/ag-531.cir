* official Analog Canvas netlist; PDK X cards rewritten by convert.py
.model nch nmos

.subckt dut VDD VSS Vcont Vb
CS1 P Y 1p
CS2 Q X 1p
ISS net0 VSS DC 1m
L1 VDD X 1n
L2 VDD Y 1n
M1 X Y net0 VSS nch l=0.15 w=1 nf=1 m=1
M2 Y X net0 VSS nch l=0.15 w=1 nf=1 m=1
Mv1 Vcont P Vcont VSS nch l=0.15 w=1 nf=1 m=1
Mv2 Vcont Q Vcont VSS nch l=0.15 w=1 nf=1 m=1
R1 P Vb 1k
R2 Q Vb 1k
.ends dut
