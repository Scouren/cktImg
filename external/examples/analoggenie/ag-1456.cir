* official Analog Canvas netlist; PDK X cards rewritten by convert.py
.model nch nmos
.model pch pmos

.subckt cmp VDD VSS INN OUT
M1 VX VX VDD VDD pch l=0.15 w=1 nf=1 m=1
M10 VY VB1 VDD VDD pch l=0.15 w=1 nf=1 m=1
M11 VB1 VB1 VDD VDD pch l=0.15 w=1 nf=1 m=1
M12 net2 VZ VDD VDD pch l=0.15 w=1 nf=1 m=1
M13 net0 VZ VDD VDD pch l=0.15 w=1 nf=1 m=1
M14 VZ VZ VDD VDD pch l=0.15 w=1 nf=1 m=1
M15 VB3 VZ VDD VDD pch l=0.15 w=1 nf=1 m=1
M16 VY VY VSS VSS nch l=0.15 w=1 nf=1 m=1
M17 VB1 net2 VSS VSS nch l=0.15 w=1 nf=1 m=1
M18 net2 net2 VSS VSS nch l=0.15 w=1 nf=1 m=1
M19 net0 net0 VSS VSS nch l=0.15 w=1 nf=1 m=1
M2 OUT OUT VDD VDD pch l=0.15 w=1 nf=1 m=1
M20 VZ VB3 VB2 VSS nch l=0.15 w=1 nf=1 m=1
M21 VB2 net0 VSS VSS nch l=0.15 w=1 nf=1 m=1
M22 VB3 VB2 VSS VSS nch l=0.15 w=1 nf=1 m=1
M3 OUT OUT VDD VDD pch l=0.15 w=1 nf=1 m=1
M4 net1 VX VDD VDD pch l=0.15 w=1 nf=1 m=1
M5 VX INN net3 VSS nch l=0.15 w=1 nf=1 m=1
M6 OUT OUT net3 VSS nch l=0.15 w=1 nf=1 m=1
M7 net3 VY VSS VSS nch l=0.15 w=1 nf=1 m=1
M8 OUT net1 VSS VSS nch l=0.15 w=1 nf=1 m=1
M9 net1 net1 VSS VSS nch l=0.15 w=1 nf=1 m=1
.ends cmp

.subckt dut VDD VSS VSTO VOUT VCONT1 VCONT2 VCONT3
CL VOUT VSS 1p
CSTO VSTO VSS 1p
LRX net2 net0 1n
MN1 net2 VCONT2 VSS VSS nch l=0.15 w=1 nf=1 m=1
MN2 net0 VCONT3 VSS VSS nch l=0.15 w=1 nf=1 m=1
MP2 net0 net1 VOUT VDD pch l=0.15 w=1 nf=1 m=1
MP3 net2 VCONT1 VSTO VDD pch l=0.15 w=1 nf=1 m=1
X1 VDD VSS net0 net1 cmp
.ends dut
