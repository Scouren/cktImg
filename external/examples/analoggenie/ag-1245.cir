* official Analog Canvas netlist; PDK X cards rewritten by convert.py
.model nch nmos
.model pch pmos

.subckt dut VDD VSS VCONT1 VCONT2 VCONT3 VIN VCONT4 VCONT5 VP VB2 VREF VB1
.model DIODE D(IS=1e-14 N=1)
CFLY VX1 VX2 1p
CO VP VN 1p
COP VP VSS 1p
D1 VN VX2 DIODE
L1 VX1 VX3 1n
M1 net1 VCONT1 VIN VDD pch l=0.15 w=1 nf=1 m=1
M10 net5 net5 net1 VDD pch l=0.15 w=1 nf=1 m=1
M11 VX1 net5 net1 VDD pch l=0.15 w=1 nf=1 m=1
M12 net2 net4 VDD VDD pch l=0.15 w=1 nf=1 m=1
M13 net4 net4 VDD VDD pch l=0.15 w=1 nf=1 m=1
M14 VX3 VX3 VDD VDD pch l=0.15 w=1 nf=1 m=1
M15 VCTRL VX3 VDD VDD pch l=0.15 w=1 nf=1 m=1
M16 net4 VFP1 net3 VSS nch l=0.15 w=1 nf=1 m=1
M17 VX3 VREF net3 VSS nch l=0.15 w=1 nf=1 m=1
M18 net3 VB3 VSS VSS nch l=0.15 w=1 nf=1 m=1
M19 net2 net2 VSS VSS nch l=0.15 w=1 nf=1 m=1
M2 VX1 VCONT2 VIN VDD pch l=0.15 w=1 nf=1 m=1
M20 VCTRL net2 VSS VSS nch l=0.15 w=1 nf=1 m=1
M21 VB3 net6 VDD VDD pch l=0.15 w=1 nf=1 m=1
M22 net6 net6 VDD VDD pch l=0.15 w=1 nf=1 m=1
M23 VB1 net6 VDD VDD pch l=0.15 w=1 nf=1 m=1
M24 VB3 VB3 VSS VSS nch l=0.15 w=1 nf=1 m=1
M25 net6 VB1 VSS VSS nch l=0.15 w=1 nf=1 m=1
M26 VB1 VB1 VSS VSS nch l=0.15 w=1 nf=1 m=1
M3 VX2 VCONT3 VIN VDD pch l=0.15 w=1 nf=1 m=1
M4 VX3 VCONT4 VSS VSS nch l=0.15 w=1 nf=1 m=1
M5 VP VCONT5 VX3 VDD pch l=0.15 w=1 nf=1 m=1
M6 net0 VCTRL net1 VDD pch l=0.15 w=1 nf=1 m=1
M7 net0 net0 VSS VSS nch l=0.15 w=1 nf=1 m=1
M8 net5 net0 VSS VSS nch l=0.15 w=1 nf=1 m=1
M9 net0 VB2 VSS VSS nch l=0.15 w=1 nf=1 m=1
R1 VP VFP1 1k
R2 VFP1 VSS 1k
.ends dut
