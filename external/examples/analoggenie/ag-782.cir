* official Analog Canvas netlist; PDK X cards rewritten by convert.py
.model nch nmos
.model qnpn npn

.subckt opamp_differential VDD VSS VIP VIN VOP VON params: gain=1e6 vocm=0
VCM ncm 0 DC {vocm}
EPLUS VOP ncm VIP VIN {gain/2}
EMINUS VON ncm VIN VIP {gain/2}
.ends opamp_differential

.subckt dut VDD VSS VB VN vb- va- va+ vb+ vo+ vo-
C1 vo+ net5 1p
C2 vo- net1 1p
I1 VDD net2 DC 1m
I2 VDD net3 DC 1m
M1 net0 va- VSS VSS nch l=0.15 w=1 nf=1 m=1
M2 net4 va+ VSS VSS nch l=0.15 w=1 nf=1 m=1
M3 net0 vb- VSS VSS nch l=0.15 w=1 nf=1 m=1
M4 net4 vb+ VSS VSS nch l=0.15 w=1 nf=1 m=1
M7 net5 VN net3 VSS nch l=0.15 w=1 nf=1 m=1
M8 net1 VN net2 VSS nch l=0.15 w=1 nf=1 m=1
Q5 net2 VB net0 VSS qnpn m=1
Q6 net3 VB net4 VSS qnpn m=1
X1 VDD VSS net2 net3 vo+ vo- opamp_differential gain=1e6
.ends dut
