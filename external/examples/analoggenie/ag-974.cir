* official Analog Canvas netlist; PDK X cards rewritten by convert.py
.model nch nmos
.model pch pmos

.subckt dut VDD VSS Vb1 Vb2
VB1 net1 net3 DC 1
M1 net2 Vb1 net0 VDD pch l=0.15 w=1 nf=1 m=1
M2 VSS net1 net0 VDD pch l=0.15 w=1 nf=1 m=1
M3 net3 net2 VDD VDD pch l=0.15 w=1 nf=1 m=1
M4 net3 net2 VSS VSS nch l=0.15 w=1 nf=1 m=1
M5 net0 Vb2 VDD VDD pch l=0.15 w=1 nf=1 m=1
vin net2 VSS DC 1
.ends dut
