* official Analog Canvas netlist; PDK X cards rewritten by convert.py
.model nch nmos
.model pch pmos
.model qpnp pnp

.subckt A1 VDD VSS INP INN OUT
M1 net0 INP net2 VDD pch l=0.15 w=1 nf=1 m=1
M10 net6 VB2 VSS VSS nch l=0.15 w=1 nf=1 m=1
M11 net2 VB1 VDD VDD pch l=0.15 w=1 nf=1 m=1
M12 VC net1 VDD VDD pch l=0.15 w=1 nf=1 m=1
M13 VC VC net4 VSS nch l=0.15 w=1 nf=1 m=1
M14 net4 VC VSS VSS nch l=0.15 w=1 nf=1 m=1
M15 net1 net1 VDD VDD pch l=0.15 w=1 nf=1 m=1
M16 net1 VB4 VSS VSS nch l=0.15 w=1 nf=1 m=1
M17 VB4 net1 VDD VDD pch l=0.15 w=1 nf=1 m=1
M18 net5 VB4 VSS VSS nch l=0.15 w=1 nf=1 m=1
M2 net6 INN net2 VDD pch l=0.15 w=1 nf=1 m=1
M3 net3 VP VDD VDD pch l=0.15 w=1 nf=1 m=1
M4 net7 VP VDD VDD pch l=0.15 w=1 nf=1 m=1
M5 VP VB3 net3 VDD pch l=0.15 w=1 nf=1 m=1
M6 OUT VB3 net7 VDD pch l=0.15 w=1 nf=1 m=1
M7 VP VC net0 VSS nch l=0.15 w=1 nf=1 m=1
M8 OUT VC net6 VSS nch l=0.15 w=1 nf=1 m=1
M9 net0 VB2 VSS VSS nch l=0.15 w=1 nf=1 m=1
R1 VB4 net5 1k
.ends A1

.subckt dut VDD VSS Vout
Q1 VSS VSS X qpnp m=1
Q2 VSS VSS net0 qpnp m=1
R1 Vout X 1k
R2 Vout Y 1k
R3 Y net0 1k
X1 VDD VSS X Y Vout A1
.ends dut
