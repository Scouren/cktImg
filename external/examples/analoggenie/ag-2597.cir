* official Analog Canvas netlist; PDK X cards rewritten by convert.py
.model nch nmos
.model pch pmos

.subckt dut VDD VSS Vref biasp biascas biasn Vout
C1 Vset VSS 1p
C2 n3 Vout 1p
M1 Vout n3 VDD VDD pch l=0.15 w=1 nf=1 m=1
M10 net1 net2 VDD VDD pch l=0.15 w=1 nf=1 m=1
M11 Vset fb VDD VDD pch l=0.15 w=1 nf=1 m=1
M12 net1 net1 VSS VSS nch l=0.15 w=1 nf=1 m=1
M13 net0 VB VSS VSS nch l=0.15 w=1 nf=1 m=1
M14 VB net3 VDD VDD pch l=0.15 w=1 nf=1 m=1
M15 net3 net3 VDD VDD pch l=0.15 w=1 nf=1 m=1
M16 VB VB VSS VSS nch l=0.15 w=1 nf=1 m=1
M17 Vset net1 VSS VSS nch l=0.15 w=1 nf=1 m=1
M2 n1 Vset Vout VDD pch l=0.15 w=1 nf=1 m=1
M3 n1 biasn VSS VSS nch l=0.15 w=1 nf=1 m=1
M4 n3 biasp VDD VDD pch l=0.15 w=1 nf=1 m=1
M5 n3 biascas n1 VSS nch l=0.15 w=1 nf=1 m=1
M6 net2 fb net0 VSS nch l=0.15 w=1 nf=1 m=1
M7 fb Vref net0 VSS nch l=0.15 w=1 nf=1 m=1
M8 fb fb VDD VDD pch l=0.15 w=1 nf=1 m=1
M9 net2 net2 VDD VDD pch l=0.15 w=1 nf=1 m=1
R1 fb VSS 1k
R2 Vout fb 1k
R3 net3 VSS 1k
.ends dut
