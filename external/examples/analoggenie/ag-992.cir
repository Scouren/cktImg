* official Analog Canvas netlist; PDK X cards rewritten by convert.py
.model nch nmos
.model pch pmos

.subckt dut VDD VSS GND v1 v2 vout
C1 vout GND 10pF
I1 net5 net2 DC 1m
M1 net8 v1 net3 VSS nch l=0.15 w=1 nf=1 m=1
M10 net6 net6 VSS VSS nch l=0.15 w=1 nf=1 m=1
M11 net0 net6 VSS VSS nch l=0.15 w=1 nf=1 m=1
M12 net2 net2 VSS VSS nch l=0.15 w=1 nf=1 m=1
M13 net4 net2 VSS VSS nch l=0.15 w=1 nf=1 m=1
M14 net5 net5 VDD VDD pch l=0.15 w=1 nf=1 m=1
M15 net4 net4 VDD VDD pch l=0.15 w=1 nf=1 m=1
M2 net7 v2 net3 VSS nch l=0.15 w=1 nf=1 m=1
M3 net8 net5 VDD VDD pch l=0.15 w=1 nf=1 m=1
M4 net7 net5 VDD VDD pch l=0.15 w=1 nf=1 m=1
M5 net3 net2 VSS VSS nch l=0.15 w=1 nf=1 m=1
M6 net1 net4 net8 VDD pch l=0.15 w=1 nf=1 m=1
M7 vout net4 net7 VDD pch l=0.15 w=1 nf=1 m=1
M8 net1 net1 net6 VSS nch l=0.15 w=1 nf=1 m=1
M9 vout net1 net0 VSS nch l=0.15 w=1 nf=1 m=1
.ends dut
