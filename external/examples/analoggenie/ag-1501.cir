* official Analog Canvas netlist; PDK X cards rewritten by convert.py
.model nch nmos
.model pch pmos
.model qnpn npn

.subckt opamp VDD VSS VB1 VB2 INP INN OUT VB3
M1 net3 INP VX VDD pch l=0.15 w=1 nf=1 m=1
M10 net5 VB5 VSS VSS nch l=0.15 w=1 nf=1 m=1
M11 VX VB1 VDD VDD pch l=0.15 w=1 nf=1 m=1
M12 VB4 net1 VDD VDD pch l=0.15 w=1 nf=1 m=1
M13 VB4 VB4 VB5 VSS nch l=0.15 w=1 nf=1 m=1
M14 VB5 VB5 VSS VSS nch l=0.15 w=1 nf=1 m=1
M15 net1 net1 VDD VDD pch l=0.15 w=1 nf=1 m=1
M16 VX net1 VDD VDD pch l=0.15 w=1 nf=1 m=1
M17 net1 VX VB3 VSS nch l=0.15 w=1 nf=1 m=1
M18 VX VB3 VSS VSS nch l=0.15 w=1 nf=1 m=1
M2 net5 INN VX VDD pch l=0.15 w=1 nf=1 m=1
M3 net0 net2 VDD VDD pch l=0.15 w=1 nf=1 m=1
M4 net4 net2 VDD VDD pch l=0.15 w=1 nf=1 m=1
M5 net2 VB2 net0 VDD pch l=0.15 w=1 nf=1 m=1
M6 OUT VB2 net4 VDD pch l=0.15 w=1 nf=1 m=1
M7 net2 VB4 net3 VSS nch l=0.15 w=1 nf=1 m=1
M8 OUT VB4 net5 VSS nch l=0.15 w=1 nf=1 m=1
M9 net3 VB5 VSS VSS nch l=0.15 w=1 nf=1 m=1
R1 VB3 VSS 1k
.ends opamp

.subckt dut VDD VSS Vout VB1 VB2 VB3
Q1 net0 net0 VSS VSS qnpn m=1
Q2 net1 net1 VSS VSS qnpn m=1
R1 Vout net0 1k
R2 Vout net2 1k
R3 net2 net1 1k
X1 VDD VSS VB1 VB2 net0 net2 Vout VB3 opamp
.ends dut
