* official Analog Canvas netlist; PDK X cards rewritten by convert.py
.model nch nmos
.model pch pmos

.subckt dut VDD VSS VB1 VREF VB3 VB2 IBUF VB4 VIN VOUT
CL VOUT net8 1p
M10 EAO VB3 net0 VDD pch l=0.15 w=1 nf=1 m=1
M11 net5 VX VDD VDD pch l=0.15 w=1 nf=1 m=1
M12 net0 VX VDD VDD pch l=0.15 w=1 nf=1 m=1
M13 net4 VB4 VDD VDD pch l=0.15 w=1 nf=1 m=1
M14 VX EAO net4 VDD pch l=0.15 w=1 nf=1 m=1
M15 VX VX VSS VSS nch l=0.15 w=1 nf=1 m=1
M16 GATE VX VSS VSS nch l=0.15 w=1 nf=1 m=1
M17 VDD net4 GATE VSS nch l=0.15 w=1 nf=1 m=1
M18 net0 EAO IBUF VSS nch l=0.15 w=1 nf=1 m=1
M19 net0 net0 VDD VDD pch l=0.15 w=1 nf=1 m=1
M2 net3 VB1 VDD VDD pch l=0.15 w=1 nf=1 m=1
M20 GATE net0 VDD VDD pch l=0.15 w=1 nf=1 m=1
M21 VSS IBUF GATE VDD pch l=0.15 w=1 nf=1 m=1
M22 net2 net2 VDD VDD pch l=0.15 w=1 nf=1 m=1
M23 VB5 net2 VDD VDD pch l=0.15 w=1 nf=1 m=1
M24 VB5 VB5 net6 VSS nch l=0.15 w=1 nf=1 m=1
M25 net6 VB5 VSS VSS nch l=0.15 w=1 nf=1 m=1
M3 net7 VREF net3 VDD pch l=0.15 w=1 nf=1 m=1
M4 net1 FB net3 VDD pch l=0.15 w=1 nf=1 m=1
M5 net7 VB2 VSS VSS nch l=0.15 w=1 nf=1 m=1
M6 net1 VB2 VSS VSS nch l=0.15 w=1 nf=1 m=1
M7 VX VB5 net7 VSS nch l=0.15 w=1 nf=1 m=1
M8 EAO VB5 net1 VSS nch l=0.15 w=1 nf=1 m=1
M9 VX VB3 net5 VDD pch l=0.15 w=1 nf=1 m=1
MNP VIN GATE VOUT VSS nch l=0.15 w=1 nf=1 m=1
R1 FB VSS 1k
R2 VOUT FB 1k
R3 net2 VSS 1k
R4 net8 VSS 1k
RL VOUT VSS 1k
.ends dut
