* official Analog Canvas netlist; PDK X cards rewritten by convert.py
.model nch nmos
.model pch pmos

.subckt dut VDD VSS vci phi1 phi2 vco
C1 net4 VSS 1p
C2 net5 vco 1p
C3 net1 vco 1p
M1 vci phi1 net4 VSS nch l=0.15 w=1 nf=1 m=1
M10 net2 net2 net3 VDD pch l=0.15 w=1 nf=1 m=1
M11 VB net2 VDD VDD pch l=0.15 w=1 nf=1 m=1
M12 VB VB VSS VSS nch l=0.15 w=1 nf=1 m=1
M2 net4 phi2 net5 VSS nch l=0.15 w=1 nf=1 m=1
M3 net0 net5 net6 VSS nch l=0.15 w=1 nf=1 m=1
M4 net1 VSS net6 VSS nch l=0.15 w=1 nf=1 m=1
M5 net6 VB VSS VSS nch l=0.15 w=1 nf=1 m=1
M6 net0 net0 VDD VDD pch l=0.15 w=1 nf=1 m=1
M7 net1 net0 VDD VDD pch l=0.15 w=1 nf=1 m=1
M8 vco net1 VDD VDD pch l=0.15 w=1 nf=1 m=1
M9 vco VB VSS VSS nch l=0.15 w=1 nf=1 m=1
R1 VDD net3 1k
R2 net2 VSS 1k
.ends dut
