* official Analog Canvas netlist; PDK X cards rewritten by convert.py
.model nch nmos
.model pch pmos

.subckt dut VDD VSS VIN VCONT1 VCONT2 VCONT3 VCONT4 VCONT5 VP VB1 VREF VB3 VB2 VB4 VB5
.model DIODE D(IS=1e-14 N=1)
CFLY VX1 VX2 1p
CO VP VN 1p
COP VP VSS 1p
D1 VN VX2 DIODE
L1 VX1 VX3 1n
M1 VISR VCONT1 VIN VIN pch l=0.15 w=1 nf=1 m=1
M2 VX1 VCONT2 VIN VIN pch l=0.15 w=1 nf=1 m=1
M3 VX2 VCONT3 VIN VIN pch l=0.15 w=1 nf=1 m=1
M4 VX3 VCONT4 VSS VSS nch l=0.15 w=1 nf=1 m=1
M5 VX3 VCONT5 VP VP pch l=0.15 w=1 nf=1 m=1
MN1 net5 VBN net2 VSS nch l=0.15 w=1 nf=1 m=1
MN10 net6 net3 VSS VSS nch l=0.15 w=1 nf=1 m=1
MN11 net3 VB5 VSS VSS nch l=0.15 w=1 nf=1 m=1
MN2 VCTRL VBN net7 VSS nch l=0.15 w=1 nf=1 m=1
MN3 net2 VB2 VSS VSS nch l=0.15 w=1 nf=1 m=1
MN4 net7 VB2 VSS VSS nch l=0.15 w=1 nf=1 m=1
MN5 VBN VBN net9 VSS nch l=0.15 w=1 nf=1 m=1
MN6 net9 VBN VSS VSS nch l=0.15 w=1 nf=1 m=1
MN7 net10 VB4 VSS VSS nch l=0.15 w=1 nf=1 m=1
MN8 VB4 VB4 VSS VSS nch l=0.15 w=1 nf=1 m=1
MN9 net3 net3 VSS VSS nch l=0.15 w=1 nf=1 m=1
MP1 net1 VB1 VDD VDD pch l=0.15 w=1 nf=1 m=1
MP10 VB4 net10 VDD VDD pch l=0.15 w=1 nf=1 m=1
MP11 net3 VCTRL VISR VISR pch l=0.15 w=1 nf=1 m=1
MP12 net6 net6 VISR VISR pch l=0.15 w=1 nf=1 m=1
MP13 VX1 net6 VISR VISR pch l=0.15 w=1 nf=1 m=1
MP2 net2 VREF net1 net8 pch l=0.15 w=1 nf=1 m=1
MP3 net7 VFP1 net1 net8 pch l=0.15 w=1 nf=1 m=1
MP4 net0 net5 VDD VDD pch l=0.15 w=1 nf=1 m=1
MP5 net4 net5 VDD VDD pch l=0.15 w=1 nf=1 m=1
MP6 net5 VB3 net0 VDD pch l=0.15 w=1 nf=1 m=1
MP7 VCTRL VB3 net4 VDD pch l=0.15 w=1 nf=1 m=1
MP8 VBN net10 VDD VDD pch l=0.15 w=1 nf=1 m=1
MP9 net10 net10 VDD VDD pch l=0.15 w=1 nf=1 m=1
R1 VP VFP1 1k
R2 VFP1 VSS 1k
.ends dut
