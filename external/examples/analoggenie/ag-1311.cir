* official Analog Canvas netlist; PDK X cards rewritten by convert.py
.model nch nmos
.model pch pmos

.subckt EA1 VDD VSS INP INN OUT VX2 VB1 VB2
MN1 net1 VX2 VSS VSS nch l=0.15 w=1 nf=1 m=1
MN2 OUT net2 VSS VSS nch l=0.15 w=1 nf=1 m=1
MN3 net2 net2 VSS VSS nch l=0.15 w=1 nf=1 m=1
MN4 VX2 VX2 VSS VSS nch l=0.15 w=1 nf=1 m=1
MN5 VB4 VB1 VSS VSS nch l=0.15 w=1 nf=1 m=1
MN6 VB1 VB1 VSS VSS nch l=0.15 w=1 nf=1 m=1
MN7 net3 net4 VSS VSS nch l=0.15 w=1 nf=1 m=1
MN8 net4 net4 VSS VSS nch l=0.15 w=1 nf=1 m=1
MN9 VB2 net4 VX2 VSS nch l=0.15 w=1 nf=1 m=1
MP1 net1 net1 VDD VDD pch l=0.15 w=1 nf=1 m=1
MP10 VB2 VB2 VDD VDD pch l=0.15 w=1 nf=1 m=1
MP2 OUT net1 VDD VDD pch l=0.15 w=1 nf=1 m=1
MP3 net0 VB4 VDD VDD pch l=0.15 w=1 nf=1 m=1
MP4 net2 INN net0 VDD pch l=0.15 w=1 nf=1 m=1
MP5 VX2 INP net0 VDD pch l=0.15 w=1 nf=1 m=1
MP6 VB4 VB4 VDD VDD pch l=0.15 w=1 nf=1 m=1
MP7 VB1 net3 VDD VDD pch l=0.15 w=1 nf=1 m=1
MP8 net3 net3 VDD VDD pch l=0.15 w=1 nf=1 m=1
MP9 net4 VB2 VDD VDD pch l=0.15 w=1 nf=1 m=1
RBIAS VX2 VSS 1k
.ends EA1

.subckt dut VDD VSS VIN VCONT1 VCONT2 VCONT3 VCONT4 VCONT5 VB3 VP VB1 VB2 VREF
.model DIODE D(IS=1e-14 N=1)
CFLY VX1 VX2 1p
CO VP VN 1p
COP VP VSS 1p
D1 VN VX2 DIODE
L1 VX1 VX3 1n
M1 net1 VCONT1 VIN VDD pch l=0.15 w=1 nf=1 m=1
M2 VX1 VCONT2 VIN VDD pch l=0.15 w=1 nf=1 m=1
M3 VX2 VCONT3 VIN VDD pch l=0.15 w=1 nf=1 m=1
M4 VX3 VCONT4 VSS VSS nch l=0.15 w=1 nf=1 m=1
M5 VP VCONT5 VX3 VDD pch l=0.15 w=1 nf=1 m=1
MN10 net0 net0 VSS VSS nch l=0.15 w=1 nf=1 m=1
MN11 net2 net0 VSS VSS nch l=0.15 w=1 nf=1 m=1
MN12 net0 VB3 VSS VSS nch l=0.15 w=1 nf=1 m=1
MP11 net2 net2 net1 VDD pch l=0.15 w=1 nf=1 m=1
MP12 VX1 net2 net1 VDD pch l=0.15 w=1 nf=1 m=1
MP13 net0 net3 net1 VDD pch l=0.15 w=1 nf=1 m=1
R1 VP VFP1 1k
R2 VFP1 VSS 1k
X1 VDD VSS VREF VFP1 net3 VX2 VB1 VB2 EA1
.ends dut
