* official Analog Canvas netlist; PDK X cards rewritten by convert.py
.model nch nmos
.model pch pmos

.subckt dut VDD VSS X Y PHI1 VB1 PHI2 VR1 Vin1 PHI1_bar VR2 Vin2 Vo1 Vo2
C1 net0 X 1p
C2 net5 Y 1p
I1 net3 VSS DC 1m
I2 net6 VSS DC 1m
I3 X VSS DC 1m
I4 Y VSS DC 1m
I5 net2 VSS DC 1m
M1 A net7 net3 VSS nch l=0.15 w=1 nf=1 m=1
M10 VDD A Y VSS nch l=0.15 w=1 nf=1 m=1
M11 Vo1 X VSS VSS nch l=0.15 w=1 nf=1 m=1
M12 Vo2 Y VSS VSS nch l=0.15 w=1 nf=1 m=1
M13 Vo1 net4 VDD VDD pch l=0.15 w=1 nf=1 m=1
M14 Vo2 net4 VDD VDD pch l=0.15 w=1 nf=1 m=1
M15 net4 net2 VSS VSS nch l=0.15 w=1 nf=1 m=1
M16 net1 net1 VDD VDD pch l=0.15 w=1 nf=1 m=1
M17 net1 net1 net2 VSS nch l=0.15 w=1 nf=1 m=1
M18 net4 net4 VDD VDD pch l=0.15 w=1 nf=1 m=1
M19 Vin1 PHI1_bar net7 VSS nch l=0.15 w=1 nf=1 m=1
M2 B net8 net3 VSS nch l=0.15 w=1 nf=1 m=1
M20 Vin2 PHI1_bar net8 VSS nch l=0.15 w=1 nf=1 m=1
M21 VR1 PHI1 net7 VSS nch l=0.15 w=1 nf=1 m=1
M22 VR2 PHI1 net8 VSS nch l=0.15 w=1 nf=1 m=1
M23 E PHI2 VB1 VSS nch l=0.15 w=1 nf=1 m=1
M24 F PHI2 VB1 VSS nch l=0.15 w=1 nf=1 m=1
M25 net0 PHI1 VB1 VSS nch l=0.15 w=1 nf=1 m=1
M26 net5 PHI1 VB1 VSS nch l=0.15 w=1 nf=1 m=1
M27 net0 PHI2 E VDD pch l=0.15 w=1 nf=1 m=1
M28 net5 PHI2 F VDD pch l=0.15 w=1 nf=1 m=1
M3 A E net6 VSS nch l=0.15 w=1 nf=1 m=1
M4 B F net6 VSS nch l=0.15 w=1 nf=1 m=1
M5 A A VDD VDD pch l=0.15 w=1 nf=1 m=1
M6 B B VDD VDD pch l=0.15 w=1 nf=1 m=1
M7 A E VDD VDD pch l=0.15 w=1 nf=1 m=1
M8 B F VDD VDD pch l=0.15 w=1 nf=1 m=1
M9 VDD B X VSS nch l=0.15 w=1 nf=1 m=1
.ends dut
