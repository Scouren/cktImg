* official Analog Canvas netlist; PDK X cards rewritten by convert.py
.model nch nmos
.model pch pmos
.model qpnp pnp

.subckt opamp VDD VSS VB1 VB2 INP INN OUT
M1 INP INP net2 VSS nch l=0.15 w=1 nf=1 m=1
M10 net3 VX VSS VSS nch l=0.15 w=1 nf=1 m=1
M11 net4 VX VSS VSS nch l=0.15 w=1 nf=1 m=1
M12 VB4 net0 VDD VDD pch l=0.15 w=1 nf=1 m=1
M13 net0 net0 VDD VDD pch l=0.15 w=1 nf=1 m=1
M14 VX net0 VDD VDD pch l=0.15 w=1 nf=1 m=1
M15 net0 VX VB3 VSS nch l=0.15 w=1 nf=1 m=1
M16 VX VB3 VSS VSS nch l=0.15 w=1 nf=1 m=1
M17 VB4 VB4 VB5 VSS nch l=0.15 w=1 nf=1 m=1
M18 VB5 VB5 VSS VSS nch l=0.15 w=1 nf=1 m=1
M2 net1 INN net2 VSS nch l=0.15 w=1 nf=1 m=1
M3 INP VB1 VDD VDD pch l=0.15 w=1 nf=1 m=1
M4 net1 VB1 VDD VDD pch l=0.15 w=1 nf=1 m=1
M5 VX VB2 INP VDD pch l=0.15 w=1 nf=1 m=1
M6 OUT VB2 net1 VDD pch l=0.15 w=1 nf=1 m=1
M7 net2 VB5 VSS VSS nch l=0.15 w=1 nf=1 m=1
M8 VX VB4 net3 VSS nch l=0.15 w=1 nf=1 m=1
M9 OUT VB4 net4 VSS nch l=0.15 w=1 nf=1 m=1
R4 VB3 VSS 1k
.ends opamp

.subckt dut VDD VSS Vout VB1 VB2
Q1 VSS VSS net2 qpnp m=1
Q2 net2 net2 net0 qpnp m=1
Q3 VSS VSS net1 qpnp m=1
Q4 net1 net1 Y qpnp m=1
R1 Vout X 1k
R2 Vout Y 1k
R3 X net0 1k
X1 VDD VSS VB1 VB2 X Y Vout opamp
.ends dut
