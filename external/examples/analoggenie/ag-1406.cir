* official Analog Canvas netlist; PDK X cards rewritten by convert.py
.model nch nmos
.model pch pmos

.subckt comparator VDD VSS VB1 VB3 VB2 OUT INN
M10 OUT VB3 net4 VDD pch l=0.15 w=1 nf=1 m=1
M11 OUT VC net6 VSS nch l=0.15 w=1 nf=1 m=1
M12 net6 VB2 VSS VSS nch l=0.15 w=1 nf=1 m=1
M13 net0 VB1 VDD VDD pch l=0.15 w=1 nf=1 m=1
M14 net9 OUT net0 net7 pch l=0.15 w=1 nf=1 m=1
M15 net6 INN net0 net7 pch l=0.15 w=1 nf=1 m=1
M16 net1 VP VDD VDD pch l=0.15 w=1 nf=1 m=1
M17 net1 net1 VSS VSS nch l=0.15 w=1 nf=1 m=1
M18 VP VP VDD VDD pch l=0.15 w=1 nf=1 m=1
M19 VP net5 net8 VSS nch l=0.15 w=1 nf=1 m=1
M20 net8 net1 VSS VSS nch l=0.15 w=1 nf=1 m=1
M21 net5 VP VDD VDD pch l=0.15 w=1 nf=1 m=1
M22 net5 net5 VSS VSS nch l=0.15 w=1 nf=1 m=1
M23 VC VP VDD VDD pch l=0.15 w=1 nf=1 m=1
M24 VC VC net10 VSS nch l=0.15 w=1 nf=1 m=1
M25 net10 VC VSS VSS nch l=0.15 w=1 nf=1 m=1
M5 net2 net3 VDD VDD pch l=0.15 w=1 nf=1 m=1
M6 net3 VB3 net2 VDD pch l=0.15 w=1 nf=1 m=1
M7 net3 VC net9 VSS nch l=0.15 w=1 nf=1 m=1
M8 net9 VB2 VSS VSS nch l=0.15 w=1 nf=1 m=1
M9 net4 net3 VDD VDD pch l=0.15 w=1 nf=1 m=1
.ends comparator

.subckt dut VDD VSS VSTO VCONT1 VCONT2 VCONT3 VOUT VB1 VB2 VB3
CL VOUT VSS 1p
CSTO VSTO VSS 1p
LRX net0 net1 1n
MN1 net0 VCONT2 VSS VSS nch l=0.15 w=1 nf=1 m=1
MN2 net1 VCONT3 VSS VSS nch l=0.15 w=1 nf=1 m=1
MP2 net1 net2 VOUT VOUT pch l=0.15 w=1 nf=1 m=1
MP3 net0 VCONT1 VSTO VSTO pch l=0.15 w=1 nf=1 m=1
X1 VDD VSS VB1 VB3 VB2 net2 net1 comparator
.ends dut
