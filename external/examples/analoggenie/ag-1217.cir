* official Analog Canvas netlist; PDK X cards rewritten by convert.py
.model nch nmos
.model pch pmos

.subckt dut VDD VSS VIN VCONT1 VCONT2 VCONT3 VCONT4 VCONT5 VP VB5 VB1 VB2
.model DIODE D(IS=1e-14 N=1)
C1 VX1 VX2 1p
C2 VP VN 1p
C3 VP VSS 1p
D1 VN VX2 DIODE
L1 VX1 VX3 1n
M1 net4 VCONT1 VIN VDD pch l=0.15 w=1 nf=1 m=1
M10 VM VM VSS VSS nch l=0.15 w=1 nf=1 m=1
M11 VM VB5 VSS VSS nch l=0.15 w=1 nf=1 m=1
M12 net3 VB1 VDD VDD pch l=0.15 w=1 nf=1 m=1
M13 net0 VB1 VDD VDD pch l=0.15 w=1 nf=1 m=1
M14 net1 VB2 net3 VDD pch l=0.15 w=1 nf=1 m=1
M15 VCTRL VB2 net0 VDD pch l=0.15 w=1 nf=1 m=1
M16 net1 VB6 VM VSS nch l=0.15 w=1 nf=1 m=1
M17 VCTRL VB6 net6 VSS nch l=0.15 w=1 nf=1 m=1
M18 VM net1 VSS VSS nch l=0.15 w=1 nf=1 m=1
M19 net6 net1 VSS VSS nch l=0.15 w=1 nf=1 m=1
M2 VX1 VCONT2 VIN VDD pch l=0.15 w=1 nf=1 m=1
M20 net3 VFP1 net8 VSS nch l=0.15 w=1 nf=1 m=1
M21 net0 VREF net8 VSS nch l=0.15 w=1 nf=1 m=1
M22 net8 VB7 VSS VSS nch l=0.15 w=1 nf=1 m=1
M23 VBP VBP VDD VDD pch l=0.15 w=1 nf=1 m=1
M24 net7 VBP VDD VDD pch l=0.15 w=1 nf=1 m=1
M25 VX2 VBP VDD VDD pch l=0.15 w=1 nf=1 m=1
M26 VB6 VBP VDD VDD pch l=0.15 w=1 nf=1 m=1
M27 VBP net7 net5 VSS nch l=0.15 w=1 nf=1 m=1
M28 net5 VX2 VSS VSS nch l=0.15 w=1 nf=1 m=1
M29 net7 net5 VSS VSS nch l=0.15 w=1 nf=1 m=1
M3 VX2 VCONT3 VIN VDD pch l=0.15 w=1 nf=1 m=1
M30 VX2 VX2 VSS VSS nch l=0.15 w=1 nf=1 m=1
M31 VB6 VB6 VB7 VSS nch l=0.15 w=1 nf=1 m=1
M32 VB7 VB7 VSS VSS nch l=0.15 w=1 nf=1 m=1
M4 VX3 VCONT4 VSS VSS nch l=0.15 w=1 nf=1 m=1
M5 VX3 VCONT5 VP VDD pch l=0.15 w=1 nf=1 m=1
M6 VX1 net2 net4 VDD pch l=0.15 w=1 nf=1 m=1
M7 net2 net2 net4 VDD pch l=0.15 w=1 nf=1 m=1
M8 VM VCTRL net4 VDD pch l=0.15 w=1 nf=1 m=1
M9 net2 VM VSS VSS nch l=0.15 w=1 nf=1 m=1
R1 VP VFP1 1k
R2 VFP1 VSS 1k
.ends dut
