* official Analog Canvas netlist; PDK X cards rewritten by convert.py
.model nch nmos
.model pch pmos

.subckt isr VDD VSS VREF VFP1 VS VX2 VB3 VG
MN1 VCTRL VREF net3 VSS nch l=0.15 w=1 nf=1 m=1
MN10 VX2 VS VSS VSS nch l=0.15 w=1 nf=1 m=1
MN11 VS VS VSS VSS nch l=0.15 w=1 nf=1 m=1
MN12 net0 net0 VSS VSS nch l=0.15 w=1 nf=1 m=1
MN2 net4 VFP1 net3 VSS nch l=0.15 w=1 nf=1 m=1
MN3 net2 net2 VSS VSS nch l=0.15 w=1 nf=1 m=1
MN4 net3 net2 VSS VSS nch l=0.15 w=1 nf=1 m=1
MN6 VG net1 VSS VSS nch l=0.15 w=1 nf=1 m=1
MN7 net1 net1 VSS VSS nch l=0.15 w=1 nf=1 m=1
MN8 net1 VB3 VSS VSS nch l=0.15 w=1 nf=1 m=1
MN9 VB4 net0 VX2 VSS nch l=0.15 w=1 nf=1 m=1
MP1 net4 net4 VDD VDD pch l=0.15 w=1 nf=1 m=1
MP10 net0 VB4 VDD VDD pch l=0.15 w=1 nf=1 m=1
MP2 VCTRL net4 VDD VDD pch l=0.15 w=1 nf=1 m=1
MP6 net1 VCTRL VS VDD pch l=0.15 w=1 nf=1 m=1
MP7 net2 VB4 VDD VDD pch l=0.15 w=1 nf=1 m=1
MP8 VB4 VB4 VDD VDD pch l=0.15 w=1 nf=1 m=1
MP9 VS VB4 VDD VDD pch l=0.15 w=1 nf=1 m=1
.ends isr

.subckt dut VDD VSS VCONT1 VCONT2 VCONT3 VIN VCONT5 VCONT4 VP VREF VB3
.model DIODE D(IS=1e-14 N=1)
CFLY VX1 VX2 1p
CO VP VN 1p
COP VP VSS 1p
D1 VN VX2 DIODE
L1 VX1 VX3 1n
M1 VS VCONT1 VIN VDD pch l=0.15 w=1 nf=1 m=1
M2 VX1 VCONT2 VIN VDD pch l=0.15 w=1 nf=1 m=1
M3 VX2 VCONT3 VIN VDD pch l=0.15 w=1 nf=1 m=1
M4 VP VCONT5 VX3 VDD pch l=0.15 w=1 nf=1 m=1
M5 VX3 VCONT4 VSS VSS nch l=0.15 w=1 nf=1 m=1
MP4 VG VG VS VDD pch l=0.15 w=1 nf=1 m=1
MP5 VX1 VG VS VDD pch l=0.15 w=1 nf=1 m=1
R1 VP VFP1 1k
R2 VFP1 VSS 1k
X1 VDD VSS VREF VFP1 VS VX2 VB3 VG isr
.ends dut
