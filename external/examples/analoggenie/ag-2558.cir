* official Analog Canvas netlist; PDK X cards rewritten by convert.py
.model nch nmos
.model pch pmos

.subckt AMP1 VDD VSS INN INP OUT
M10 net5 n4 VSS VSS nch l=0.15 w=1 nf=1 m=1
M11 n5 VBN net2 VSS nch l=0.15 w=1 nf=1 m=1
M12 net2 n5 VSS VSS nch l=0.15 w=1 nf=1 m=1
M13 net0 net4 VDD VDD pch l=0.15 w=1 nf=1 m=1
M14 net7 net4 VDD VDD pch l=0.15 w=1 nf=1 m=1
M15 net4 VB1 net0 VDD pch l=0.15 w=1 nf=1 m=1
M16 OUT VB1 net7 VDD pch l=0.15 w=1 nf=1 m=1
M17 net4 VBN net9 VSS nch l=0.15 w=1 nf=1 m=1
M18 OUT VBN net8 VSS nch l=0.15 w=1 nf=1 m=1
M19 net9 n5 VSS VSS nch l=0.15 w=1 nf=1 m=1
M20 net8 n4 VSS VSS nch l=0.15 w=1 nf=1 m=1
M21 net6 VP VDD VDD pch l=0.15 w=1 nf=1 m=1
M22 VP VP VDD VDD pch l=0.15 w=1 nf=1 m=1
M23 VB4 VP VDD VDD pch l=0.15 w=1 nf=1 m=1
M24 VBN VP VDD VDD pch l=0.15 w=1 nf=1 m=1
M25 VP VB4 VB3 VSS nch l=0.15 w=1 nf=1 m=1
M26 VBN VBN net3 VSS nch l=0.15 w=1 nf=1 m=1
M27 net6 net6 VSS VSS nch l=0.15 w=1 nf=1 m=1
M28 VB3 net6 VSS VSS nch l=0.15 w=1 nf=1 m=1
M29 VB4 VB3 VSS VSS nch l=0.15 w=1 nf=1 m=1
M30 net3 VBN VSS VSS nch l=0.15 w=1 nf=1 m=1
M6 net1 VB2 VDD VDD pch l=0.15 w=1 nf=1 m=1
M7 n4 INN net1 VDD pch l=0.15 w=1 nf=1 m=1
M8 n5 INP net1 VDD pch l=0.15 w=1 nf=1 m=1
M9 n4 VBN net5 VSS nch l=0.15 w=1 nf=1 m=1
.ends AMP1

.subckt dut VDD VSS biasp biascas biasn Vref Vout
C1 Vset VSS 1p
C2 n3 Vout 1p
M1 Vout n3 VDD VDD pch l=0.15 w=1 nf=1 m=1
M2 n1 Vset Vout VDD pch l=0.15 w=1 nf=1 m=1
M3 n1 biasn VSS VSS nch l=0.15 w=1 nf=1 m=1
M4 n3 biasp VDD VDD pch l=0.15 w=1 nf=1 m=1
M5 n3 biascas n1 VSS nch l=0.15 w=1 nf=1 m=1
R1 fb VSS 1k
R2 Vout fb 1k
X1 VDD VSS fb Vref Vset AMP1
.ends dut
