* official Analog Canvas netlist; PDK X cards rewritten by convert.py
.model nch nmos
.model pch pmos

.subckt Opamp VDD VSS INN INP OUT
M10 OUT VB3 net6 VDD pch l=0.15 w=1 nf=1 m=1
M11 OUT VB5 net8 VSS nch l=0.15 w=1 nf=1 m=1
M12 net8 VB2 VSS VSS nch l=0.15 w=1 nf=1 m=1
M13 VB5 net2 VDD VDD pch l=0.15 w=1 nf=1 m=1
M14 VB5 VB5 net5 VSS nch l=0.15 w=1 nf=1 m=1
M15 net5 VB5 VSS VSS nch l=0.15 w=1 nf=1 m=1
M16 net2 net2 VDD VDD pch l=0.15 w=1 nf=1 m=1
M17 VB4 net2 VDD VDD pch l=0.15 w=1 nf=1 m=1
M18 net2 VB4 VSS VSS nch l=0.15 w=1 nf=1 m=1
M19 VB4 VB4 VSS VSS nch l=0.15 w=1 nf=1 m=1
M2 net1 VB1 VDD VDD pch l=0.15 w=1 nf=1 m=1
M3 net8 INN net1 net7 pch l=0.15 w=1 nf=1 m=1
M4 net4 INP net1 net7 pch l=0.15 w=1 nf=1 m=1
M5 net0 net3 VDD VDD pch l=0.15 w=1 nf=1 m=1
M6 net3 VB3 net0 VDD pch l=0.15 w=1 nf=1 m=1
M7 net3 VB5 net4 VSS nch l=0.15 w=1 nf=1 m=1
M8 net4 VB2 VSS VSS nch l=0.15 w=1 nf=1 m=1
M9 net6 net3 VDD VDD pch l=0.15 w=1 nf=1 m=1
.ends Opamp

.subckt dut VDD VSS Vref VIN VOUT
CL VOUT net0 1p
M1 VIN net1 VOUT VOUT nch l=0.15 w=1 nf=1 m=1
R1 VOUT FB 1k
R2 FB VSS 1k
R3 net0 VSS 1k
X1 VDD VSS FB Vref net1 Opamp
.ends dut
