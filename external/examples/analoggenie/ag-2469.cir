* official Analog Canvas netlist; PDK X cards rewritten by convert.py
.model nch nmos
.model pch pmos

.subckt stage1 VDD VSS VIN VREF VFB VX2 VX1
M1 net6 VB1 VIN VDD pch l=0.15 w=1 nf=1 m=1
M11 net3 VC2 VSS VSS nch l=0.15 w=1 nf=1 m=1
M12 net6 VFB net3 VSS nch l=0.15 w=1 nf=1 m=1
M13 VX2 VREF net3 VSS nch l=0.15 w=1 nf=1 m=1
M2 VX2 VB1 VIN VDD pch l=0.15 w=1 nf=1 m=1
M3 VX1 VB2 net6 VDD pch l=0.15 w=1 nf=1 m=1
M4 net1 VB2 VX2 VDD pch l=0.15 w=1 nf=1 m=1
M5 VX1 VC1 net0 VSS nch l=0.15 w=1 nf=1 m=1
M6 net1 VC1 net4 VSS nch l=0.15 w=1 nf=1 m=1
M7 net0 net1 VSS VSS nch l=0.15 w=1 nf=1 m=1
M8 net4 net1 VSS VSS nch l=0.15 w=1 nf=1 m=1
MB1 VC1 VC1 VC2 VSS nch l=0.15 w=1 nf=1 m=1
MB2 VC2 VC2 VSS VSS nch l=0.15 w=1 nf=1 m=1
MB3 VC1 net2 VIN VDD pch l=0.15 w=1 nf=1 m=1
MB4 net2 net5 VSS VSS nch l=0.15 w=1 nf=1 m=1
MB5 net5 net5 VSS VSS nch l=0.15 w=1 nf=1 m=1
MB6 net2 net2 VIN VDD pch l=0.15 w=1 nf=1 m=1
MB7 net5 net2 VIN VDD pch l=0.15 w=1 nf=1 m=1
.ends stage1

.subckt dut VDD VSS VB4 VB5 VOUT VIN VREF
CF1 VOUT VFB 1p
Cm1 VOUT VX1 1p
Cm2 VX1 VX3 1p
M16 VX4 VB4 VIN VDD pch l=0.15 w=1 nf=1 m=1
M17 VX4 VX1 VSS VSS nch l=0.15 w=1 nf=1 m=1
M18 VX4 VX4 VSS VSS nch l=0.15 w=1 nf=1 m=1
M21 net3 VX1 VSS VSS nch l=0.15 w=1 nf=1 m=1
M22 net2 VX4 VSS VSS nch l=0.15 w=1 nf=1 m=1
M23 net3 net3 VIN VDD pch l=0.15 w=1 nf=1 m=1
M24 net2 net3 VIN VDD pch l=0.15 w=1 nf=1 m=1
MD1 VX3 VX1 VSS VSS nch l=0.15 w=1 nf=1 m=1
MD2 net1 VB5 VSS VSS nch l=0.15 w=1 nf=1 m=1
MD3 VX2 VX3 net1 VSS nch l=0.15 w=1 nf=1 m=1
MD4 net0 VB6 net1 VSS nch l=0.15 w=1 nf=1 m=1
MD5 VX3 net0 VIN VDD pch l=0.15 w=1 nf=1 m=1
MD6 net0 net0 VIN VDD pch l=0.15 w=1 nf=1 m=1
MD7 VX2 VX2 VIN VDD pch l=0.15 w=1 nf=1 m=1
MPT VOUT net2 VIN VDD pch l=0.15 w=1 nf=1 m=1
RF1 VOUT VFB 1k
RF2 VFB VSS 1k
X1 VDD VSS VIN VREF VFB VX2 VX1 stage1
.ends dut
