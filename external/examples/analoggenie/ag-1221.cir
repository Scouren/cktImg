* official Analog Canvas netlist; PDK X cards rewritten by convert.py
.model nch nmos
.model pch pmos

.subckt ea VDD VSS VFP1 VREF VS VG
MN1 net7 VFP1 net0 VSS nch l=0.15 w=1 nf=1 m=1
MN10 VG VD VSS VSS nch l=0.15 w=1 nf=1 m=1
MN11 VB5 VB5 net5 VSS nch l=0.15 w=1 nf=1 m=1
MN12 net5 VB5 VSS VSS nch l=0.15 w=1 nf=1 m=1
MN2 net6 VREF net0 VSS nch l=0.15 w=1 nf=1 m=1
MN3 net0 VB2 VSS VSS nch l=0.15 w=1 nf=1 m=1
MN4 net3 VB5 VD VSS nch l=0.15 w=1 nf=1 m=1
MN5 VCTRL VB5 net4 VSS nch l=0.15 w=1 nf=1 m=1
MN6 VD net3 VSS VSS nch l=0.15 w=1 nf=1 m=1
MN7 net4 net3 VSS VSS nch l=0.15 w=1 nf=1 m=1
MN8 VD VB4 VSS VSS nch l=0.15 w=1 nf=1 m=1
MN9 VD VD VSS VSS nch l=0.15 w=1 nf=1 m=1
MP1 net7 VB1 VDD VDD pch l=0.15 w=1 nf=1 m=1
MP2 net6 VB1 VDD VDD pch l=0.15 w=1 nf=1 m=1
MP3 net3 VB3 net7 VDD pch l=0.15 w=1 nf=1 m=1
MP4 VCTRL VB3 net6 VDD pch l=0.15 w=1 nf=1 m=1
MP5 VD VCTRL VS VDD pch l=0.15 w=1 nf=1 m=1
MP8 VB5 net2 VDD VDD pch l=0.15 w=1 nf=1 m=1
MP9 net2 net2 net1 VDD pch l=0.15 w=1 nf=1 m=1
RB1 VDD net1 1k
RB2 net2 VSS 1k
.ends ea

.subckt dut VDD VSS VIN VCONT1 VCONT2 VCONT3 VCONT4 VCONT5 VP VREF
.model DIODE D(IS=1e-14 N=1)
CFLY VX1 VX2 1p
CO VP VN 1p
COP VP VSS 1p
D1 VN VX2 DIODE
L1 VX1 VX3 1n
M1 VX1 VCONT2 VIN VDD pch l=0.15 w=1 nf=1 m=1
M2 VX2 VCONT3 VIN VDD pch l=0.15 w=1 nf=1 m=1
M3 VP VCONT5 VX3 VDD pch l=0.15 w=1 nf=1 m=1
M4 VX3 VCONT4 VSS VSS nch l=0.15 w=1 nf=1 m=1
M5 net0 VCONT1 VIN VDD pch l=0.15 w=1 nf=1 m=1
MP6 VG VG net0 VDD pch l=0.15 w=1 nf=1 m=1
MP7 VX1 VG net0 VDD pch l=0.15 w=1 nf=1 m=1
R1 VP VFP1 1k
R2 VFP1 VSS 1k
X1 VDD VSS VFP1 VREF net0 VG ea
.ends dut
