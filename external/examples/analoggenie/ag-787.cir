* official Analog Canvas netlist; PDK X cards rewritten by convert.py
.model nch nmos

.subckt opamp_differential VDD VSS VIP VIN VOP VON params: gain=1e6 vocm=0
VCM ncm 0 DC {vocm}
EPLUS VOP ncm VIP VIN {gain/2}
EMINUS VON ncm VIN VIP {gain/2}
.ends opamp_differential

.subckt dut VSS VC1 VC2 vi+ vi- vo+ vo-
C1 vo+ net1 1p
C2 vo- net3 1p
M1 net0 VC1 net1 VSS nch l=0.15 w=1 nf=1 m=1
M2 net0 VC2 VSS VSS nch l=0.15 w=1 nf=1 m=1
M3 net2 VC1 net3 VSS nch l=0.15 w=1 nf=1 m=1
M4 net2 VC2 VSS VSS nch l=0.15 w=1 nf=1 m=1
R1 net0 vi+ 1k
R2 vo+ net0 1k
R3 net2 vi- 1k
R4 vo- net2 1k
X1 0 VSS net3 net1 vo+ vo- opamp_differential gain=1e6
.ends dut
