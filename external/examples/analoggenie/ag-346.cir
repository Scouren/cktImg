* official Analog Canvas netlist; PDK X cards rewritten by convert.py
.model nch nmos
.model pch pmos

.subckt dut VDD VSS Vin Vout
CC net2 Vout 1p
I1 Vout VSS DC 1m
ISS net0 VSS DC 1m
M1 net2 Vin net0 VSS nch l=0.15 w=1 nf=1 m=1
M2 net1 Vout net0 VSS nch l=0.15 w=1 nf=1 m=1
M3 net2 net1 VDD VDD pch l=0.15 w=1 nf=1 m=1
M4 net1 net1 VDD VDD pch l=0.15 w=1 nf=1 m=1
M5 Vout net2 VDD VDD pch l=0.15 w=1 nf=1 m=1
.ends dut
