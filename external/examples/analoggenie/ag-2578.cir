* official Analog Canvas netlist; PDK X cards rewritten by convert.py
.model nch nmos
.model pch pmos

.subckt AMP1 VDD VSS INP INN OUT TAIL VB1 VB2
M10 VC VN2 net4 VSS nch l=0.15 w=1 nf=1 m=1
M11 net4 VN1 VSS VSS nch l=0.15 w=1 nf=1 m=1
M12 net6 VC VDD VDD pch l=0.15 w=1 nf=1 m=1
M13 OUT VB2 net6 VDD pch l=0.15 w=1 nf=1 m=1
M14 OUT VN2 net2 VSS nch l=0.15 w=1 nf=1 m=1
M15 net2 VN1 VSS VSS nch l=0.15 w=1 nf=1 m=1
M16 VN2 net5 VDD VDD pch l=0.15 w=1 nf=1 m=1
M17 net5 net5 VDD VDD pch l=0.15 w=1 nf=1 m=1
M18 net1 net5 VDD VDD pch l=0.15 w=1 nf=1 m=1
M19 net5 net1 VSS VSS nch l=0.15 w=1 nf=1 m=1
M20 net3 net1 VSS VSS nch l=0.15 w=1 nf=1 m=1
M21 VN2 VN2 VN1 VSS nch l=0.15 w=1 nf=1 m=1
M22 VN1 VN1 VSS VSS nch l=0.15 w=1 nf=1 m=1
M5 TAIL VB1 VDD VDD pch l=0.15 w=1 nf=1 m=1
M6 net4 INP TAIL VDD pch l=0.15 w=1 nf=1 m=1
M7 net2 INN TAIL VDD pch l=0.15 w=1 nf=1 m=1
M8 net0 VC VDD VDD pch l=0.15 w=1 nf=1 m=1
M9 VC VB2 net0 VDD pch l=0.15 w=1 nf=1 m=1
R3 net1 net3 1k
.ends AMP1

.subckt dut VDD VSS Vref biasp biascas biasn Vout VB1 VB2
C1 Vset VSS 1p
C2 n3 Vout 1p
M1 Vout n3 VDD VDD pch l=0.15 w=1 nf=1 m=1
M2 n1 Vset Vout VDD pch l=0.15 w=1 nf=1 m=1
M3 n1 biasn VSS VSS nch l=0.15 w=1 nf=1 m=1
M4 n3 biasp VDD VDD pch l=0.15 w=1 nf=1 m=1
M5 n3 biascas n1 VSS nch l=0.15 w=1 nf=1 m=1
R1 fb VSS 1k
R2 Vout fb 1k
X1 VDD VSS Vref fb Vset n3 VB1 VB2 AMP1
.ends dut
