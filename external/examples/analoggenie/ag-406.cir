* official Analog Canvas netlist; PDK X cards rewritten by convert.py
.model nch nmos

.subckt dut VDD VSS
ISS1 net6 VSS DC 1m
ISS2 net1 VSS DC 1m
ISS3 net2 VSS DC 1m
M1 X net5 net6 VSS nch l=0.15 w=1 nf=1 m=1
M2 Y net4 net6 VSS nch l=0.15 w=1 nf=1 m=1
M3 net0 Y net1 VSS nch l=0.15 w=1 nf=1 m=1
M4 net3 X net1 VSS nch l=0.15 w=1 nf=1 m=1
M5 net5 net3 net2 VSS nch l=0.15 w=1 nf=1 m=1
M6 net4 net0 net2 VSS nch l=0.15 w=1 nf=1 m=1
R1 VDD X 1k
R2 VDD Y 1k
R3 VDD net0 1k
R4 VDD net3 1k
R5 VDD net5 1k
R6 VDD net4 1k
.ends dut
