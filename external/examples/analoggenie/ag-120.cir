* official Analog Canvas netlist; PDK X cards rewritten by convert.py
.model nch nmos
.model pch pmos

.subckt dut VDD VSS Vin Vb Vout
M1 net0 Vin P VSS nch l=0.15 w=1 nf=1 m=1
M2 Vout Vout P VSS nch l=0.15 w=1 nf=1 m=1
M3 net0 net0 VDD VDD pch l=0.15 w=1 nf=1 m=1
M4 Vout net0 VDD VDD pch l=0.15 w=1 nf=1 m=1
M5 P Vb VSS VSS nch l=0.15 w=1 nf=1 m=1
.ends dut
