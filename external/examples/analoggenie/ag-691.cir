* official Analog Canvas netlist; PDK X cards rewritten by convert.py
.model nch nmos
.model pch pmos

.subckt dut VDD VSS Vin Vbias Vout
CL Vout VSS 1p
Ibias1 VDD net1 DC 1m
Ibias2 Vout VSS DC 1m
M1 net1 net0 VSS VSS nch l=0.15 w=1 nf=1 m=1
M2 Vout Vbias net1 VDD pch l=0.15 w=1 nf=1 m=1
Rs Vin net0 1k
.ends dut
