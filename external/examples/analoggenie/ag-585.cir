* official Analog Canvas netlist; PDK X cards rewritten by convert.py
.model nch nmos

.subckt dut VDD VSS Vin1 Vin2
C1 net0 net1 1p
L1 VDD net0 1n
M1 net0 Vin1 VSS VSS nch l=0.15 w=1 nf=1 m=1
M2 net0 Vin2 VSS VSS nch l=0.15 w=1 nf=1 m=1
RL net1 VSS 1k
.ends dut
