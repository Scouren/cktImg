* official Analog Canvas netlist; PDK X cards rewritten by convert.py
.model nch nmos
.model pch pmos
.model qpnp pnp

.subckt dut VDD VSS Vout VB1 VB2
M1 X VG VDD VDD pch l=0.15 w=1 nf=1 m=1
M10 net2 Y VE3 VDD pch l=0.15 w=1 nf=1 m=1
M11 net1 X VE3 VDD pch l=0.15 w=1 nf=1 m=1
M12 net5 VE4 VDD VDD pch l=0.15 w=1 nf=1 m=1
M13 VG VB2 net5 VDD pch l=0.15 w=1 nf=1 m=1
M14 VG VB4 net1 VSS nch l=0.15 w=1 nf=1 m=1
M15 net1 VB5 VSS VSS nch l=0.15 w=1 nf=1 m=1
M16 VB3 net3 VDD VDD pch l=0.15 w=1 nf=1 m=1
M17 net3 net3 VDD VDD pch l=0.15 w=1 nf=1 m=1
M18 VB4 net3 VDD VDD pch l=0.15 w=1 nf=1 m=1
M19 VB3 VB3 VSS VSS nch l=0.15 w=1 nf=1 m=1
M2 Vout VG VDD VDD pch l=0.15 w=1 nf=1 m=1
M20 net3 VB3 VSS VSS nch l=0.15 w=1 nf=1 m=1
M21 VB4 VB4 VB5 VSS nch l=0.15 w=1 nf=1 m=1
M22 VB5 VB5 VSS VSS nch l=0.15 w=1 nf=1 m=1
M3 net4 VG VDD VDD pch l=0.15 w=1 nf=1 m=1
M4 VE3 VG VDD VDD pch l=0.15 w=1 nf=1 m=1
M5 net0 VE4 VDD VDD pch l=0.15 w=1 nf=1 m=1
M6 VE4 VB2 net0 VDD pch l=0.15 w=1 nf=1 m=1
M7 VE4 VB4 net2 VSS nch l=0.15 w=1 nf=1 m=1
M8 net2 VB5 VSS VSS nch l=0.15 w=1 nf=1 m=1
M9 VE3 VB1 VDD VDD pch l=0.15 w=1 nf=1 m=1
Q1 VSS VSS net4 qpnp m=1
Q2 VSS net4 X qpnp m=1
Q3 VSS VSS VE3 qpnp m=1
Q4 VSS VE3 VE4 qpnp m=1
R1 Y VE4 1k
R2 Vout Y 1k
.ends dut
