* official Analog Canvas netlist; PDK X cards rewritten by convert.py
.model nch nmos
.model pch pmos

.subckt dut VDD VSS Vref VOUT VB1 VIN
CL VOUT VX 1p
M1 VX FB net4 VSS nch l=0.15 w=1 nf=1 m=1
M10 VB1 net3 VDD VDD pch l=0.15 w=1 nf=1 m=1
M11 net3 net3 VDD VDD pch l=0.15 w=1 nf=1 m=1
M12 VB2 net3 VDD VDD pch l=0.15 w=1 nf=1 m=1
M13 VB1 VB1 VSS VSS nch l=0.15 w=1 nf=1 m=1
M14 net3 VB1 VSS VSS nch l=0.15 w=1 nf=1 m=1
M15 VB2 VB2 VSS VSS nch l=0.15 w=1 nf=1 m=1
M2 net1 Vref net4 VSS nch l=0.15 w=1 nf=1 m=1
M3 VX VX VDD VDD pch l=0.15 w=1 nf=1 m=1
M4 net1 net1 VDD VDD pch l=0.15 w=1 nf=1 m=1
M5 net4 VB2 VSS VSS nch l=0.15 w=1 nf=1 m=1
M6 net0 VX VDD VDD pch l=0.15 w=1 nf=1 m=1
M7 net2 net1 VDD VDD pch l=0.15 w=1 nf=1 m=1
M8 net0 net0 VSS VSS nch l=0.15 w=1 nf=1 m=1
M9 net2 net0 VSS VSS nch l=0.15 w=1 nf=1 m=1
MNP VIN net2 VOUT VSS nch l=0.15 w=1 nf=1 m=1
R1 VOUT FB 1k
R2 FB VSS 1k
RESR VX VSS 1k
.ends dut
