* official Analog Canvas netlist; PDK X cards rewritten by convert.py
.model nch nmos
.model pch pmos

.subckt dut VDD VSS Vin Vb Vout
ISS net4 VSS DC 1m
M1 net3 Vin net4 VSS nch l=0.15 w=1 nf=1 m=1
M2 X Vout net4 VSS nch l=0.15 w=1 nf=1 m=1
M3 net1 Vb net3 VSS nch l=0.15 w=1 nf=1 m=1
M4 Vout Vb X VSS nch l=0.15 w=1 nf=1 m=1
M5 net1 net1 net2 VDD pch l=0.15 w=1 nf=1 m=1
M6 Vout net1 net0 VDD pch l=0.15 w=1 nf=1 m=1
M7 net2 net2 VDD VDD pch l=0.15 w=1 nf=1 m=1
M8 net0 net2 VDD VDD pch l=0.15 w=1 nf=1 m=1
.ends dut
