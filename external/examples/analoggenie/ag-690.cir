* official Analog Canvas netlist; PDK X cards rewritten by convert.py
.model nch nmos

.subckt dut VDD VSS Vin Vbias Vout
CL Vout VSS 1p
Ibias VDD Vout DC 1m
M1 net1 net0 VSS VSS nch l=0.15 w=1 nf=1 m=1
M2 Vout Vbias net1 VSS nch l=0.15 w=1 nf=1 m=1
Rs net0 Vin 1k
.ends dut
