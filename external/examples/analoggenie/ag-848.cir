* official Analog Canvas netlist; PDK X cards rewritten by convert.py
.model nch nmos
.model pch pmos

.subckt dut VDD VSS vi1 vi2 vo
IBIAS VDD net2 DC 1m
M1 net0 vi1 net1 VSS nch l=0.15 w=1 nf=1 m=1
M2 vo vi2 net1 VSS nch l=0.15 w=1 nf=1 m=1
M3 net0 net0 VDD VDD pch l=0.15 w=1 nf=1 m=1
M4 vo net0 VDD VDD pch l=0.15 w=1 nf=1 m=1
M5 net1 net2 VSS VSS nch l=0.15 w=1 nf=1 m=1
M6 net2 net2 VSS VSS nch l=0.15 w=1 nf=1 m=1
.ends dut
