* official Analog Canvas netlist; PDK X cards rewritten by convert.py
.model nch nmos
.model pch pmos

.subckt dut VDD VSS Vin1 Vin2 Vout1 Vout2 Vb4 Vb5 Vb3 Vb2 Vb1
CL1 Vout1 VSS 1p
CL2 Vout2 VSS 1p
ISS net0 VSS DC 1m
M1 X Vin1 net0 VSS nch l=0.15 w=1 nf=1 m=1
M10 Vout2 F VDD VDD pch l=0.15 w=1 nf=1 m=1
M11 Vout1 Vb4 VSS VSS nch l=0.15 w=1 nf=1 m=1
M12 Vout2 Vb5 VSS VSS nch l=0.15 w=1 nf=1 m=1
M2 Y Vin2 net0 VSS nch l=0.15 w=1 nf=1 m=1
M3 E Vb1 X VSS nch l=0.15 w=1 nf=1 m=1
M4 F Vb1 Y VSS nch l=0.15 w=1 nf=1 m=1
M5 E Vb2 net1 VDD pch l=0.15 w=1 nf=1 m=1
M6 F Vb2 net2 VDD pch l=0.15 w=1 nf=1 m=1
M7 net1 Vb3 VDD VDD pch l=0.15 w=1 nf=1 m=1
M8 net2 Vb3 VDD VDD pch l=0.15 w=1 nf=1 m=1
M9 Vout1 E VDD VDD pch l=0.15 w=1 nf=1 m=1
.ends dut
