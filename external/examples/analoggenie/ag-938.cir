* official Analog Canvas netlist; PDK X cards rewritten by convert.py
.model qpnp pnp

.subckt dut VDD VSS VREF
Q1 VSS net0 VREF qpnp m=1
R VDD VREF 1k
R1 VREF net0 1k
R2 net0 VSS 1k
.ends dut
