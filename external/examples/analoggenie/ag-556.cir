* official Analog Canvas netlist; PDK X cards rewritten by convert.py
.model nch nmos

.subckt dut VDD VSS A B Vb X Y
ISS1 net0 VSS DC 1m
M1 X A net0 VSS nch l=0.15 w=1 nf=1 m=1
M2 X B net0 VSS nch l=0.15 w=1 nf=1 m=1
M3 Y Vb net0 VSS nch l=0.15 w=1 nf=1 m=1
RD1 VDD X 1k
RD2 VDD Y 1k
.ends dut
