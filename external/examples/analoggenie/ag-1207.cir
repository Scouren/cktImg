* official Analog Canvas netlist; PDK X cards rewritten by convert.py
.model nch nmos
.model pch pmos

.subckt dut VDD VSS VIN VP VC1 VC2 VC3 VC5 VC4 VB1 VB2 VREF VB4 VB3
.model DIODE D(IS=1e-14 N=1)
CFLY VX1 VX2 1p
CO VP VN 1p
COP VP VSS 1p
D1 VN VX2 DIODE
L1 VX1 VX3 1n
M1 VX1 VC2 VIN VDD pch l=0.15 w=1 nf=1 m=1
M10 net3 net6 VDD VDD pch l=0.15 w=1 nf=1 m=1
M11 VCTRL VB1 net3 VDD pch l=0.15 w=1 nf=1 m=1
M12 VCTRL VB5 net5 VSS nch l=0.15 w=1 nf=1 m=1
M13 net5 V1 VSS VSS nch l=0.15 w=1 nf=1 m=1
M14 net9 VB2 VDD VDD pch l=0.15 w=1 nf=1 m=1
M15 V2 VREF net9 VDD pch l=0.15 w=1 nf=1 m=1
M16 V1 VFP1 net9 VDD pch l=0.15 w=1 nf=1 m=1
M17 V2 VB5 net2 VSS nch l=0.15 w=1 nf=1 m=1
M18 net2 V2 VSS VSS nch l=0.15 w=1 nf=1 m=1
M19 V1 VB5 VX1 VSS nch l=0.15 w=1 nf=1 m=1
M2 VX2 VC3 VIN VDD pch l=0.15 w=1 nf=1 m=1
M20 VX1 V1 VSS VSS nch l=0.15 w=1 nf=1 m=1
M21 net1 VCTRL VS VDD pch l=0.15 w=1 nf=1 m=1
M22 net1 VB4 VSS VSS nch l=0.15 w=1 nf=1 m=1
M23 net1 net1 VSS VSS nch l=0.15 w=1 nf=1 m=1
M24 net0 net0 VS VDD pch l=0.15 w=1 nf=1 m=1
M25 VX1 net0 VS VDD pch l=0.15 w=1 nf=1 m=1
M26 net0 net1 VSS VSS nch l=0.15 w=1 nf=1 m=1
M27 VBP VBP VDD VDD pch l=0.15 w=1 nf=1 m=1
M28 VB3 VBP VDD VDD pch l=0.15 w=1 nf=1 m=1
M29 VS VBP VDD VDD pch l=0.15 w=1 nf=1 m=1
M3 VP VC5 VX3 VDD pch l=0.15 w=1 nf=1 m=1
M30 VB5 VBP VDD VDD pch l=0.15 w=1 nf=1 m=1
M31 VBP VB3 VX2 VSS nch l=0.15 w=1 nf=1 m=1
M32 VX2 VS VSS VSS nch l=0.15 w=1 nf=1 m=1
M33 VB3 VB3 VSS VSS nch l=0.15 w=1 nf=1 m=1
M34 VS VS VSS VSS nch l=0.15 w=1 nf=1 m=1
M35 VB5 VB5 net8 VSS nch l=0.15 w=1 nf=1 m=1
M36 net8 VB5 VSS VSS nch l=0.15 w=1 nf=1 m=1
M4 VX3 VC4 VSS VSS nch l=0.15 w=1 nf=1 m=1
M5 VS VC1 VIN VDD pch l=0.15 w=1 nf=1 m=1
M6 net4 net6 VDD VDD pch l=0.15 w=1 nf=1 m=1
M7 net6 VB1 net4 VDD pch l=0.15 w=1 nf=1 m=1
M8 net6 VB5 net7 VSS nch l=0.15 w=1 nf=1 m=1
M9 net7 V2 VSS VSS nch l=0.15 w=1 nf=1 m=1
R1 VP VFP1 1k
R2 VFP1 VSS 1k
.ends dut
