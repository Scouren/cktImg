* official Analog Canvas netlist; PDK X cards rewritten by convert.py
.model nch nmos
.model pch pmos

.subckt comparator VDD VSS INN OUT
M1 net0 INN net1 VSS nch l=0.15 w=1 nf=1 m=1
M10 OUT net2 VSS VSS nch l=0.15 w=1 nf=1 m=1
M11 VB2 VB2 VDD VDD pch l=0.15 w=1 nf=1 m=1
M12 net4 VB2 VDD VDD pch l=0.15 w=1 nf=1 m=1
M13 VB2 net4 VSS VSS nch l=0.15 w=1 nf=1 m=1
M14 net4 net4 VSS VSS nch l=0.15 w=1 nf=1 m=1
M15 net3 net3 VDD VDD pch l=0.15 w=1 nf=1 m=1
M16 VB3 net3 VDD VDD pch l=0.15 w=1 nf=1 m=1
M17 net3 net4 VSS VSS nch l=0.15 w=1 nf=1 m=1
M18 VB3 VB3 VSS VSS nch l=0.15 w=1 nf=1 m=1
M19 VB1 VB1 VDD VDD pch l=0.15 w=1 nf=1 m=1
M2 OUT OUT net1 VSS nch l=0.15 w=1 nf=1 m=1
M20 VB1 VB3 VSS VSS nch l=0.15 w=1 nf=1 m=1
M3 net1 VB3 VSS VSS nch l=0.15 w=1 nf=1 m=1
M5 net0 net0 VDD VDD pch l=0.15 w=1 nf=1 m=1
M6 net2 net0 VDD VDD pch l=0.15 w=1 nf=1 m=1
M7 OUT OUT VDD VDD pch l=0.15 w=1 nf=1 m=1
M8 OUT OUT VDD VDD pch l=0.15 w=1 nf=1 m=1
M9 net2 net2 VSS VSS nch l=0.15 w=1 nf=1 m=1
.ends comparator

.subckt dut VDD VSS VSTO VCONT1 VCONT2 VCONT3 VOUT
CL VOUT VSS 1p
CSTO VSTO VSS 1p
LRX net1 net2 1n
MN1 net1 VCONT2 VSS VSS nch l=0.15 w=1 nf=1 m=1
MN2 net2 VCONT3 VSS VSS nch l=0.15 w=1 nf=1 m=1
MP2 net2 net0 VOUT VDD pch l=0.15 w=1 nf=1 m=1
MP3 net1 VCONT1 VSTO VDD pch l=0.15 w=1 nf=1 m=1
X1 VDD VSS net2 net0 comparator
.ends dut
