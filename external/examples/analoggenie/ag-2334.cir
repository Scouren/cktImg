* official Analog Canvas netlist; PDK X cards rewritten by convert.py
.model nch nmos
.model pch pmos

.subckt dut VDD VSS VREF VB4 IBUF VIN VOUT
CL VOUT net4 1p
M1 VB2 VB2 VSS VSS nch l=0.15 w=1 nf=1 m=1
M10 EAO net0 VDD VDD pch l=0.15 w=1 nf=1 m=1
M11 net1 net1 VDD VDD pch l=0.15 w=1 nf=1 m=1
M12 net0 net0 VDD VDD pch l=0.15 w=1 nf=1 m=1
M13 net6 VB4 VDD VDD pch l=0.15 w=1 nf=1 m=1
M14 VX EAO net6 VDD pch l=0.15 w=1 nf=1 m=1
M15 VX VX VSS VSS nch l=0.15 w=1 nf=1 m=1
M16 GATE VX VSS VSS nch l=0.15 w=1 nf=1 m=1
M17 VDD net6 GATE VSS nch l=0.15 w=1 nf=1 m=1
M18 net5 EAO IBUF IBUF nch l=0.15 w=1 nf=1 m=1
M19 net5 net5 VDD VDD pch l=0.15 w=1 nf=1 m=1
M2 VX VB2 VSS VSS nch l=0.15 w=1 nf=1 m=1
M20 GATE net5 VDD VDD pch l=0.15 w=1 nf=1 m=1
M21 VSS IBUF GATE VSS pch l=0.15 w=1 nf=1 m=1
M22 VB2 VB1 VDD VDD pch l=0.15 w=1 nf=1 m=1
M23 VB1 VB1 VDD VDD pch l=0.15 w=1 nf=1 m=1
M24 VB1 net2 VSS VSS nch l=0.15 w=1 nf=1 m=1
M25 net2 net3 VDD VDD pch l=0.15 w=1 nf=1 m=1
M26 net2 net2 VSS VSS nch l=0.15 w=1 nf=1 m=1
M27 net3 net3 VDD VDD pch l=0.15 w=1 nf=1 m=1
M28 net3 net2 VSS VSS nch l=0.15 w=1 nf=1 m=1
M3 net0 VREF VX VSS nch l=0.15 w=1 nf=1 m=1
M4 net1 FB VX VSS nch l=0.15 w=1 nf=1 m=1
M7 net3 net3 VSS VSS nch l=0.15 w=1 nf=1 m=1
M8 EAO net3 VSS VSS nch l=0.15 w=1 nf=1 m=1
M9 net3 net1 VDD VDD pch l=0.15 w=1 nf=1 m=1
MNP VIN GATE VOUT VOUT nch l=0.15 w=1 nf=1 m=1
R1 FB VSS 1k
R2 VOUT FB 1k
R3 VDD net2 1k
R4 net4 VSS 1k
RL VOUT VSS 1k
.ends dut
