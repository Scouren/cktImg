* official Analog Canvas netlist; PDK X cards rewritten by convert.py
.model nch nmos

.subckt dut VDD VSS VLO VLO_bar Vout+ Vout-
ISS net0 VSS DC 1m
L1 VDD Vout+ 1n
L2 VDD Vout- 1n
M2 Vout+ VLO net0 VSS nch l=0.15 w=1 nf=1 m=1
M3 Vout- VLO_bar net0 VSS nch l=0.15 w=1 nf=1 m=1
R1 VDD Vout+ 1k
R2 VDD Vout- 1k
.ends dut
