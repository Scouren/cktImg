* official Analog Canvas netlist; PDK X cards rewritten by convert.py
.model nch nmos
.model pch pmos
.model qpnp pnp

.subckt dut VDD VSS Vout VB1 VB3
M1 X VG VDD VDD pch l=0.15 w=1 nf=1 m=1
M10 VG VB3 net0 VDD pch l=0.15 w=1 nf=1 m=1
M11 VG VB4 net3 VSS nch l=0.15 w=1 nf=1 m=1
M12 net3 Z VSS VSS nch l=0.15 w=1 nf=1 m=1
M13 net6 X Y VSS nch l=0.15 w=1 nf=1 m=1
M14 net0 Y Y VSS nch l=0.15 w=1 nf=1 m=1
M15 Y VB2 VSS VSS nch l=0.15 w=1 nf=1 m=1
M16 VB4 net4 VDD VDD pch l=0.15 w=1 nf=1 m=1
M17 VB4 VB4 net5 VSS nch l=0.15 w=1 nf=1 m=1
M18 net5 VB4 VSS VSS nch l=0.15 w=1 nf=1 m=1
M19 net4 net4 X VDD pch l=0.15 w=1 nf=1 m=1
M2 Vout VG VDD VDD pch l=0.15 w=1 nf=1 m=1
M3 net2 VG VDD VDD pch l=0.15 w=1 nf=1 m=1
M4 Z VG VDD VDD pch l=0.15 w=1 nf=1 m=1
M5 net6 VB1 VDD VDD pch l=0.15 w=1 nf=1 m=1
M6 Z VB3 net6 VDD pch l=0.15 w=1 nf=1 m=1
M7 Z VB4 net1 VSS nch l=0.15 w=1 nf=1 m=1
M8 net1 Z VSS VSS nch l=0.15 w=1 nf=1 m=1
M9 net0 VB1 VDD VDD pch l=0.15 w=1 nf=1 m=1
Q1 VSS VSS net2 qpnp m=1
Q2 VSS net2 X qpnp m=1
Q3 VSS VSS Z qpnp m=1
Q4 VSS Z net7 qpnp m=1
R1 Y net7 1k
R2 Vout Y 1k
R3 net4 VSS 1k
R4 VDD X 1k
.ends dut
