* official Analog Canvas netlist; PDK X cards rewritten by convert.py
.model nch nmos
.model pch pmos
.model qnpn npn

.subckt dut VDD VSS Vout1 Vout2
M3 net3 net0 VDD VDD pch l=0.15 w=1 nf=1 m=1
M4 net0 net0 VDD VDD pch l=0.15 w=1 nf=1 m=1
M5 Vout1 net0 VDD VDD pch l=0.15 w=1 nf=1 m=1
M6 IVBE net3 VSS VSS nch l=0.15 w=1 nf=1 m=1
M7 IVBE IVBE VDD VDD pch l=0.15 w=1 nf=1 m=1
M8 net1 IVBE VDD VDD pch l=0.15 w=1 nf=1 m=1
M9 Vout2 IVBE VDD VDD pch l=0.15 w=1 nf=1 m=1
Q1 net3 net1 VSS VSS qnpn m=1
Q2 net0 net1 net2 VSS qnpn m=1
R1 net2 VSS 1k
R2 Vout1 VSS 1k
R3 net1 VSS 1k
R4 Vout2 VSS 1k
.ends dut
