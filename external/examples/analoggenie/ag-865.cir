* official Analog Canvas netlist; PDK X cards rewritten by convert.py
.model nch nmos
.model pch pmos

.subckt dut VDD VSS IOUT1 IOUT2
IIN VDD net3 DC 1m
M1 net3 net3 VSS VSS nch l=0.15 w=1 nf=1 m=1
M10 net4 net4 VSS VSS nch l=0.15 w=1 nf=1 m=1
M11 IOUT2 net4 VSS VSS nch l=0.15 w=1 nf=1 m=1
M2 net1 net3 VSS VSS nch l=0.15 w=1 nf=1 m=1
M3 net0 net3 VSS VSS nch l=0.15 w=1 nf=1 m=1
M4 net1 net1 VDD VDD pch l=0.15 w=1 nf=1 m=1
M5 net2 net1 VDD VDD pch l=0.15 w=1 nf=1 m=1
M6 net2 net2 VSS VSS nch l=0.15 w=1 nf=1 m=1
M7 IOUT1 net2 VSS VSS nch l=0.15 w=1 nf=1 m=1
M8 net0 net0 VDD VDD pch l=0.15 w=1 nf=1 m=1
M9 net4 net0 VDD VDD pch l=0.15 w=1 nf=1 m=1
.ends dut
