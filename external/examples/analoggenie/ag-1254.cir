* official Analog Canvas netlist; PDK X cards rewritten by convert.py
.model nch nmos
.model pch pmos

.subckt ISR VDD VSS VS VB2 VCTRL IOUT
M1 net1 VCTRL VS VDD pch l=0.15 w=1 nf=1 m=1
M2 net0 net0 VS VDD pch l=0.15 w=1 nf=1 m=1
M3 IOUT net0 VS VDD pch l=0.15 w=1 nf=1 m=1
M4 net1 VB2 VSS VSS nch l=0.15 w=1 nf=1 m=1
M5 net1 net1 VSS VSS nch l=0.15 w=1 nf=1 m=1
M6 net0 net1 VSS VSS nch l=0.15 w=1 nf=1 m=1
.ends ISR

.subckt EA VDD VSS INN INP VCTRL VX3
M1 VB4 net1 VDD VDD pch l=0.15 w=1 nf=1 m=1
M10 VB4 VB4 VDD VDD pch l=0.15 w=1 nf=1 m=1
M11 net0 VB4 VDD VDD pch l=0.15 w=1 nf=1 m=1
M12 VB1 VB1 VDD VDD pch l=0.15 w=1 nf=1 m=1
M13 VB3 VB1 VDD VDD pch l=0.15 w=1 nf=1 m=1
M14 VB4 net0 VSS VSS nch l=0.15 w=1 nf=1 m=1
M15 net0 net0 VSS VSS nch l=0.15 w=1 nf=1 m=1
M16 VB1 net0 VSS VSS nch l=0.15 w=1 nf=1 m=1
M17 VB3 VB3 VSS VSS nch l=0.15 w=1 nf=1 m=1
M2 net1 net1 VDD VDD pch l=0.15 w=1 nf=1 m=1
M3 VX3 VX3 VDD VDD pch l=0.15 w=1 nf=1 m=1
M4 VCTRL VX3 VDD VDD pch l=0.15 w=1 nf=1 m=1
M5 net1 INN net2 VSS nch l=0.15 w=1 nf=1 m=1
M6 VX3 INP net2 VSS nch l=0.15 w=1 nf=1 m=1
M7 net2 VB3 VSS VSS nch l=0.15 w=1 nf=1 m=1
M8 VB4 VB4 VSS VSS nch l=0.15 w=1 nf=1 m=1
M9 VCTRL VB4 VSS VSS nch l=0.15 w=1 nf=1 m=1
R1 VDD net0 1k
.ends EA

.subckt dut VDD VSS VIN VS5 VS1 VS2 VS4 VS3 VP VB2 VREF
.model DIODE D(IS=1e-14 N=1)
CFLY VX1 VX2 1p
CO VP VN 1p
COP VP VSS 1p
D1 VN VX2 DIODE
L1 VX1 VX3 1n
M1 net1 VS5 VIN VDD pch l=0.15 w=1 nf=1 m=1
M2 VX1 VS1 VIN VDD pch l=0.15 w=1 nf=1 m=1
M3 VX2 VS2 VIN VDD pch l=0.15 w=1 nf=1 m=1
M4 VX3 VS4 VSS VSS nch l=0.15 w=1 nf=1 m=1
M5 VX3 VS3 VP VDD pch l=0.15 w=1 nf=1 m=1
R1 VP VFP1 1k
R2 VFP1 VSS 1k
X1 VDD VSS net1 VB2 net0 VX1 ISR
X2 VDD VSS VFP1 VREF net0 VX3 EA
.ends dut
