* official Analog Canvas netlist; PDK X cards rewritten by convert.py
.model nch nmos
.model pch pmos

.subckt dut VDD VSS VIN VOUT VERR nb pb VB1 VREF VB2
M1 VA VEAOUT VIN VDD pch l=0.15 w=1 nf=1 m=1
M11 VCTRL VB1 VDD VDD pch l=0.15 w=1 nf=1 m=1
M12 VA VREF VCTRL VDD pch l=0.15 w=1 nf=1 m=1
M13 VS VEAOUT VCTRL VDD pch l=0.15 w=1 nf=1 m=1
M14 VG VX VDD VDD pch l=0.15 w=1 nf=1 m=1
M15 VX VB2 VG VDD pch l=0.15 w=1 nf=1 m=1
M16 VX VY VA VSS nch l=0.15 w=1 nf=1 m=1
M17 VA VZ VSS VSS nch l=0.15 w=1 nf=1 m=1
M18 net1 VX VDD VDD pch l=0.15 w=1 nf=1 m=1
M19 VEAOUT VB2 net1 VDD pch l=0.15 w=1 nf=1 m=1
M2 VCTRL VCTRL VA VDD pch l=0.15 w=1 nf=1 m=1
M20 VEAOUT VY VS VSS nch l=0.15 w=1 nf=1 m=1
M21 VS VZ VSS VSS nch l=0.15 w=1 nf=1 m=1
M22 VY net2 VDD VDD pch l=0.15 w=1 nf=1 m=1
M23 VY VY VZ VSS nch l=0.15 w=1 nf=1 m=1
M24 VZ VZ VSS VSS nch l=0.15 w=1 nf=1 m=1
M25 net2 net2 VDD VDD pch l=0.15 w=1 nf=1 m=1
M26 net0 net2 VDD VDD pch l=0.15 w=1 nf=1 m=1
M27 net2 net0 VSS VSS nch l=0.15 w=1 nf=1 m=1
M28 net3 net0 VSS VSS nch l=0.15 w=1 nf=1 m=1
M3 VCTRL nb VSS VSS nch l=0.15 w=1 nf=1 m=1
MBIAS VERR nb VSS VSS nch l=0.15 w=1 nf=1 m=1
MCHG VS pb VIN VDD pch l=0.15 w=1 nf=1 m=1
MCTRL VERR VCTRL VOUT VDD pch l=0.15 w=1 nf=1 m=1
MGEN VG VG VSS VSS nch l=0.15 w=1 nf=1 m=1
MINJ VERR VG VSS VSS nch l=0.15 w=1 nf=1 m=1
MRES VOUT VERR VIN VDD pch l=0.15 w=1 nf=1 m=1
MSEN VG VEAOUT VS VDD pch l=0.15 w=1 nf=1 m=1
R1 net0 net3 1k
.ends dut
