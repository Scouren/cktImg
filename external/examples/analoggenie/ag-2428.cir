* official Analog Canvas netlist; PDK X cards rewritten by convert.py
.model nch nmos
.model pch pmos

.subckt AEA VDD VSS VREF OUT VB1
M11 net0 net0 VDD VDD pch l=0.15 w=1 nf=1 m=1
M12 OUT net0 VDD VDD pch l=0.15 w=1 nf=1 m=1
M13 OUT net3 VDD VDD pch l=0.15 w=1 nf=1 m=1
M14 net3 net3 VDD VDD pch l=0.15 w=1 nf=1 m=1
M15 OUT OUT VSS VSS nch l=0.15 w=1 nf=1 m=1
M16 OUT OUT VSS VSS nch l=0.15 w=1 nf=1 m=1
M17 net0 VREF net1 VSS nch l=0.15 w=1 nf=1 m=1
M18 net3 OUT net1 VSS nch l=0.15 w=1 nf=1 m=1
M19 net1 VBN VSS VSS nch l=0.15 w=1 nf=1 m=1
M20 VBN VB1 VDD VDD pch l=0.15 w=1 nf=1 m=1
M21 VB1 VB1 VDD VDD pch l=0.15 w=1 nf=1 m=1
M22 VBN VBN VSS VSS nch l=0.15 w=1 nf=1 m=1
M23 VB1 net2 VSS VSS nch l=0.15 w=1 nf=1 m=1
M24 net2 net2 VSS VSS nch l=0.15 w=1 nf=1 m=1
R1 VDD net2 1k
.ends AEA

.subckt dut VDD VSS VIN pb nb VOUT VERR VREF VB1
M1 net2 VEAOUT VIN VDD pch l=0.15 w=1 nf=1 m=1
M10 VERR nb VSS VSS nch l=0.15 w=1 nf=1 m=1
M2 net1 net1 net2 VDD pch l=0.15 w=1 nf=1 m=1
M3 net1 nb VSS VSS nch l=0.15 w=1 nf=1 m=1
M4 net0 pb VIN VDD pch l=0.15 w=1 nf=1 m=1
M5 net3 VEAOUT net0 VDD pch l=0.15 w=1 nf=1 m=1
M6 net3 net3 VSS VSS nch l=0.15 w=1 nf=1 m=1
M7 VERR net3 VSS VSS nch l=0.15 w=1 nf=1 m=1
M8 VOUT VERR VIN VDD pch l=0.15 w=1 nf=1 m=1
M9 VERR net1 VOUT VDD pch l=0.15 w=1 nf=1 m=1
X1 VDD VSS VREF VEAOUT VB1 AEA
.ends dut
