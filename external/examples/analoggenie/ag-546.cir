* official Analog Canvas netlist; PDK X cards rewritten by convert.py
.model nch nmos

.subckt dut VDD VSS VOUT1 VOUT2 VCONT1
C1 net1 VSS 1p
C2 VCONT1 VSS 1p
ISS net0 VSS DC 1m
L1 VDD VOUT1 1n
L2 VDD VOUT2 1n
M1 VOUT1 VOUT2 net0 VSS nch l=0.15 w=1 nf=1 m=1
M2 VOUT2 VOUT1 net0 VSS nch l=0.15 w=1 nf=1 m=1
MV1 VCONT1 VOUT1 VCONT1 VSS nch l=0.15 w=1 nf=1 m=1
MV2 VCONT1 VOUT2 VCONT1 VSS nch l=0.15 w=1 nf=1 m=1
R1 VCONT1 net1 1k
.ends dut
