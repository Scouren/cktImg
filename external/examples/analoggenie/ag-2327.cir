* official Analog Canvas netlist; PDK X cards rewritten by convert.py
.model nch nmos
.model pch pmos

.subckt dut VDD VSS VREF VB1 IBUF VIN VOUT
CL VOUT net5 1p
M1 net3 net3 VDD VDD pch l=0.15 w=1 nf=1 m=1
M10 VB2 VB2 VSS VSS nch l=0.15 w=1 nf=1 m=1
M11 VB2 net6 VDD VDD pch l=0.15 w=1 nf=1 m=1
M12 net6 net6 VDD VDD pch l=0.15 w=1 nf=1 m=1
M13 net1 VB1 VDD VDD pch l=0.15 w=1 nf=1 m=1
M14 VX EAO net1 VDD pch l=0.15 w=1 nf=1 m=1
M15 VX VX VSS VSS nch l=0.15 w=1 nf=1 m=1
M16 GATE VX VSS VSS nch l=0.15 w=1 nf=1 m=1
M17 VDD net1 GATE VSS nch l=0.15 w=1 nf=1 m=1
M18 net4 EAO IBUF IBUF nch l=0.15 w=1 nf=1 m=1
M19 net4 net4 VDD VDD pch l=0.15 w=1 nf=1 m=1
M2 net2 net2 VDD VDD pch l=0.15 w=1 nf=1 m=1
M20 GATE net4 VDD VDD pch l=0.15 w=1 nf=1 m=1
M21 VSS IBUF GATE VSS pch l=0.15 w=1 nf=1 m=1
M22 VIN GATE VOUT VOUT nch l=0.15 w=1 nf=1 m=1
M3 net3 VREF VX VSS nch l=0.15 w=1 nf=1 m=1
M4 net2 FB VX VSS nch l=0.15 w=1 nf=1 m=1
M5 VX VB2 VSS VSS nch l=0.15 w=1 nf=1 m=1
M6 net0 net2 VDD VDD pch l=0.15 w=1 nf=1 m=1
M7 EAO net3 VDD VDD pch l=0.15 w=1 nf=1 m=1
M8 net0 net0 VSS VSS nch l=0.15 w=1 nf=1 m=1
M9 EAO net0 VSS VSS nch l=0.15 w=1 nf=1 m=1
R1 FB VSS 1k
R2 VOUT FB 1k
R3 net6 VSS 1k
R4 net5 VSS 1k
RL VOUT VSS 1k
.ends dut
