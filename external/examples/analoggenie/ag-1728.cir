* official Analog Canvas netlist; PDK X cards rewritten by convert.py
.model nch nmos
.model pch pmos
.model qpnp pnp

.subckt opamp VDD VSS INP INN OUT VB1
M1 net0 INP net4 VSS nch l=0.15 w=1 nf=1 m=1
M10 net1 net1 VSS VSS nch l=0.15 w=1 nf=1 m=1
M11 OUT net1 VSS VSS nch l=0.15 w=1 nf=1 m=1
M12 net2 net2 VDD VDD pch l=0.15 w=1 nf=1 m=1
M13 VB2 net2 VDD VDD pch l=0.15 w=1 nf=1 m=1
M14 VB1 VB1 VDD VDD pch l=0.15 w=1 nf=1 m=1
M15 VB2 VB2 VSS VSS nch l=0.15 w=1 nf=1 m=1
M16 VB1 VB2 VSS VSS nch l=0.15 w=1 nf=1 m=1
M2 net3 INN net4 VSS nch l=0.15 w=1 nf=1 m=1
M3 net0 net0 VDD VDD pch l=0.15 w=1 nf=1 m=1
M4 net3 net3 VDD VDD pch l=0.15 w=1 nf=1 m=1
M5 net4 VB2 VSS VSS nch l=0.15 w=1 nf=1 m=1
M8 net1 net0 VDD VDD pch l=0.15 w=1 nf=1 m=1
M9 OUT net3 VDD VDD pch l=0.15 w=1 nf=1 m=1
R4 net2 VSS 1k
.ends opamp

.subckt dut VDD VSS Vout VB1
Q1 VSS VSS net1 qpnp m=1
Q2 net1 net1 net0 qpnp m=1
Q3 VSS VSS net2 qpnp m=1
Q4 net2 net2 Y qpnp m=1
R1 Vout X 1k
R2 Vout Y 1k
R3 X net0 1k
X1 VDD VSS X Y Vout VB1 opamp
.ends dut
