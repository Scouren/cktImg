* official Analog Canvas netlist; PDK X cards rewritten by convert.py
.model nch nmos
.model pch pmos

.subckt dut VDD VSS VB1 VB3 VB2 VIN VB4 VB5 VOUT1 VOUT2 VREF
M1 VX VB1 VDD VDD pch l=0.15 w=1 nf=1 m=1
M10 VEA nb VF2 VSS nch l=0.15 w=1 nf=1 m=1
M11 VF2 VB2 VSS VSS nch l=0.15 w=1 nf=1 m=1
M12 nb net1 VDD VDD pch l=0.15 w=1 nf=1 m=1
M13 nb nb VEA VSS nch l=0.15 w=1 nf=1 m=1
M14 VEA nb VSS VSS nch l=0.15 w=1 nf=1 m=1
M15 net1 net1 VDD VDD pch l=0.15 w=1 nf=1 m=1
M16 VF1 VEA VIN VDD pch l=0.15 w=1 nf=1 m=1
M17 VX VX VF1 VDD pch l=0.15 w=1 nf=1 m=1
M18 VX VB4 VSS VSS nch l=0.15 w=1 nf=1 m=1
M19 VF2 VB5 VIN VDD pch l=0.15 w=1 nf=1 m=1
M2 VF1 VREF VX VDD pch l=0.15 w=1 nf=1 m=1
M20 VC VEA VF2 VDD pch l=0.15 w=1 nf=1 m=1
M21 VC VC VSS VSS nch l=0.15 w=1 nf=1 m=1
M22 VOUT1 VOUT2 VIN VDD pch l=0.15 w=1 nf=1 m=1
M23 VOUT2 VX VOUT1 VDD pch l=0.15 w=1 nf=1 m=1
M24 VOUT2 VC VSS VSS nch l=0.15 w=1 nf=1 m=1
M25 VOUT2 VB4 VSS VSS nch l=0.15 w=1 nf=1 m=1
M3 VF2 VEA VX VDD pch l=0.15 w=1 nf=1 m=1
M4 VC net0 VDD VDD pch l=0.15 w=1 nf=1 m=1
M5 net0 VB3 VC VDD pch l=0.15 w=1 nf=1 m=1
M6 net0 nb VF1 VSS nch l=0.15 w=1 nf=1 m=1
M7 VF1 VB2 VSS VSS nch l=0.15 w=1 nf=1 m=1
M8 net2 net0 VDD VDD pch l=0.15 w=1 nf=1 m=1
M9 VEA VB3 net2 VDD pch l=0.15 w=1 nf=1 m=1
R1 net1 VSS 1k
.ends dut
