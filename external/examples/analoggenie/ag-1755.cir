* official Analog Canvas netlist; PDK X cards rewritten by convert.py
.model nch nmos
.model pch pmos
.model qpnp pnp

.subckt opamp VDD VSS X Y VZ VG
M10 VG VB5 net2 VSS nch l=0.15 w=1 nf=1 m=1
M11 net6 VZ VSS VSS nch l=0.15 w=1 nf=1 m=1
M12 net2 VZ VSS VSS nch l=0.15 w=1 nf=1 m=1
M13 net5 X Y VSS nch l=0.15 w=1 nf=1 m=1
M14 net3 Y Y VSS nch l=0.15 w=1 nf=1 m=1
M15 Y VB4 VSS VSS nch l=0.15 w=1 nf=1 m=1
M16 VB5 VB6 VDD VDD pch l=0.15 w=1 nf=1 m=1
M17 VB6 VB6 VDD VDD pch l=0.15 w=1 nf=1 m=1
M18 VB5 VB5 VB4 VSS nch l=0.15 w=1 nf=1 m=1
M19 VB4 VB4 VSS VSS nch l=0.15 w=1 nf=1 m=1
M20 VB6 net0 VSS VSS nch l=0.15 w=1 nf=1 m=1
M21 net4 VB6 VDD VDD pch l=0.15 w=1 nf=1 m=1
M22 net4 net4 net0 VSS nch l=0.15 w=1 nf=1 m=1
M23 net0 net4 net1 VSS nch l=0.15 w=1 nf=1 m=1
M24 net7 VB6 VDD VDD pch l=0.15 w=1 nf=1 m=1
M25 net7 net7 net1 VSS nch l=0.15 w=1 nf=1 m=1
M26 net1 net7 VB3 VSS nch l=0.15 w=1 nf=1 m=1
M27 VB3 VB6 VDD VDD pch l=0.15 w=1 nf=1 m=1
M28 VB3 VB3 VSS VSS nch l=0.15 w=1 nf=1 m=1
M5 net5 VB1 VDD VDD pch l=0.15 w=1 nf=1 m=1
M6 net3 VB1 VDD VDD pch l=0.15 w=1 nf=1 m=1
M7 VZ VB2 net5 VDD pch l=0.15 w=1 nf=1 m=1
M8 VG VB2 net3 VDD pch l=0.15 w=1 nf=1 m=1
M9 VZ VB5 net6 VSS nch l=0.15 w=1 nf=1 m=1
.ends opamp

.subckt dut VDD VSS Vout
M1 X VG VDD VDD pch l=0.15 w=1 nf=1 m=1
M2 Vout VG VDD VDD pch l=0.15 w=1 nf=1 m=1
M3 net0 VG VDD VDD pch l=0.15 w=1 nf=1 m=1
M4 VZ VG VDD VDD pch l=0.15 w=1 nf=1 m=1
Q1 VSS VSS net0 qpnp m=1
Q2 VSS net0 X qpnp m=1
Q3 VSS VSS VZ qpnp m=1
Q4 VSS VZ net1 qpnp m=1
R1 Y net1 1k
R2 Vout Y 1k
X1 VDD VSS X Y VZ VG opamp
.ends dut
