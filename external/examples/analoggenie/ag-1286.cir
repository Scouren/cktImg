* official Analog Canvas netlist; PDK X cards rewritten by convert.py
.model nch nmos
.model pch pmos

.subckt EA1 VDD VSS VREF VFP1 VX3 VS ISR VB3
MN1 net3 VFP1 net1 VSS nch l=0.15 w=1 nf=1 m=1
MN10 VB1 net2 VSS VSS nch l=0.15 w=1 nf=1 m=1
MN11 net2 net2 VSS VSS nch l=0.15 w=1 nf=1 m=1
MN12 net5 VB2 VSS VSS nch l=0.15 w=1 nf=1 m=1
MN13 net7 VB2 VSS VSS nch l=0.15 w=1 nf=1 m=1
MN2 VX3 VREF net1 VSS nch l=0.15 w=1 nf=1 m=1
MN3 net1 VBN VSS VSS nch l=0.15 w=1 nf=1 m=1
MN4 net8 net4 VSS VSS nch l=0.15 w=1 nf=1 m=1
MN5 net4 net4 VSS VSS nch l=0.15 w=1 nf=1 m=1
MN6 net0 net0 VSS VSS nch l=0.15 w=1 nf=1 m=1
MN7 net6 net0 VSS VSS nch l=0.15 w=1 nf=1 m=1
MN8 net0 VB3 VSS VSS nch l=0.15 w=1 nf=1 m=1
MN9 VBN VBN VSS VSS nch l=0.15 w=1 nf=1 m=1
MP1 net8 VX3 VDD VDD pch l=0.15 w=1 nf=1 m=1
MP10 net2 net5 VDD VDD pch l=0.15 w=1 nf=1 m=1
MP11 net5 net5 VDD VDD pch l=0.15 w=1 nf=1 m=1
MP12 VB2 net5 VDD VDD pch l=0.15 w=1 nf=1 m=1
MP2 VX3 VX3 VDD VDD pch l=0.15 w=1 nf=1 m=1
MP3 net3 net3 VDD VDD pch l=0.15 w=1 nf=1 m=1
MP4 net4 net3 VDD VDD pch l=0.15 w=1 nf=1 m=1
MP5 net0 net8 VS VDD pch l=0.15 w=1 nf=1 m=1
MP6 net6 net6 VS VDD pch l=0.15 w=1 nf=1 m=1
MP7 ISR net6 VS VDD pch l=0.15 w=1 nf=1 m=1
MP8 VBN VB1 VDD VDD pch l=0.15 w=1 nf=1 m=1
MP9 VB1 VB1 VDD VDD pch l=0.15 w=1 nf=1 m=1
RB VB2 net7 1k
.ends EA1

.subckt dut VDD VSS VIN VC1 VC2 VC3 VC4 VC5 VP VREF VB3
.model DIODE D(IS=1e-14 N=1)
CFLY VX1 VX2 1p
CO VP VN 1p
COP VP VSS 1p
D1 VN VX2 DIODE
L1 VX1 VX3 1n
M1 VX1 VC2 VIN VDD pch l=0.15 w=1 nf=1 m=1
M2 VX2 VC3 VIN VDD pch l=0.15 w=1 nf=1 m=1
M3 VP VC5 VX3 VDD pch l=0.15 w=1 nf=1 m=1
M4 VX3 VC4 VSS VSS nch l=0.15 w=1 nf=1 m=1
M5 net0 VC1 VIN VDD pch l=0.15 w=1 nf=1 m=1
R1 VP VFP1 1k
R2 VFP1 VSS 1k
X1 VDD VSS VREF VFP1 VX3 net0 VX1 VB3 EA1
.ends dut
