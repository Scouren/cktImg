* official Analog Canvas netlist; PDK X cards rewritten by convert.py
.model nch nmos
.model pch pmos

.subckt dut VDD VSS VB1 VB2 VB4 VOUT VIN
CF1 VOUT VFB 1p
Cm1 net1 VOUT 1p
Cm2 net1 net9 1p
M1 net1 VY VIN VDD pch l=0.15 w=1 nf=1 m=1
M11 net0 VN1 VSS VSS nch l=0.15 w=1 nf=1 m=1
M12 VY VFB net0 VSS nch l=0.15 w=1 nf=1 m=1
M13 VX VREF net0 VSS nch l=0.15 w=1 nf=1 m=1
M14 VY VY VIN VDD pch l=0.15 w=1 nf=1 m=1
M15 VX VX VIN VDD pch l=0.15 w=1 nf=1 m=1
M16 VX VB1 VIN VDD pch l=0.15 w=1 nf=1 m=1
M17 VX net1 VSS VSS nch l=0.15 w=1 nf=1 m=1
M18 VX VX VSS VSS nch l=0.15 w=1 nf=1 m=1
M2 net10 VX VIN VDD pch l=0.15 w=1 nf=1 m=1
M21 net7 net1 VSS VSS nch l=0.15 w=1 nf=1 m=1
M22 net2 VX VSS VSS nch l=0.15 w=1 nf=1 m=1
M23 net7 net7 VIN VDD pch l=0.15 w=1 nf=1 m=1
M24 net2 net7 VIN VDD pch l=0.15 w=1 nf=1 m=1
M3 net1 net10 VSS VSS nch l=0.15 w=1 nf=1 m=1
M4 net10 net10 VSS VSS nch l=0.15 w=1 nf=1 m=1
MB1 VN2 VP2 VIN VDD pch l=0.15 w=1 nf=1 m=1
MB10 net4 net11 VN2 VSS nch l=0.15 w=1 nf=1 m=1
MB11 net3 net3 VIN VDD pch l=0.15 w=1 nf=1 m=1
MB12 VN1 net3 VIN VDD pch l=0.15 w=1 nf=1 m=1
MB13 net3 VN2 VSS VSS nch l=0.15 w=1 nf=1 m=1
MB14 VN1 VN1 VSS VSS nch l=0.15 w=1 nf=1 m=1
MB2 VP2 VP2 VIN VDD pch l=0.15 w=1 nf=1 m=1
MB3 net12 VP2 VIN VDD pch l=0.15 w=1 nf=1 m=1
MB4 net11 VP2 VIN VDD pch l=0.15 w=1 nf=1 m=1
MB5 VN2 VN2 VSS VSS nch l=0.15 w=1 nf=1 m=1
MB6 VP2 net5 VSS VSS nch l=0.15 w=1 nf=1 m=1
MB7 net12 net12 net5 VSS nch l=0.15 w=1 nf=1 m=1
MB8 net5 net12 net4 VSS nch l=0.15 w=1 nf=1 m=1
MB9 net11 net11 net4 VSS nch l=0.15 w=1 nf=1 m=1
MD1 net9 net1 VSS VSS nch l=0.15 w=1 nf=1 m=1
MD2 net6 VB2 VSS VSS nch l=0.15 w=1 nf=1 m=1
MD3 net8 net9 net6 VSS nch l=0.15 w=1 nf=1 m=1
MD4 VY VB4 net6 VSS nch l=0.15 w=1 nf=1 m=1
MD5 net9 VY VIN VDD pch l=0.15 w=1 nf=1 m=1
MD6 VY VY VIN VDD pch l=0.15 w=1 nf=1 m=1
MD7 net8 net8 VIN VDD pch l=0.15 w=1 nf=1 m=1
MPT VOUT net2 VIN VDD pch l=0.15 w=1 nf=1 m=1
RF1 VOUT VFB 1k
RF2 VFB VSS 1k
.ends dut
