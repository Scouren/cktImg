* official Analog Canvas netlist; PDK X cards rewritten by convert.py
.model nch nmos
.model pch pmos
.model qpnp pnp

.subckt opamp VDD VSS INP INN OUT VB1 VB2
M1 OUT VB4 net0 VSS nch l=0.15 w=1 nf=1 m=1
M10 net1 net6 VSS VSS nch l=0.15 w=1 nf=1 m=1
M11 net8 net2 VSS VSS nch l=0.15 w=1 nf=1 m=1
M12 net0 net6 VSS VSS nch l=0.15 w=1 nf=1 m=1
M13 net12 net9 VDD VDD pch l=0.15 w=1 nf=1 m=1
M14 net10 net9 VDD VDD pch l=0.15 w=1 nf=1 m=1
M15 VB4 VB4 net5 VSS nch l=0.15 w=1 nf=1 m=1
M16 net9 VB4 net8 VSS nch l=0.15 w=1 nf=1 m=1
M17 net7 VB3 VSS VSS nch l=0.15 w=1 nf=1 m=1
M18 net7 net3 VDD VDD pch l=0.15 w=1 nf=1 m=1
M19 net3 net7 VB3 VSS nch l=0.15 w=1 nf=1 m=1
M2 net9 VB1 net12 VDD pch l=0.15 w=1 nf=1 m=1
M20 net3 net3 VDD VDD pch l=0.15 w=1 nf=1 m=1
M21 net5 VB4 VSS VSS nch l=0.15 w=1 nf=1 m=1
M22 VB4 net3 VDD VDD pch l=0.15 w=1 nf=1 m=1
M3 OUT VB1 net10 VDD pch l=0.15 w=1 nf=1 m=1
M4 net13 net2 VSS VSS nch l=0.15 w=1 nf=1 m=1
M5 net4 VB2 VDD VDD pch l=0.15 w=1 nf=1 m=1
M6 net2 INP net4 net11 pch l=0.15 w=1 nf=1 m=1
M7 net6 INN net4 net11 pch l=0.15 w=1 nf=1 m=1
M8 net2 VB4 net13 VSS nch l=0.15 w=1 nf=1 m=1
M9 net6 VB4 net1 VSS nch l=0.15 w=1 nf=1 m=1
R4 VB3 VSS 1k
.ends opamp

.subckt dut VDD VSS Vout VB1 VB2
Q1 VSS VSS X qpnp m=1
Q2 VSS VSS net0 qpnp m=1
R1 Vout X 1k
R2 Vout Y 1k
R3 Y net0 1k
X1 VDD VSS X Y Vout VB1 VB2 opamp
.ends dut
