* official Analog Canvas netlist; PDK X cards rewritten by convert.py
.model nch nmos
.model pch pmos
.model qpnp pnp

.subckt A1 VDD VSS VB1 VB3 INN INP VB2 OUT VB4
M1 INN VB1 VDD VDD pch l=0.15 w=1 nf=1 m=1
M10 net3 INP net7 VSS nch l=0.15 w=1 nf=1 m=1
M11 net7 VB2 VSS VSS nch l=0.15 w=1 nf=1 m=1
M12 VY VX VDD VDD pch l=0.15 w=1 nf=1 m=1
M13 VY VY net6 VSS nch l=0.15 w=1 nf=1 m=1
M14 net6 VY VSS VSS nch l=0.15 w=1 nf=1 m=1
M15 VX VX VDD VDD pch l=0.15 w=1 nf=1 m=1
M16 VX VZ VSS VSS nch l=0.15 w=1 nf=1 m=1
M17 net0 VX VDD VDD pch l=0.15 w=1 nf=1 m=1
M18 net0 net0 net8 VSS nch l=0.15 w=1 nf=1 m=1
M19 net8 net0 VB4 VSS nch l=0.15 w=1 nf=1 m=1
M2 net1 VB3 INN VDD pch l=0.15 w=1 nf=1 m=1
M20 net5 VX VDD VDD pch l=0.15 w=1 nf=1 m=1
M21 net5 net5 VZ VSS nch l=0.15 w=1 nf=1 m=1
M22 VZ net5 net8 VSS nch l=0.15 w=1 nf=1 m=1
M23 VB4 VX VDD VDD pch l=0.15 w=1 nf=1 m=1
M24 VB4 VB4 VSS VSS nch l=0.15 w=1 nf=1 m=1
M3 net1 VY net4 VSS nch l=0.15 w=1 nf=1 m=1
M4 net4 net1 VSS VSS nch l=0.15 w=1 nf=1 m=1
M5 net3 VB1 VDD VDD pch l=0.15 w=1 nf=1 m=1
M6 OUT VB3 net3 VDD pch l=0.15 w=1 nf=1 m=1
M7 OUT VY net2 VSS nch l=0.15 w=1 nf=1 m=1
M8 net2 net1 VSS VSS nch l=0.15 w=1 nf=1 m=1
M9 INN INN net7 VSS nch l=0.15 w=1 nf=1 m=1
.ends A1

.subckt dut VDD VSS Vout VB1 VB2 VB3 VB4
Q1 VSS VSS net0 qpnp m=1
Q2 net0 net0 X qpnp m=1
Q3 VSS VSS net1 qpnp m=1
Q4 net1 net1 net2 qpnp m=1
R1 Vout X 1k
R2 Vout Y 1k
R3 Y net2 1k
X1 VDD VSS VB1 VB3 Y X VB2 Vout VB4 A1
.ends dut
