* official Analog Canvas netlist; PDK X cards rewritten by convert.py
.model nch nmos
.model pch pmos

.subckt dut VDD VSS VB1 VREF VB2 IBUF VIN VOUT
CL VOUT net5 1p
M1 net1 net1 VDD VDD pch l=0.15 w=1 nf=1 m=1
M10 net0 net0 VDD VDD pch l=0.15 w=1 nf=1 m=1
M11 VB3 net0 VDD VDD pch l=0.15 w=1 nf=1 m=1
M12 VB3 VB3 VSS VSS nch l=0.15 w=1 nf=1 m=1
M13 net4 VB2 VDD VDD pch l=0.15 w=1 nf=1 m=1
M14 VX EAO net4 VDD pch l=0.15 w=1 nf=1 m=1
M15 VX VX VSS VSS nch l=0.15 w=1 nf=1 m=1
M16 GATE VX VSS VSS nch l=0.15 w=1 nf=1 m=1
M17 VDD net4 GATE VSS nch l=0.15 w=1 nf=1 m=1
M18 net3 EAO IBUF VSS nch l=0.15 w=1 nf=1 m=1
M19 net3 net3 VDD VDD pch l=0.15 w=1 nf=1 m=1
M2 net2 net2 VDD VDD pch l=0.15 w=1 nf=1 m=1
M20 GATE net3 VDD VDD pch l=0.15 w=1 nf=1 m=1
M21 VSS IBUF GATE VDD pch l=0.15 w=1 nf=1 m=1
M22 VB1 VB3 VSS VSS nch l=0.15 w=1 nf=1 m=1
M23 VB1 VB1 VDD VDD pch l=0.15 w=1 nf=1 m=1
M3 net1 VREF VX VSS nch l=0.15 w=1 nf=1 m=1
M4 net2 FB VX VSS nch l=0.15 w=1 nf=1 m=1
M5 VX VB3 VSS VSS nch l=0.15 w=1 nf=1 m=1
M6 EAO net1 VDD VDD pch l=0.15 w=1 nf=1 m=1
M7 net6 net2 VDD VDD pch l=0.15 w=1 nf=1 m=1
M8 net6 net6 VSS VSS nch l=0.15 w=1 nf=1 m=1
M9 EAO net6 VSS VSS nch l=0.15 w=1 nf=1 m=1
MNP VIN GATE VOUT VSS nch l=0.15 w=1 nf=1 m=1
R1 FB VSS 1k
R2 VOUT FB 1k
R3 net0 VSS 1k
R5 net5 VSS 1k
RL VOUT VSS 1k
.ends dut
