* official Analog Canvas netlist; PDK X cards rewritten by convert.py
.model nch nmos
.model pch pmos

.subckt opamp VDD VSS VP VN VOUT
M10 net0 net0 VDD VDD pch l=0.15 w=1 nf=1 m=1
M11 VOUT net0 VDD VDD pch l=0.15 w=1 nf=1 m=1
M12 VN VB2 VDD VDD pch l=0.15 w=1 nf=1 m=1
M13 VN net2 VSS VSS nch l=0.15 w=1 nf=1 m=1
M14 VB2 VB2 VDD VDD pch l=0.15 w=1 nf=1 m=1
M15 VB2 VN net2 VSS nch l=0.15 w=1 nf=1 m=1
M16 VB3 VB3 VDD VDD pch l=0.15 w=1 nf=1 m=1
M17 VB3 net2 VSS VSS nch l=0.15 w=1 nf=1 m=1
M18 VB1 VB3 VDD VDD pch l=0.15 w=1 nf=1 m=1
M19 VB1 VB1 VSS VSS nch l=0.15 w=1 nf=1 m=1
M3 net3 VB3 VDD VDD pch l=0.15 w=1 nf=1 m=1
M4 net1 VN net3 VDD pch l=0.15 w=1 nf=1 m=1
M5 net4 VP net3 VDD pch l=0.15 w=1 nf=1 m=1
M6 net1 net1 VSS VSS nch l=0.15 w=1 nf=1 m=1
M7 net4 net4 VSS VSS nch l=0.15 w=1 nf=1 m=1
M8 VOUT net1 VSS VSS nch l=0.15 w=1 nf=1 m=1
M9 net0 net4 VSS VSS nch l=0.15 w=1 nf=1 m=1
R1 net2 VSS 1k
.ends opamp

.subckt dut VDD VSS vci vco phi1 phi2
C1 net1 VSS 1p
C2 net0 vco 1p
M1 vci phi1 net1 VSS nch l=0.15 w=1 nf=1 m=1
M2 net1 phi2 net0 VSS nch l=0.15 w=1 nf=1 m=1
X1 VDD VSS VSS net0 vco opamp
.ends dut
