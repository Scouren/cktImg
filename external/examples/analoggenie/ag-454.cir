* official Analog Canvas netlist; PDK X cards rewritten by convert.py
.model nch nmos
.model pch pmos

.subckt dut VDD VSS Vin Vb Vout
I1 net0 VSS DC 1m
M1 Vout Vb Vin VDD pch l=0.15 w=1 nf=1 m=1
M2 VDD VDD net0 VSS nch l=0.15 w=1 nf=1 m=1
RD Vout net0 1k
.ends dut
