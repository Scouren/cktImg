* official Analog Canvas netlist; PDK X cards rewritten by convert.py
.model nch nmos
.model pch pmos

.subckt dut VDD VSS Vb2 Vb1 Vin1 Vin2 X Y
M1 net5 Vin1 net4 VSS nch l=0.15 w=1 nf=1 m=1
M10 net0 net0 VSS VSS nch l=0.15 w=1 nf=1 m=1
M11 net2 net2 VDD VDD pch l=0.15 w=1 nf=1 m=1
M2 net6 Vin2 net4 VSS nch l=0.15 w=1 nf=1 m=1
M3 X Vb1 net5 VSS nch l=0.15 w=1 nf=1 m=1
M4 Y Vb1 net6 VSS nch l=0.15 w=1 nf=1 m=1
M5 X Vb2 net1 VDD pch l=0.15 w=1 nf=1 m=1
M6 Y Vb2 net3 VDD pch l=0.15 w=1 nf=1 m=1
M7 net1 net2 VDD VDD pch l=0.15 w=1 nf=1 m=1
M8 net3 net2 VDD VDD pch l=0.15 w=1 nf=1 m=1
M9 net4 net0 VSS VSS nch l=0.15 w=1 nf=1 m=1
R1 net2 net0 1k
.ends dut
