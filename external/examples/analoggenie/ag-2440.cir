* official Analog Canvas netlist; PDK X cards rewritten by convert.py
.model nch nmos
.model pch pmos

.subckt Bias VDD VSS VC VB2 VB1 VBN
M1 net0 net0 VDD VDD pch l=0.15 w=1 nf=1 m=1
M10 VC VX VSS VSS nch l=0.15 w=1 nf=1 m=1
M2 net0 VX VSS VSS nch l=0.15 w=1 nf=1 m=1
M3 VBN net0 VDD VDD pch l=0.15 w=1 nf=1 m=1
M4 VBN VBN VSS VSS nch l=0.15 w=1 nf=1 m=1
M5 VB1 VB1 VDD VDD pch l=0.15 w=1 nf=1 m=1
M6 VB1 VBN VSS VSS nch l=0.15 w=1 nf=1 m=1
M7 VB2 VB2 VDD VDD pch l=0.15 w=1 nf=1 m=1
M8 VB2 VC VX VSS nch l=0.15 w=1 nf=1 m=1
M9 VC VB2 VDD VDD pch l=0.15 w=1 nf=1 m=1
R1 VX VSS 1k
.ends Bias

.subckt AEA VDD VSS VREF VBN OUT
M1 net0 net0 VDD VDD pch l=0.15 w=1 nf=1 m=1
M2 OUT net0 VDD VDD pch l=0.15 w=1 nf=1 m=1
M3 OUT net1 VDD VDD pch l=0.15 w=1 nf=1 m=1
M4 net1 net1 VDD VDD pch l=0.15 w=1 nf=1 m=1
M5 OUT OUT VSS VSS nch l=0.15 w=1 nf=1 m=1
M6 OUT OUT VSS VSS nch l=0.15 w=1 nf=1 m=1
M7 net0 VREF net2 VSS nch l=0.15 w=1 nf=1 m=1
M8 net1 OUT net2 VSS nch l=0.15 w=1 nf=1 m=1
M9 net2 VBN VSS VSS nch l=0.15 w=1 nf=1 m=1
.ends AEA

.subckt dut VDD VSS VB1 VB2 VREF VIN pb nb VOUT VERR
M1 net1 net3 VIN VDD pch l=0.15 w=1 nf=1 m=1
M2 VC VC net1 VDD pch l=0.15 w=1 nf=1 m=1
M3 VC nb VSS VSS nch l=0.15 w=1 nf=1 m=1
MBIAS VERR nb VSS VSS nch l=0.15 w=1 nf=1 m=1
MCHG net2 pb VIN VDD pch l=0.15 w=1 nf=1 m=1
MCTRL VERR VC VOUT VDD pch l=0.15 w=1 nf=1 m=1
MGEN net0 net0 VSS VSS nch l=0.15 w=1 nf=1 m=1
MINJ VERR net0 VSS VSS nch l=0.15 w=1 nf=1 m=1
MRES VOUT VERR VIN VDD pch l=0.15 w=1 nf=1 m=1
MSEN net0 net3 net2 VDD pch l=0.15 w=1 nf=1 m=1
X1 VDD VSS VC VB2 VB1 VBN Bias
X2 VDD VSS VREF VBN net3 AEA
.ends dut
