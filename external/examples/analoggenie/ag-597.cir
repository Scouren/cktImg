* official Analog Canvas netlist; PDK X cards rewritten by convert.py
.model nch nmos
.model pch pmos

.subckt dut VDD VSS Vb VLO_I VLO_I_bar VBBIp VBBIn VLO_Q VLO_Q_bar VBBQp VBBQn
C1 VSS net3 2pF
C2 net9 net10 1pF
C3 net7 net2 1p
C4 net10 VRF 0.5pF
I1 VDD net3 DC 2mA
I2 VDD net10 DC 2mA
I3 VDD net0 DC 5mA
I4 VDD net1 DC 5mA
M1 net8 net2 VSS VSS nch l=0.15 w=30 nf=1 m=1
M10 VBBQn net11 net1 net1 pch l=1.2 w=100 nf=1 m=1
M11 VBBQp net5 net1 net1 pch l=1.2 w=100 nf=1 m=1
M2 net8 net2 net3 net3 pch l=0.1 w=80 nf=1 m=1
M3 VSS net8 net10 net10 pch l=0.15 w=80 nf=1 m=1
M4 net4 VLO_I VRF VSS nch l=0.15 w=5 nf=1 m=1
M5 net12 VLO_I_bar VRF VSS nch l=0.15 w=5 nf=1 m=1
M6 VBBIn net4 net0 net0 pch l=1.2 w=100 nf=1 m=1
M7 VBBIp net12 net0 net0 pch l=1.2 w=100 nf=1 m=1
M8 net11 VLO_Q VRF VSS nch l=0.15 w=5 nf=1 m=1
M9 net5 VLO_Q_bar VRF VSS nch l=0.15 w=5 nf=1 m=1
R1 net2 net8 5kΩ
R2 VRF Vb 2kΩ
R3 VBBIn VSS 200Ω
R4 VBBIp VSS 200Ω
R5 VBBQn VSS 200Ω
R6 VBBQp VSS 200Ω
RM net2 net9 450Ω
RS net6 net7 1k
Vin net6 VSS DC 1
.ends dut
