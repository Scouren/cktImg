* official Analog Canvas netlist; PDK X cards rewritten by convert.py
.model nch nmos
.model pch pmos
.model qpnp pnp

.subckt opamp VDD VSS INN INP OUT
M1 net1 INN net3 VSS nch l=0.15 w=1 nf=1 m=1
M10 VB2 VB2 VSS VSS nch l=0.15 w=1 nf=1 m=1
M11 VB1 VB1 VDD VDD pch l=0.15 w=1 nf=1 m=1
M12 VB2 VB1 VDD VDD pch l=0.15 w=1 nf=1 m=1
M13 VB1 net0 VSS VSS nch l=0.15 w=1 nf=1 m=1
M14 net0 net0 net4 VSS nch l=0.15 w=1 nf=1 m=1
M2 net2 INP net3 VSS nch l=0.15 w=1 nf=1 m=1
M3 net1 net1 VDD VDD pch l=0.15 w=1 nf=1 m=1
M4 net2 net2 VDD VDD pch l=0.15 w=1 nf=1 m=1
M5 net3 VB2 VSS VSS nch l=0.15 w=1 nf=1 m=1
M6 net5 net5 VSS VSS nch l=0.15 w=1 nf=1 m=1
M7 net5 net1 VDD VDD pch l=0.15 w=1 nf=1 m=1
M8 OUT net2 VDD VDD pch l=0.15 w=1 nf=1 m=1
M9 OUT net5 VSS VSS nch l=0.15 w=1 nf=1 m=1
R4 VDD net0 1k
R5 net4 VSS 1k
.ends opamp

.subckt dut VDD VSS Vout
Q1 VSS VSS X qpnp m=1
Q2 VSS VSS net0 qpnp m=1
R1 Vout X 1k
R2 Vout Y 1k
R3 Y net0 1k
X1 VDD VSS Y X Vout opamp
.ends dut
