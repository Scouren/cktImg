* official Analog Canvas netlist; PDK X cards rewritten by convert.py
.model nch nmos
.model pch pmos

.subckt dut VDD VSS VIN VOUT VERR pb nb VREF VB1
M1 net3 net8 VIN VDD pch l=0.15 w=1 nf=1 m=1
M10 net1 net8 net6 VSS nch l=0.15 w=1 nf=1 m=1
M11 net8 net8 VSS VSS nch l=0.15 w=1 nf=1 m=1
M12 net6 VBN VSS VSS nch l=0.15 w=1 nf=1 m=1
M13 net4 net4 VDD VDD pch l=0.15 w=1 nf=1 m=1
M14 VBN net4 VDD VDD pch l=0.15 w=1 nf=1 m=1
M15 VBN VBN VSS VSS nch l=0.15 w=1 nf=1 m=1
M16 VB1 VBN VSS VSS nch l=0.15 w=1 nf=1 m=1
M17 VB1 VB1 VDD VDD pch l=0.15 w=1 nf=1 m=1
M2 net5 net5 net3 VDD pch l=0.15 w=1 nf=1 m=1
M3 net5 nb VSS VSS nch l=0.15 w=1 nf=1 m=1
M4 net8 net2 VDD VDD pch l=0.15 w=1 nf=1 m=1
M5 net2 net2 VDD VDD pch l=0.15 w=1 nf=1 m=1
M6 net1 net1 VDD VDD pch l=0.15 w=1 nf=1 m=1
M7 net8 net1 VDD VDD pch l=0.15 w=1 nf=1 m=1
M8 net8 net8 VSS VSS nch l=0.15 w=1 nf=1 m=1
M9 net2 VREF net6 VSS nch l=0.15 w=1 nf=1 m=1
MBIAS VERR nb VSS VSS nch l=0.15 w=1 nf=1 m=1
MCHG net7 pb VIN VDD pch l=0.15 w=1 nf=1 m=1
MCTRL VERR net5 VOUT VDD pch l=0.15 w=1 nf=1 m=1
MGEN net0 net0 VSS VSS nch l=0.15 w=1 nf=1 m=1
MINJ VERR net0 VSS VSS nch l=0.15 w=1 nf=1 m=1
MRES VOUT VERR VIN VDD pch l=0.15 w=1 nf=1 m=1
MSEN net0 net8 net7 VDD pch l=0.15 w=1 nf=1 m=1
R1 net4 VSS 1k
.ends dut
