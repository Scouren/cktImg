* official Analog Canvas netlist; PDK X cards rewritten by convert.py
.model nch nmos
.model pch pmos

.subckt dut VDD VSS vci phi1 phi2 vco
C1 net3 net4 1p
C2 net1 vco 1p
M1 vci phi1 net3 VSS nch l=0.15 w=1 nf=1 m=1
M10 net5 VB3 net7 VDD pch l=0.15 w=1 nf=1 m=1
M11 vco VB3 net0 VDD pch l=0.15 w=1 nf=1 m=1
M12 net2 net2 VSS VSS nch l=0.15 w=1 nf=1 m=1
M13 VB1 net2 VSS VSS nch l=0.15 w=1 nf=1 m=1
M14 VB1 VB1 VDD VDD pch l=0.15 w=1 nf=1 m=1
M15 VB2 VB1 VDD VDD pch l=0.15 w=1 nf=1 m=1
M16 VB2 VB2 VSS VSS nch l=0.15 w=1 nf=1 m=1
M2 net3 phi2 VSS VSS nch l=0.15 w=1 nf=1 m=1
M3 net4 phi1 VSS VSS nch l=0.15 w=1 nf=1 m=1
M4 net4 phi2 net1 VSS nch l=0.15 w=1 nf=1 m=1
M5 net5 net1 net6 VSS nch l=0.15 w=1 nf=1 m=1
M6 vco VSS net6 VSS nch l=0.15 w=1 nf=1 m=1
M7 net6 VB2 VSS VSS nch l=0.15 w=1 nf=1 m=1
M8 net7 net5 VDD VDD pch l=0.15 w=1 nf=1 m=1
M9 net0 net5 VDD VDD pch l=0.15 w=1 nf=1 m=1
R1 VDD net2 1k
.ends dut
