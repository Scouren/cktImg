* official Analog Canvas netlist; PDK X cards rewritten by convert.py
.model nch nmos
.model pch pmos

.subckt dut VDD VSS VB2 VREF VB1 VB4 VB6 VB5 VOUT VIN
CF1 VOUT VFB 1p
Cm1 VOUT VO1 1p
Cm2 VO1 net9 1p
M11 net11 VB2 VIN VDD pch l=0.15 w=1 nf=1 m=1
M12 VX VFB net11 VDD pch l=0.15 w=1 nf=1 m=1
M13 VY VREF net11 VDD pch l=0.15 w=1 nf=1 m=1
M14 VZ VX VSS VSS nch l=0.15 w=1 nf=1 m=1
M15 net6 VY VSS VSS nch l=0.15 w=1 nf=1 m=1
M16 net10 net0 VIN VDD pch l=0.15 w=1 nf=1 m=1
M17 net14 VY VSS VSS nch l=0.15 w=1 nf=1 m=1
M18 net8 VX VSS VSS nch l=0.15 w=1 nf=1 m=1
M21 net2 VO1 VSS VSS nch l=0.15 w=1 nf=1 m=1
M22 net13 VY VSS VSS nch l=0.15 w=1 nf=1 m=1
M23 net2 net2 VIN VDD pch l=0.15 w=1 nf=1 m=1
M24 net13 net2 VIN VDD pch l=0.15 w=1 nf=1 m=1
M25 VY VB4 VIN VDD pch l=0.15 w=1 nf=1 m=1
M26 VY VO1 VSS VSS nch l=0.15 w=1 nf=1 m=1
M27 VY VY VSS VSS nch l=0.15 w=1 nf=1 m=1
M31 VX VC VZ VSS nch l=0.15 w=1 nf=1 m=1
M32 VY VC net6 VSS nch l=0.15 w=1 nf=1 m=1
M33 VO1 VC net14 VSS nch l=0.15 w=1 nf=1 m=1
M34 net0 VC net8 VSS nch l=0.15 w=1 nf=1 m=1
M35 net7 net0 VIN VDD pch l=0.15 w=1 nf=1 m=1
M36 net0 VB1 net10 VDD pch l=0.15 w=1 nf=1 m=1
M37 VO1 VB1 net7 VDD pch l=0.15 w=1 nf=1 m=1
M41 net1 VC VSS VSS nch l=0.15 w=1 nf=1 m=1
M42 VC VC net1 VSS nch l=0.15 w=1 nf=1 m=1
M43 VC net5 VIN VDD pch l=0.15 w=1 nf=1 m=1
M44 net5 VB3 VSS VSS nch l=0.15 w=1 nf=1 m=1
M45 net12 VB3 VSS VSS nch l=0.15 w=1 nf=1 m=1
M46 net5 net5 VIN VDD pch l=0.15 w=1 nf=1 m=1
M47 VB3 net5 VIN VDD pch l=0.15 w=1 nf=1 m=1
MD1 net9 VO1 VSS VSS nch l=0.15 w=1 nf=1 m=1
MD2 net3 VB5 VSS VSS nch l=0.15 w=1 nf=1 m=1
MD3 VZ net9 net3 VSS nch l=0.15 w=1 nf=1 m=1
MD4 net4 VB6 net3 VSS nch l=0.15 w=1 nf=1 m=1
MD5 net9 net4 VIN VDD pch l=0.15 w=1 nf=1 m=1
MD6 net4 net4 VIN VDD pch l=0.15 w=1 nf=1 m=1
MD7 VZ VZ VIN VDD pch l=0.15 w=1 nf=1 m=1
MPT VOUT net13 VIN VDD pch l=0.15 w=1 nf=1 m=1
RB VB3 net12 1k
RF1 VOUT VFB 1k
RF2 VFB VSS 1k
.ends dut
