* official Analog Canvas netlist; PDK X cards rewritten by convert.py
.model nch nmos
.model pch pmos

.subckt opamp VDD VSS INP INN OUT
M10 net8 net6 VSS VSS nch l=0.15 w=1 nf=1 m=1
M11 net7 net6 VSS VSS nch l=0.15 w=1 nf=1 m=1
M12 net1 net1 VDD VDD pch l=0.15 w=1 nf=1 m=1
M13 net1 VB1 VSS VSS nch l=0.15 w=1 nf=1 m=1
M14 VB1 net3 VDD VDD pch l=0.15 w=1 nf=1 m=1
M15 VB1 VB1 VSS VSS nch l=0.15 w=1 nf=1 m=1
M16 net3 net3 VDD VDD pch l=0.15 w=1 nf=1 m=1
M17 net3 net0 VSS VSS nch l=0.15 w=1 nf=1 m=1
M18 net0 VB2 VDD VDD pch l=0.15 w=1 nf=1 m=1
M19 net0 net0 VSS VSS nch l=0.15 w=1 nf=1 m=1
M20 VB2 VB2 VDD VDD pch l=0.15 w=1 nf=1 m=1
M21 VB2 net0 net2 VSS nch l=0.15 w=1 nf=1 m=1
M5 net5 net1 VDD VDD pch l=0.15 w=1 nf=1 m=1
M6 net6 INP net5 net4 pch l=0.15 w=1 nf=1 m=1
M7 OUT INN net5 net4 pch l=0.15 w=1 nf=1 m=1
M8 net6 VB4 net8 VSS nch l=0.15 w=1 nf=1 m=1
M9 OUT VB4 net7 VSS nch l=0.15 w=1 nf=1 m=1
R1 net2 VSS 1k
.ends opamp

.subckt dut VDD VSS vci phi1 phi2 vco
C1 net2 net1 1p
C2 net0 vco 1p
M1 vci phi1 net2 VSS nch l=0.15 w=1 nf=1 m=1
M2 net2 phi2 VSS VSS nch l=0.15 w=1 nf=1 m=1
M3 net1 phi1 VSS VSS nch l=0.15 w=1 nf=1 m=1
M4 net1 phi2 net0 VSS nch l=0.15 w=1 nf=1 m=1
X1 VDD VSS VSS net0 vco opamp
.ends dut
