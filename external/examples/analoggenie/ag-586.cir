* official Analog Canvas netlist; PDK X cards rewritten by convert.py
.model nch nmos

.subckt dut VDD VSS Vin Vb
C1 Vin net1 1p
C2 Vin net2 1p
C3 X net0 1p
L1 VDD X 1n
M1 X net1 VSS VSS nch l=0.15 w=1 nf=1 m=1
M2 X net2 VSS VSS nch l=0.15 w=1 nf=1 m=1
R1 net1 Vb 1k
R2 net2 VSS 1k
RL net0 VSS 1k
.ends dut
