* official Analog Canvas netlist; PDK X cards rewritten by convert.py
.model nch nmos
.model pch pmos

.subckt dut VDD VSS vci phi1 phi2 vco
C1 net8 net5 1p
C2 net4 vco 1p
M1 vci phi1 net8 VSS nch l=0.15 w=1 nf=1 m=1
M10 net2 net0 VSS VSS nch l=0.15 w=1 nf=1 m=1
M11 vco net7 VSS VSS nch l=0.15 w=1 nf=1 m=1
M12 net2 net2 VDD VDD pch l=0.15 w=1 nf=1 m=1
M13 vco net2 VDD VDD pch l=0.15 w=1 nf=1 m=1
M14 VB3 VB3 VDD VDD pch l=0.15 w=1 nf=1 m=1
M15 VB3 VB1 VSS VSS nch l=0.15 w=1 nf=1 m=1
M16 VB1 net1 VDD VDD pch l=0.15 w=1 nf=1 m=1
M17 VB1 VB1 VSS VSS nch l=0.15 w=1 nf=1 m=1
M18 net1 net1 VDD VDD pch l=0.15 w=1 nf=1 m=1
M19 net1 net3 VSS VSS nch l=0.15 w=1 nf=1 m=1
M2 net8 phi2 VSS VSS nch l=0.15 w=1 nf=1 m=1
M20 VB2 VB2 VDD VDD pch l=0.15 w=1 nf=1 m=1
M21 VB2 net9 net3 VSS nch l=0.15 w=1 nf=1 m=1
M22 net9 VB2 VDD VDD pch l=0.15 w=1 nf=1 m=1
M23 net9 net3 VSS VSS nch l=0.15 w=1 nf=1 m=1
M3 net5 phi1 VSS VSS nch l=0.15 w=1 nf=1 m=1
M4 net5 phi2 net4 VSS nch l=0.15 w=1 nf=1 m=1
M5 net6 VB3 VDD VDD pch l=0.15 w=1 nf=1 m=1
M6 net7 net4 net6 VDD pch l=0.15 w=1 nf=1 m=1
M7 net0 VSS net6 VDD pch l=0.15 w=1 nf=1 m=1
M8 net7 net7 VSS VSS nch l=0.15 w=1 nf=1 m=1
M9 net0 net0 VSS VSS nch l=0.15 w=1 nf=1 m=1
R1 net3 VSS 1k
.ends dut
