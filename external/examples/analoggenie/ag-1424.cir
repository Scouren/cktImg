* official Analog Canvas netlist; PDK X cards rewritten by convert.py
.model nch nmos
.model pch pmos

.subckt comparator VDD VSS INN OUT
M1 net4 INN net2 VSS nch l=0.15 w=1 nf=1 m=1
M10 VB2 VB2 VDD VDD pch l=0.15 w=1 nf=1 m=1
M11 VB2 net0 VSS VSS nch l=0.15 w=1 nf=1 m=1
M12 net3 VB2 VDD VDD pch l=0.15 w=1 nf=1 m=1
M13 net3 net3 net0 VSS nch l=0.15 w=1 nf=1 m=1
M14 net0 net3 net1 VSS nch l=0.15 w=1 nf=1 m=1
M15 net5 VB2 VDD VDD pch l=0.15 w=1 nf=1 m=1
M16 net5 net5 net1 VSS nch l=0.15 w=1 nf=1 m=1
M17 net1 net5 VB3 VSS nch l=0.15 w=1 nf=1 m=1
M18 VB3 VB2 VDD VDD pch l=0.15 w=1 nf=1 m=1
M19 VB3 VB3 VSS VSS nch l=0.15 w=1 nf=1 m=1
M2 net4 net4 VDD VDD pch l=0.15 w=1 nf=1 m=1
M20 VB1 VB1 VDD VDD pch l=0.15 w=1 nf=1 m=1
M21 VB1 VB3 VSS VSS nch l=0.15 w=1 nf=1 m=1
M22 VB4 VB1 VDD VDD pch l=0.15 w=1 nf=1 m=1
M23 VB4 VB4 VSS VSS nch l=0.15 w=1 nf=1 m=1
M3 OUT OUT VDD VDD pch l=0.15 w=1 nf=1 m=1
M4 OUT OUT net2 VSS nch l=0.15 w=1 nf=1 m=1
M5 OUT OUT VDD VDD pch l=0.15 w=1 nf=1 m=1
M6 VX net4 VDD VDD pch l=0.15 w=1 nf=1 m=1
M7 OUT VX VSS VSS nch l=0.15 w=1 nf=1 m=1
M8 VX VX VSS VSS nch l=0.15 w=1 nf=1 m=1
M9 net2 VB4 VSS VSS nch l=0.15 w=1 nf=1 m=1
.ends comparator

.subckt dut VSS VSTO VCONT2 VCONT3 VOUT VCONT1
CL VOUT VSS 1p
CSTO VSTO VSS 1p
LRX net1 net0 1n
MN1 net1 VCONT2 VSS VSS nch l=0.15 w=1 nf=1 m=1
MN2 net0 VCONT3 VSS VSS nch l=0.15 w=1 nf=1 m=1
MP2 net0 net2 VOUT VDD pch l=0.15 w=1 nf=1 m=1
MP3 net1 VCONT1 VSTO VDD pch l=0.15 w=1 nf=1 m=1
X1 VDD VSS net0 net2 comparator
.ends dut
