* official Analog Canvas netlist; PDK X cards rewritten by convert.py
.model nch nmos
.model pch pmos

.subckt comparator VDD VSS IN VB3 OUT
MN3 net0 IN net2 VSS nch l=0.15 w=1 nf=1 m=1
MN4 OUT OUT net2 VSS nch l=0.15 w=1 nf=1 m=1
MN5 net2 VB3 VSS VSS nch l=0.15 w=1 nf=1 m=1
MN6 net1 net1 VSS VSS nch l=0.15 w=1 nf=1 m=1
MN7 OUT net1 VSS VSS nch l=0.15 w=1 nf=1 m=1
MP4 net1 net0 VDD VDD pch l=0.15 w=1 nf=1 m=1
MP5 net0 net0 VDD VDD pch l=0.15 w=1 nf=1 m=1
MP6 OUT OUT VDD VDD pch l=0.15 w=1 nf=1 m=1
MP7 OUT OUT VDD VDD pch l=0.15 w=1 nf=1 m=1
.ends comparator

.subckt dut VDD VSS VSTO VOUT VCONT1 VCONT2 VCONT3 VB2 VB1
CL VOUT VSS 1p
CSTO VSTO VSS 1p
LRX net3 net4 1n
MN1 net3 VCONT2 VSS VSS nch l=0.15 w=1 nf=1 m=1
MN10 VB3 VB3 VSS VSS nch l=0.15 w=1 nf=1 m=1
MN11 VB1 VB3 VSS VSS nch l=0.15 w=1 nf=1 m=1
MN2 net4 VCONT3 VSS VSS nch l=0.15 w=1 nf=1 m=1
MN8 VB2 VB2 VSS VSS nch l=0.15 w=1 nf=1 m=1
MN9 net2 VB2 net0 VSS nch l=0.15 w=1 nf=1 m=1
MP10 VB3 net2 VDD VDD pch l=0.15 w=1 nf=1 m=1
MP11 VB1 VB1 VDD VDD pch l=0.15 w=1 nf=1 m=1
MP2 net4 net1 VOUT VDD pch l=0.15 w=1 nf=1 m=1
MP3 net3 VCONT1 VSTO VDD pch l=0.15 w=1 nf=1 m=1
MP8 VB2 net2 VDD VDD pch l=0.15 w=1 nf=1 m=1
MP9 net2 net2 VDD VDD pch l=0.15 w=1 nf=1 m=1
R1 net0 VSS 1k
X1 VDD VSS net4 VB3 net1 comparator
.ends dut
