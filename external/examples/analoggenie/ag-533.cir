* official Analog Canvas netlist; PDK X cards rewritten by convert.py
.model nch nmos
.model pch pmos

.subckt dut VDD VSS Vcont
LXY X Y 1n
M1 X Y VSS VSS nch l=0.15 w=1 nf=1 m=1
M2 Y X VSS VSS nch l=0.15 w=1 nf=1 m=1
M3 X Y VDD VDD pch l=0.15 w=1 nf=1 m=1
M4 Y X VDD VDD pch l=0.15 w=1 nf=1 m=1
Mv1 Vcont X Vcont VSS nch l=0.15 w=1 nf=1 m=1
Mv2 Vcont Y Vcont VSS nch l=0.15 w=1 nf=1 m=1
.ends dut
