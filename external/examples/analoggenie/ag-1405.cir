* official Analog Canvas netlist; PDK X cards rewritten by convert.py
.model nch nmos
.model pch pmos

.subckt opamp VDD VSS vn vo VB1 VB2 VB3 VB4
M10 net3 VB2 VSS VSS nch l=0.15 w=1 nf=1 m=1
M11 net10 VB1 VDD VDD pch l=0.15 w=1 nf=1 m=1
M12 net5 vn net10 VDD pch l=0.15 w=1 nf=1 m=1
M13 net3 vo net10 VDD pch l=0.15 w=1 nf=1 m=1
M14 VP VP VDD VDD pch l=0.15 w=1 nf=1 m=1
M15 net9 VP VDD VDD pch l=0.15 w=1 nf=1 m=1
M16 net6 VP VDD VDD pch l=0.15 w=1 nf=1 m=1
M17 VB4 VP VDD VDD pch l=0.15 w=1 nf=1 m=1
M18 VC VP VDD VDD pch l=0.15 w=1 nf=1 m=1
M19 VP net0 VSS VSS nch l=0.15 w=1 nf=1 m=1
M20 net9 net9 net0 VSS nch l=0.15 w=1 nf=1 m=1
M21 net0 net9 net1 VSS nch l=0.15 w=1 nf=1 m=1
M22 net6 net6 net1 VSS nch l=0.15 w=1 nf=1 m=1
M23 net1 net6 VB4 VSS nch l=0.15 w=1 nf=1 m=1
M24 VB4 VB4 VSS VSS nch l=0.15 w=1 nf=1 m=1
M25 VC VC net4 VSS nch l=0.15 w=1 nf=1 m=1
M26 net4 VC VSS VSS nch l=0.15 w=1 nf=1 m=1
M3 net2 net7 VDD VDD pch l=0.15 w=1 nf=1 m=1
M4 net8 net7 VDD VDD pch l=0.15 w=1 nf=1 m=1
M5 vo VB3 net2 VDD pch l=0.15 w=1 nf=1 m=1
M6 net7 VB3 net8 VDD pch l=0.15 w=1 nf=1 m=1
M7 vo VC net5 VSS nch l=0.15 w=1 nf=1 m=1
M8 net7 VC net3 VSS nch l=0.15 w=1 nf=1 m=1
M9 net5 VB2 VSS VSS nch l=0.15 w=1 nf=1 m=1
.ends opamp

.subckt dut VDD VSS VSTO VCONT1 VCONT2 VCONT3 VOUT VB1 VB2 VB3 VB4
CL VOUT VSS 1p
CSTO VSTO VSS 1p
LRX net0 net2 1n
MN1 net0 VCONT2 VSS VSS nch l=0.15 w=1 nf=1 m=1
MN2 net2 VCONT3 VSS VSS nch l=0.15 w=1 nf=1 m=1
MP2 net2 net1 VOUT VDD pch l=0.15 w=1 nf=1 m=1
MP3 net0 VCONT1 VSTO VDD pch l=0.15 w=1 nf=1 m=1
X1 VDD VSS net2 net1 VB1 VB2 VB3 VB4 opamp
.ends dut
