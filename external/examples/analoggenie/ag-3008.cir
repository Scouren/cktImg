* official Analog Canvas netlist; PDK X cards rewritten by convert.py
.model nch nmos
.model pch pmos

.subckt dut VDD VSS vci phi1 phi2 vco
C1 vcx VSS 1p
C2 VX vco 1p
C3 net3 vco 1p
M1 vci phi1 vcx VSS nch l=0.15 w=1 nf=1 m=1
M10 VB2 VB2 VDD VDD pch l=0.15 w=1 nf=1 m=1
M11 VB2 net0 VSS VSS nch l=0.15 w=1 nf=1 m=1
M12 VB1 VB1 VDD VDD pch l=0.15 w=1 nf=1 m=1
M13 VB1 VX net0 VSS nch l=0.15 w=1 nf=1 m=1
M14 VX VB1 VDD VDD pch l=0.15 w=1 nf=1 m=1
M15 VX net0 VSS VSS nch l=0.15 w=1 nf=1 m=1
M2 vcx phi2 VX VSS nch l=0.15 w=1 nf=1 m=1
M3 net3 VX net2 VDD pch l=0.15 w=1 nf=1 m=1
M4 net1 VSS net2 VDD pch l=0.15 w=1 nf=1 m=1
M5 net3 net1 VSS VSS nch l=0.15 w=1 nf=1 m=1
M6 net1 net1 VSS VSS nch l=0.15 w=1 nf=1 m=1
M7 net2 VB2 VDD VDD pch l=0.15 w=1 nf=1 m=1
M8 vco net3 VSS VSS nch l=0.15 w=1 nf=1 m=1
M9 vco VB2 VDD VDD pch l=0.15 w=1 nf=1 m=1
R1 net0 VSS 1k
.ends dut
