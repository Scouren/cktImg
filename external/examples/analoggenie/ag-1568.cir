* official Analog Canvas netlist; PDK X cards rewritten by convert.py
.model nch nmos
.model pch pmos
.model qpnp pnp

.subckt opamp VDD VSS INP INN VB2 VB1 OUT
M10 VX VB5 net3 VSS nch l=0.15 w=1 nf=1 m=1
M11 net4 VB5 net13 VSS nch l=0.15 w=1 nf=1 m=1
M12 net8 VB5 net9 VSS nch l=0.15 w=1 nf=1 m=1
M13 OUT VB5 net12 VSS nch l=0.15 w=1 nf=1 m=1
M14 net3 net4 VSS VSS nch l=0.15 w=1 nf=1 m=1
M15 net13 net4 VSS VSS nch l=0.15 w=1 nf=1 m=1
M16 net9 net8 VSS VSS nch l=0.15 w=1 nf=1 m=1
M17 net12 net8 VSS VSS nch l=0.15 w=1 nf=1 m=1
M18 net0 net7 VDD VDD pch l=0.15 w=1 nf=1 m=1
M19 net7 net7 VDD VDD pch l=0.15 w=1 nf=1 m=1
M20 net6 net7 VDD VDD pch l=0.15 w=1 nf=1 m=1
M21 VB5 net7 VDD VDD pch l=0.15 w=1 nf=1 m=1
M22 net7 net6 net10 VSS nch l=0.15 w=1 nf=1 m=1
M23 VB5 VB5 net5 VSS nch l=0.15 w=1 nf=1 m=1
M24 net0 net0 VSS VSS nch l=0.15 w=1 nf=1 m=1
M25 net10 net0 VSS VSS nch l=0.15 w=1 nf=1 m=1
M26 net6 net10 VSS VSS nch l=0.15 w=1 nf=1 m=1
M27 net5 VB5 VSS VSS nch l=0.15 w=1 nf=1 m=1
M3 net2 VX VDD VDD pch l=0.15 w=1 nf=1 m=1
M4 net1 VB2 VDD VDD pch l=0.15 w=1 nf=1 m=1
M5 net11 VX VDD VDD pch l=0.15 w=1 nf=1 m=1
M6 VX VB1 net2 VDD pch l=0.15 w=1 nf=1 m=1
M7 net4 INP net1 VDD pch l=0.15 w=1 nf=1 m=1
M8 net8 INN net1 VDD pch l=0.15 w=1 nf=1 m=1
M9 OUT VB1 net11 VDD pch l=0.15 w=1 nf=1 m=1
.ends opamp

.subckt dut VDD VSS Vout VB1 VB2
Q1 VSS VSS X qpnp m=1
Q2 VSS VSS net0 qpnp m=1
R1 Vout X 1k
R2 Vout Y 1k
R3 Y net0 1k
X1 VDD VSS X Y VB2 VB1 Vout opamp
.ends dut
