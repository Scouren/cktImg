* official Analog Canvas netlist; PDK X cards rewritten by convert.py
.model qnpn npn
.model qpnp pnp

.subckt dut VCC VEE VSS In+ In- Output
I1 VCC net11 DC 40uA
I2 In+ VEE DC 20uA
I3 In- VEE DC 20uA
Igain net10 VEE DC 1m
Q1 net0 In+ net10 VEE qnpn m=1
Q10 net2 net5 net1 qpnp m=1
Q11 net2 net2 net9 VEE qnpn m=1
Q12 net9 net4 VEE VEE qnpn m=1
Q13 Output net2 net4 VEE qnpn m=1
Q14 net4 net4 VEE VEE qnpn m=1
Q15 VCC net11 net8 VEE qnpn m=1
Q16 net11 net8 In+ VEE qnpn m=1
Q17 net11 net8 In- VEE qnpn m=1
Q2 net5 In- net10 VEE qnpn m=1
Q3 net6 net7 VCC qpnp m=1
Q4 net0 net0 net6 qpnp m=1
Q5 net7 net7 VCC qpnp m=1
Q6 Output net0 net7 qpnp m=1
Q7 net3 net1 VCC qpnp m=1
Q8 net5 net5 net3 qpnp m=1
Q9 net1 net1 VCC qpnp m=1
R1 In+ net12 22kΩ
R2 In- VSS 22kΩ
Rload Output VSS 30kΩ
Vin net12 VSS DC 1
.ends dut
