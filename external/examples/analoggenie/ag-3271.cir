* official Analog Canvas netlist; PDK X cards rewritten by convert.py
.model nch nmos
.model pch pmos

.subckt opamp VDD VSS Vp Vn Vo
M10 Vo net4 VSS VSS nch l=0.15 w=1 nf=1 m=1
M11 net0 net1 VSS VSS nch l=0.15 w=1 nf=1 m=1
M12 net0 net0 VDD VDD pch l=0.15 w=1 nf=1 m=1
M13 Vo net0 VDD VDD pch l=0.15 w=1 nf=1 m=1
M14 VB2 VB1 VSS VSS nch l=0.15 w=1 nf=1 m=1
M15 VB2 VB2 VDD VDD pch l=0.15 w=1 nf=1 m=1
M16 VB1 VB1 VSS VSS nch l=0.15 w=1 nf=1 m=1
M17 VB1 net2 VDD VDD pch l=0.15 w=1 nf=1 m=1
M18 net2 net2 VDD VDD pch l=0.15 w=1 nf=1 m=1
M19 net2 net3 VSS VSS nch l=0.15 w=1 nf=1 m=1
M20 net3 net3 VSS VSS nch l=0.15 w=1 nf=1 m=1
M21 net5 net3 VSS VSS nch l=0.15 w=1 nf=1 m=1
M22 net3 net5 VDD VDD pch l=0.15 w=1 nf=1 m=1
M5 net4 Vn net6 VDD pch l=0.15 w=1 nf=1 m=1
M6 net1 Vp net6 VDD pch l=0.15 w=1 nf=1 m=1
M7 net6 VB2 VDD VDD pch l=0.15 w=1 nf=1 m=1
M8 net4 net4 VSS VSS nch l=0.15 w=1 nf=1 m=1
M9 net1 net1 VSS VSS nch l=0.15 w=1 nf=1 m=1
R1 VDD net3 1k
R2 VDD net5 1k
.ends opamp

.subckt dut VDD VSS vci phi1 phi2 vco
C1 net2 net0 1p
C2 net1 vco 1p
M1 vci phi1 net2 VSS nch l=0.15 w=1 nf=1 m=1
M2 net2 phi2 VSS VSS nch l=0.15 w=1 nf=1 m=1
M3 net0 phi1 VSS VSS nch l=0.15 w=1 nf=1 m=1
M4 net0 phi2 net1 VSS nch l=0.15 w=1 nf=1 m=1
X1 VDD VSS VSS net1 vco opamp
.ends dut
