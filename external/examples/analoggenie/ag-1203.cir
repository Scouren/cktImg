* official Analog Canvas netlist; PDK X cards rewritten by convert.py
.model nch nmos
.model pch pmos

.subckt EA1 VDD VSS VB1 VB2 VFP1 VREF VEA VX1
MN1 VEA VBN net2 VSS nch l=0.15 w=1 nf=1 m=1
MN10 net8 VBN VSS VSS nch l=0.15 w=1 nf=1 m=1
MN2 net5 VBN VX1 VSS nch l=0.15 w=1 nf=1 m=1
MN3 net1 VBN net10 VSS nch l=0.15 w=1 nf=1 m=1
MN4 VGP VBN net6 VSS nch l=0.15 w=1 nf=1 m=1
MN5 net2 net5 VSS VSS nch l=0.15 w=1 nf=1 m=1
MN6 VX1 net5 VSS VSS nch l=0.15 w=1 nf=1 m=1
MN7 net10 net1 VSS VSS nch l=0.15 w=1 nf=1 m=1
MN8 net6 net1 VSS VSS nch l=0.15 w=1 nf=1 m=1
MN9 VBN VBN net8 VSS nch l=0.15 w=1 nf=1 m=1
MP1 net9 VGP VDD VDD pch l=0.15 w=1 nf=1 m=1
MP2 net7 VGP VDD VDD pch l=0.15 w=1 nf=1 m=1
MP3 VEA VB1 net9 VDD pch l=0.15 w=1 nf=1 m=1
MP4 VGP VB1 net7 VDD pch l=0.15 w=1 nf=1 m=1
MP5 net0 VB2 VDD VDD pch l=0.15 w=1 nf=1 m=1
MP6 net5 VFP1 net0 VDD pch l=0.15 w=1 nf=1 m=1
MP7 net1 VREF net0 VDD pch l=0.15 w=1 nf=1 m=1
MP8 net3 net3 net4 VDD pch l=0.15 w=1 nf=1 m=1
MP9 VBN net3 VDD VDD pch l=0.15 w=1 nf=1 m=1
RB1 VDD net4 1k
RB2 net3 VSS 1k
.ends EA1

.subckt ISR VDD VSS VB3 VEA VX4 VX1
MN11 net0 net1 VSS VSS nch l=0.15 w=1 nf=1 m=1
MN12 net1 net1 VSS VSS nch l=0.15 w=1 nf=1 m=1
MN13 net1 VB3 VSS VSS nch l=0.15 w=1 nf=1 m=1
MP10 net1 VEA VX4 VDD pch l=0.15 w=1 nf=1 m=1
MP11 net0 net0 VX4 VDD pch l=0.15 w=1 nf=1 m=1
MP12 VX1 net0 VX4 VDD pch l=0.15 w=1 nf=1 m=1
.ends ISR

.subckt dut VDD VSS VIN VP VS5 VS1 VS2 VS3 VS4 VB3 VB1 VB2 VREF
.model DIODE D(IS=1e-14 N=1)
CFLY VX1 VX2 1p
CO VP VN 1p
COP VP VSS 1p
D1 VN VX2 DIODE
L1 VX1 VX3 1n
M1 net1 VS5 VIN VDD pch l=0.15 w=1 nf=1 m=1
M2 VX1 VS1 VIN VDD pch l=0.15 w=1 nf=1 m=1
M3 VX2 VS2 VIN VDD pch l=0.15 w=1 nf=1 m=1
M4 VX3 VS3 VP VDD pch l=0.15 w=1 nf=1 m=1
M5 VX3 VS4 VSS VSS nch l=0.15 w=1 nf=1 m=1
R1 VP VFP1 1k
R2 VFP1 VSS 1k
X1 VDD VSS VB1 VB2 VFP1 VREF net0 VX1 EA1
X2 VDD VSS VB3 net0 net1 VX1 ISR
.ends dut
