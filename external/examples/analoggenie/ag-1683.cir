* official Analog Canvas netlist; PDK X cards rewritten by convert.py
.model nch nmos
.model pch pmos
.model qpnp pnp

.subckt opamp VDD VSS INP INN OUT VE
M1 VE INP net4 VDD pch l=0.15 w=1 nf=1 m=1
M10 VE VB5 VSS VSS nch l=0.15 w=1 nf=1 m=1
M11 net1 VB5 VSS VSS nch l=0.15 w=1 nf=1 m=1
M12 VB4 VB6 VDD VDD pch l=0.15 w=1 nf=1 m=1
M13 VB4 VB4 VB5 VSS nch l=0.15 w=1 nf=1 m=1
M14 VB5 VB5 VSS VSS nch l=0.15 w=1 nf=1 m=1
M15 VB6 VB6 VDD VDD pch l=0.15 w=1 nf=1 m=1
M16 VB6 net0 VSS VSS nch l=0.15 w=1 nf=1 m=1
M17 net6 VB6 VDD VDD pch l=0.15 w=1 nf=1 m=1
M18 net6 net6 net0 VSS nch l=0.15 w=1 nf=1 m=1
M19 net0 net6 net5 VSS nch l=0.15 w=1 nf=1 m=1
M2 net1 INN net4 VDD pch l=0.15 w=1 nf=1 m=1
M20 net2 VB6 VDD VDD pch l=0.15 w=1 nf=1 m=1
M21 net2 net2 net5 VSS nch l=0.15 w=1 nf=1 m=1
M22 net5 net2 VB3 VSS nch l=0.15 w=1 nf=1 m=1
M23 VB3 VB6 VDD VDD pch l=0.15 w=1 nf=1 m=1
M24 VB3 VB3 VSS VSS nch l=0.15 w=1 nf=1 m=1
M3 net4 VB1 VDD VDD pch l=0.15 w=1 nf=1 m=1
M4 net7 net3 VDD VDD pch l=0.15 w=1 nf=1 m=1
M5 INP net3 VDD VDD pch l=0.15 w=1 nf=1 m=1
M6 net3 VB2 net7 VDD pch l=0.15 w=1 nf=1 m=1
M7 OUT VB2 INP VDD pch l=0.15 w=1 nf=1 m=1
M8 net3 VB4 VE VSS nch l=0.15 w=1 nf=1 m=1
M9 OUT VB4 net1 VSS nch l=0.15 w=1 nf=1 m=1
.ends opamp

.subckt dut VDD VSS Vout
Q1 VSS VSS VE qpnp m=1
Q2 VE VE X qpnp m=1
Q3 VSS VSS net1 qpnp m=1
Q4 net1 net1 net0 qpnp m=1
R1 Vout X 1k
R2 Vout Y 1k
R3 Y net0 1k
X1 VDD VSS X Y Vout VE opamp
.ends dut
