* official Analog Canvas netlist; PDK X cards rewritten by convert.py
.model nch nmos
.model pch pmos

.subckt dut VDD VSS VIN VOUT VB1 VB2 VREF VB3 VB4 VB5 VB6
CF1 VOUT VFB 1p
Cm1 VOUT net7 1p
Cm2 net9 net7 1p
M10 net4 net3 VSS VSS nch l=0.15 w=1 nf=1 m=1
M11 net0 VB8 VSS VSS nch l=0.15 w=1 nf=1 m=1
M12 net13 VFB net0 VSS nch l=0.15 w=1 nf=1 m=1
M13 VX VREF net0 VSS nch l=0.15 w=1 nf=1 m=1
M14 net13 VB1 VIN VDD pch l=0.15 w=1 nf=1 m=1
M15 VX VB1 VIN VDD pch l=0.15 w=1 nf=1 m=1
M16 net7 VB2 net13 VDD pch l=0.15 w=1 nf=1 m=1
M17 net3 VB2 VX VDD pch l=0.15 w=1 nf=1 m=1
M18 net7 VB7 net11 VSS nch l=0.15 w=1 nf=1 m=1
M19 net3 VB7 net4 VSS nch l=0.15 w=1 nf=1 m=1
M20 net11 net3 VSS VSS nch l=0.15 w=1 nf=1 m=1
M21 net6 net7 VSS VSS nch l=0.15 w=1 nf=1 m=1
M22 net12 net2 VSS VSS nch l=0.15 w=1 nf=1 m=1
M23 net6 net6 VIN VDD pch l=0.15 w=1 nf=1 m=1
M24 net12 net6 VIN VDD pch l=0.15 w=1 nf=1 m=1
M25 net2 VB4 VIN VDD pch l=0.15 w=1 nf=1 m=1
M26 net2 net2 VSS VSS nch l=0.15 w=1 nf=1 m=1
M27 net2 net7 VSS VSS nch l=0.15 w=1 nf=1 m=1
M31 VB7 VB7 VB8 VSS nch l=0.15 w=1 nf=1 m=1
M32 VB8 VB8 VSS VSS nch l=0.15 w=1 nf=1 m=1
M33 VB7 net1 VIN VDD pch l=0.15 w=1 nf=1 m=1
M34 net1 net1 VIN VDD pch l=0.15 w=1 nf=1 m=1
M35 VB3 net1 VIN VDD pch l=0.15 w=1 nf=1 m=1
M36 VB3 VB3 VSS VSS nch l=0.15 w=1 nf=1 m=1
M37 net1 VB3 net10 VSS nch l=0.15 w=1 nf=1 m=1
MD1 net9 net7 VSS VSS nch l=0.15 w=1 nf=1 m=1
MD2 net8 VB5 VSS VSS nch l=0.15 w=1 nf=1 m=1
MD3 VX net9 net8 VSS nch l=0.15 w=1 nf=1 m=1
MD4 net5 VB6 net8 VSS nch l=0.15 w=1 nf=1 m=1
MD5 VX VX VIN VDD pch l=0.15 w=1 nf=1 m=1
MD6 net5 net5 VIN VDD pch l=0.15 w=1 nf=1 m=1
MD7 net9 net5 VIN VDD pch l=0.15 w=1 nf=1 m=1
MPT VOUT net12 VIN VDD pch l=0.15 w=1 nf=1 m=1
RB net10 VSS 1k
RF1 VOUT VFB 1k
RF2 VFB VSS 1k
.ends dut
