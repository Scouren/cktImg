* official Analog Canvas netlist; PDK X cards rewritten by convert.py
.model nch nmos
.model pch pmos

.subckt Bias VDD VSS VBN
M13 VB2 VB2 VDD VDD pch l=0.15 w=1 nf=1 m=1
M14 net0 VB2 VDD VDD pch l=0.15 w=1 nf=1 m=1
M15 VB1 VB1 VDD VDD pch l=0.15 w=1 nf=1 m=1
M16 VBN VB1 VDD VDD pch l=0.15 w=1 nf=1 m=1
M17 VB2 net0 VSS VSS nch l=0.15 w=1 nf=1 m=1
M18 net0 net0 VSS VSS nch l=0.15 w=1 nf=1 m=1
M19 VB1 net0 VSS VSS nch l=0.15 w=1 nf=1 m=1
M20 VBN VBN VSS VSS nch l=0.15 w=1 nf=1 m=1
.ends Bias

.subckt dut VDD VSS VIN VOUT VREF
M1 net3 VEA VIN VDD pch l=0.15 w=1 nf=1 m=1
M10 VEA VEA VSS VSS nch l=0.15 w=1 nf=1 m=1
M11 net0 VEA net4 VSS nch l=0.15 w=1 nf=1 m=1
M12 net4 net7 VSS VSS nch l=0.15 w=1 nf=1 m=1
M2 net6 net6 net3 VDD pch l=0.15 w=1 nf=1 m=1
M3 net6 nb VSS VSS nch l=0.15 w=1 nf=1 m=1
M4 net2 net2 VDD VDD pch l=0.15 w=1 nf=1 m=1
M5 VEA net2 VDD VDD pch l=0.15 w=1 nf=1 m=1
M6 VEA net0 VDD VDD pch l=0.15 w=1 nf=1 m=1
M7 net0 net0 VDD VDD pch l=0.15 w=1 nf=1 m=1
M8 net2 VREF net4 VSS nch l=0.15 w=1 nf=1 m=1
M9 VEA VEA VSS VSS nch l=0.15 w=1 nf=1 m=1
MBIAS VERR nb VSS VSS nch l=0.15 w=1 nf=1 m=1
MCHG net5 pb VIN VDD pch l=0.15 w=1 nf=1 m=1
MCTRL VERR net6 VOUT VDD pch l=0.15 w=1 nf=1 m=1
MGEN net1 net1 VSS VSS nch l=0.15 w=1 nf=1 m=1
MINJ VERR net1 VSS VSS nch l=0.15 w=1 nf=1 m=1
MRES VOUT VERR VIN VDD pch l=0.15 w=1 nf=1 m=1
MSEN net1 VEA net5 VDD pch l=0.15 w=1 nf=1 m=1
X1 VDD VSS net7 Bias
.ends dut
