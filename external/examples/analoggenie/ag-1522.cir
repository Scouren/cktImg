* official Analog Canvas netlist; PDK X cards rewritten by convert.py
.model nch nmos
.model pch pmos
.model qnpn npn

.subckt dut VDD VSS Vout VB1
M1 net0 Y net4 VSS nch l=0.15 w=1 nf=1 m=1
M10 VB2 VC VDD VDD pch l=0.15 w=1 nf=1 m=1
M11 VC VC VDD VDD pch l=0.15 w=1 nf=1 m=1
M12 net1 VC VDD VDD pch l=0.15 w=1 nf=1 m=1
M13 VB1 VC VDD VDD pch l=0.15 w=1 nf=1 m=1
M14 VC VB1 net3 VSS nch l=0.15 w=1 nf=1 m=1
M15 VB2 VB2 VSS VSS nch l=0.15 w=1 nf=1 m=1
M16 net3 net1 VSS VSS nch l=0.15 w=1 nf=1 m=1
M17 net1 net1 VSS VSS nch l=0.15 w=1 nf=1 m=1
M18 VB1 VB1 VSS VSS nch l=0.15 w=1 nf=1 m=1
M2 net2 X net4 VSS nch l=0.15 w=1 nf=1 m=1
M3 net2 net2 VDD VDD pch l=0.15 w=1 nf=1 m=1
M4 net0 net0 VDD VDD pch l=0.15 w=1 nf=1 m=1
M5 Vout net2 VDD VDD pch l=0.15 w=1 nf=1 m=1
M6 Z net0 VDD VDD pch l=0.15 w=1 nf=1 m=1
M7 net4 VB2 VSS VSS nch l=0.15 w=1 nf=1 m=1
M8 Z Z VSS VSS nch l=0.15 w=1 nf=1 m=1
M9 Vout Z VSS VSS nch l=0.15 w=1 nf=1 m=1
Q1 X X VSS VSS qnpn m=1
Q2 Z Z VSS VSS qnpn m=1
R1 Vout X 1k
R2 Vout Y 1k
R3 Y Z 1k
.ends dut
