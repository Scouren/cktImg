* official Analog Canvas netlist; PDK X cards rewritten by convert.py
.model nch nmos
.model pch pmos
.model qnpn npn

.subckt A1 VDD VSS INP INN OUT Z
M10 net5 VB3 net1 VDD pch l=0.15 w=1 nf=1 m=1
M11 OUT VB3 net3 VDD pch l=0.15 w=1 nf=1 m=1
M12 net5 VB5 net0 VSS nch l=0.15 w=1 nf=1 m=1
M13 OUT VB5 net6 VSS nch l=0.15 w=1 nf=1 m=1
M14 net0 VB2 VSS VSS nch l=0.15 w=1 nf=1 m=1
M15 net6 VB2 VSS VSS nch l=0.15 w=1 nf=1 m=1
M16 VB5 net4 VDD VDD pch l=0.15 w=1 nf=1 m=1
M17 net4 net4 VDD VDD pch l=0.15 w=1 nf=1 m=1
M18 net2 net4 VDD VDD pch l=0.15 w=1 nf=1 m=1
M19 VB5 VB5 Z VSS nch l=0.15 w=1 nf=1 m=1
M20 Z VB5 VSS VSS nch l=0.15 w=1 nf=1 m=1
M21 net4 net2 VB4 VSS nch l=0.15 w=1 nf=1 m=1
M22 net2 VB4 VSS VSS nch l=0.15 w=1 nf=1 m=1
M5 net2 VB1 VDD VDD pch l=0.15 w=1 nf=1 m=1
M6 net0 INP net2 VDD pch l=0.15 w=1 nf=1 m=1
M7 net6 INN net2 VDD pch l=0.15 w=1 nf=1 m=1
M8 net1 net5 VDD VDD pch l=0.15 w=1 nf=1 m=1
M9 net3 net5 VDD VDD pch l=0.15 w=1 nf=1 m=1
R4 VB4 VSS 1k
.ends A1

.subckt dut VDD VSS Vout
Q1 X X VSS VSS qnpn m=1
Q2 net0 net0 VSS VSS qnpn m=1
R1 Vout X 1k
R2 Vout Y 1k
R3 Y net0 1k
X1 VDD VSS X Y Vout net0 A1
.ends dut
