* official Analog Canvas netlist; PDK X cards rewritten by convert.py
.model nch nmos
.model pch pmos

.subckt dut VDD VSS VB1 VIN VOUT VERR pb VY VB2
M1 net1 VEA VIN VDD pch l=0.15 w=1 nf=1 m=1
M10 net3 VB1 net0 VDD pch l=0.15 w=1 nf=1 m=1
M11 VEA VB1 net12 VDD pch l=0.15 w=1 nf=1 m=1
M12 net11 VY net7 VSS nch l=0.15 w=1 nf=1 m=1
M13 VCTRL VEA net14 VSS nch l=0.15 w=1 nf=1 m=1
M14 net3 VREF net14 VSS nch l=0.15 w=1 nf=1 m=1
M15 VEA VY net6 VSS nch l=0.15 w=1 nf=1 m=1
M16 net7 net11 VSS VSS nch l=0.15 w=1 nf=1 m=1
M17 net14 VB2 VSS VSS nch l=0.15 w=1 nf=1 m=1
M18 net6 net11 VSS VSS nch l=0.15 w=1 nf=1 m=1
M19 VY VX VDD VDD pch l=0.15 w=1 nf=1 m=1
M2 VCTRL VCTRL net1 VDD pch l=0.15 w=1 nf=1 m=1
M20 VY VY VEA VSS nch l=0.15 w=1 nf=1 m=1
M21 VEA VY VSS VSS nch l=0.15 w=1 nf=1 m=1
M22 net2 VX VDD VDD pch l=0.15 w=1 nf=1 m=1
M23 VX VX VDD VDD pch l=0.15 w=1 nf=1 m=1
M24 net10 VX VDD VDD pch l=0.15 w=1 nf=1 m=1
M25 VX net10 net8 VSS nch l=0.15 w=1 nf=1 m=1
M26 net2 net2 VSS VSS nch l=0.15 w=1 nf=1 m=1
M27 net8 net2 VSS VSS nch l=0.15 w=1 nf=1 m=1
M28 net10 net10 VSS VSS nch l=0.15 w=1 nf=1 m=1
M3 VCTRL nb VSS VSS nch l=0.15 w=1 nf=1 m=1
M4 net5 VCTRL VDD VDD pch l=0.15 w=1 nf=1 m=1
M5 net13 VCTRL VDD VDD pch l=0.15 w=1 nf=1 m=1
M6 net0 net3 VDD VDD pch l=0.15 w=1 nf=1 m=1
M7 net12 net3 VDD VDD pch l=0.15 w=1 nf=1 m=1
M8 net11 VB1 net5 VDD pch l=0.15 w=1 nf=1 m=1
M9 VCTRL VB1 net13 VDD pch l=0.15 w=1 nf=1 m=1
MBIAS VERR nb VSS VSS nch l=0.15 w=1 nf=1 m=1
MCHG net4 pb VIN VDD pch l=0.15 w=1 nf=1 m=1
MCTRL VERR VCTRL VOUT VDD pch l=0.15 w=1 nf=1 m=1
MGEN net9 net9 VSS VSS nch l=0.15 w=1 nf=1 m=1
MINJ VERR net9 VSS VSS nch l=0.15 w=1 nf=1 m=1
MRES VOUT VERR VIN VDD pch l=0.15 w=1 nf=1 m=1
MSEN net9 VEA net4 VDD pch l=0.15 w=1 nf=1 m=1
.ends dut
