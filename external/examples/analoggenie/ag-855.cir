* official Analog Canvas netlist; PDK X cards rewritten by convert.py
.model qnpn npn
.model qpnp pnp

.subckt dut VCC VSS IBIAS2 IBIAS1
.model DIODE D(IS=1e-14 N=1)
D1 net0 net4 DIODE
D2 net0 net2 DIODE
D3 net2 net1 DIODE
D4 net1 net7 DIODE
D5 net7 VSS DIODE
Q1 net3 net6 VSS VSS qnpn m=1
Q2 net5 net3 net6 VSS qnpn m=1
Q3 IBIAS1 net6 VSS VSS qnpn m=1
Q4 net4 net5 VCC qpnp m=1
Q5 net5 net5 VCC qpnp m=1
Q6 IBIAS2 net5 VCC qpnp m=1
R net6 VSS 1k
Rs VCC net0 1k
Rx net4 net3 1k
.ends dut
