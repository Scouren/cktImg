* official Analog Canvas netlist; PDK X cards rewritten by convert.py
.model nch nmos

.subckt dut VDD VSS Iout
IB1 VDD net3 DC 1m
IB2 VDD net0 DC 1m
Iin VDD net1 DC 1m
M1 Iout net3 net2 VSS nch l=0.15 w=1 nf=1 m=1
M2 net2 net1 VSS VSS nch l=0.15 w=1 nf=1 m=1
M3 net3 net2 VSS VSS nch l=0.15 w=1 nf=1 m=1
M4 net1 net0 net4 VSS nch l=0.15 w=1 nf=1 m=1
M5 net4 net1 VSS VSS nch l=0.15 w=1 nf=1 m=1
M6 net0 net4 VSS VSS nch l=0.15 w=1 nf=1 m=1
.ends dut
