* official Analog Canvas netlist; PDK X cards rewritten by convert.py
.model nch nmos
.model pch pmos

.subckt dut VDD VSS VREF VB3 IB VIN VOUT
CL VOUT net4 1p
M1 net1 net1 VDD VDD pch l=0.15 w=1 nf=1 m=1
M13 net7 VB3 VDD VDD pch l=0.15 w=1 nf=1 m=1
M14 VX EAO net7 VDD pch l=0.15 w=1 nf=1 m=1
M15 VX VX VSS VSS nch l=0.15 w=1 nf=1 m=1
M16 GATE VX VSS VSS nch l=0.15 w=1 nf=1 m=1
M17 VDD net7 GATE VSS nch l=0.15 w=1 nf=1 m=1
M18 net3 EAO IB VSS nch l=0.15 w=1 nf=1 m=1
M19 net3 net3 VDD VDD pch l=0.15 w=1 nf=1 m=1
M2 net6 net6 VDD VDD pch l=0.15 w=1 nf=1 m=1
M20 GATE net3 VDD VDD pch l=0.15 w=1 nf=1 m=1
M21 VSS IB GATE VDD pch l=0.15 w=1 nf=1 m=1
M22 net5 VB2 VDD VDD pch l=0.15 w=1 nf=1 m=1
M23 net5 net2 VSS VSS nch l=0.15 w=1 nf=1 m=1
M24 VB2 VB2 VDD VDD pch l=0.15 w=1 nf=1 m=1
M25 VB2 net5 net2 VSS nch l=0.15 w=1 nf=1 m=1
M26 VB1 VB1 VDD VDD pch l=0.15 w=1 nf=1 m=1
M27 VB1 net2 VSS VSS nch l=0.15 w=1 nf=1 m=1
M28 VB4 VB1 VDD VDD pch l=0.15 w=1 nf=1 m=1
M29 VB4 VB4 VSS VSS nch l=0.15 w=1 nf=1 m=1
M3 net1 VREF VX VSS nch l=0.15 w=1 nf=1 m=1
M4 net6 FB VX VSS nch l=0.15 w=1 nf=1 m=1
M5 VX VB4 VSS VSS nch l=0.15 w=1 nf=1 m=1
M6 net0 net0 VSS VSS nch l=0.15 w=1 nf=1 m=1
M7 EAO net0 VSS VSS nch l=0.15 w=1 nf=1 m=1
M8 EAO net1 VDD VDD pch l=0.15 w=1 nf=1 m=1
M9 net0 net6 VDD VDD pch l=0.15 w=1 nf=1 m=1
MNP VIN GATE VOUT VSS nch l=0.15 w=1 nf=1 m=1
R1 FB VSS 1k
R2 VOUT FB 1k
R3 net4 VSS 1k
R4 net2 VSS 1k
RL VOUT VSS 1k
.ends dut
