* official Analog Canvas netlist; PDK X cards rewritten by convert.py
.model nch nmos
.model pch pmos

.subckt bias VDD VSS VIN VCN
MB1 net1 VBP VIN VDD pch l=0.15 w=1 nf=1 m=1
MB10 net0 VCN VSS VSS nch l=0.15 w=1 nf=1 m=1
MB2 net1 net1 VSS VSS nch l=0.15 w=1 nf=1 m=1
MB3 VBP VBP VIN VDD pch l=0.15 w=1 nf=1 m=1
MB4 VBP VB5 VB4 VSS nch l=0.15 w=1 nf=1 m=1
MB5 VB4 net1 VSS VSS nch l=0.15 w=1 nf=1 m=1
MB6 VB5 VBP VIN VDD pch l=0.15 w=1 nf=1 m=1
MB7 VB5 VB4 VSS VSS nch l=0.15 w=1 nf=1 m=1
MB8 VCN VBP VIN VDD pch l=0.15 w=1 nf=1 m=1
MB9 VCN VCN net0 VSS nch l=0.15 w=1 nf=1 m=1
.ends bias

.subckt dut VDD VSS VB1 VREF VB3 VB2 VB6 VB7 VOUT VIN
CF1 VOUT VFB 1p
Cm1 VOUT net2 1p
Cm2 VZ net2 1p
M11 net8 VB1 VIN VDD pch l=0.15 w=1 nf=1 m=1
M12 net7 VFB net8 VDD pch l=0.15 w=1 nf=1 m=1
M13 net6 VREF net8 VDD pch l=0.15 w=1 nf=1 m=1
M14 net7 VB2 VSS VSS nch l=0.15 w=1 nf=1 m=1
M15 net6 VB2 VSS VSS nch l=0.15 w=1 nf=1 m=1
M16 VG VB6 VIN VDD pch l=0.15 w=1 nf=1 m=1
M17 VG net2 VSS VSS nch l=0.15 w=1 nf=1 m=1
M18 VG VG VSS VSS nch l=0.15 w=1 nf=1 m=1
M21 net4 net2 VSS VSS nch l=0.15 w=1 nf=1 m=1
M22 net3 VG VSS VSS nch l=0.15 w=1 nf=1 m=1
M23 net4 net4 VIN VDD pch l=0.15 w=1 nf=1 m=1
M24 net3 net4 VIN VDD pch l=0.15 w=1 nf=1 m=1
M25 VY VX VIN VDD pch l=0.15 w=1 nf=1 m=1
M26 net0 VX VIN VDD pch l=0.15 w=1 nf=1 m=1
M27 VX VB3 VY VDD pch l=0.15 w=1 nf=1 m=1
M28 net2 VB3 net0 VDD pch l=0.15 w=1 nf=1 m=1
M29 VX VCN net7 VSS nch l=0.15 w=1 nf=1 m=1
M30 net2 VCN net6 VSS nch l=0.15 w=1 nf=1 m=1
MD1 VZ net2 VSS VSS nch l=0.15 w=1 nf=1 m=1
MD2 VY VB7 VSS VSS nch l=0.15 w=1 nf=1 m=1
MD3 net1 VZ VY VSS nch l=0.15 w=1 nf=1 m=1
MD4 net5 VB8 VY VSS nch l=0.15 w=1 nf=1 m=1
MD5 VZ net5 VIN VDD pch l=0.15 w=1 nf=1 m=1
MD6 net5 net5 VIN VDD pch l=0.15 w=1 nf=1 m=1
MD7 net1 net1 VIN VDD pch l=0.15 w=1 nf=1 m=1
MPT VOUT net3 VIN VDD pch l=0.15 w=1 nf=1 m=1
RF1 VOUT VFB 1k
RF2 VFB VSS 1k
X1 VDD VSS VIN VCN bias
.ends dut
