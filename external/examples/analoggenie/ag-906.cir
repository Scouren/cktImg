* official Analog Canvas netlist; PDK X cards rewritten by convert.py
.model nch nmos
.model pch pmos

.subckt dut VDD VSS GND vo
I1 net1 net0 DC 100uA
M1 VDD net3 net4 VSS nch l=1 w=40 nf=1 m=1
M2 net2 net5 net4 VSS nch l=1 w=40 nf=1 m=1
M3 net2 net1 VDD VDD pch l=1 w=20 nf=1 m=1
M4 net1 net1 VDD VDD pch l=1 w=20 nf=1 m=1
M5 net0 net0 VSS VSS nch l=1 w=20 nf=1 m=1
M6 net4 net0 VSS VSS nch l=1 w=40 nf=1 m=1
M7 vo net0 VSS VSS nch l=1 w=40 nf=1 m=1
M8 VDD net2 vo VSS nch l=1 w=40 nf=1 m=1
R1 vo net5 20kΩ
R2 net5 GND 1kΩ
Vi net3 GND DC 1
.ends dut
