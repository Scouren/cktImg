* official Analog Canvas netlist; PDK X cards rewritten by convert.py
.model nch nmos
.model pch pmos

.subckt opamp VDD VSS INN INP OUT
C3 net3 OUT 1p
M10 OUT VB2 VSS VSS nch l=0.15 w=1 nf=1 m=1
M11 net5 net1 VDD VDD pch l=0.15 w=1 nf=1 m=1
M12 net5 net5 VSS VSS nch l=0.15 w=1 nf=1 m=1
M13 net1 net5 VSS VSS nch l=0.15 w=1 nf=1 m=1
M14 net0 net5 VSS VSS nch l=0.15 w=1 nf=1 m=1
M15 net0 net0 VDD VDD pch l=0.15 w=1 nf=1 m=1
M16 VB2 net0 VDD VDD pch l=0.15 w=1 nf=1 m=1
M17 VB2 VB2 VSS VSS nch l=0.15 w=1 nf=1 m=1
M18 VB1 VB2 VSS VSS nch l=0.15 w=1 nf=1 m=1
M19 VB1 VB1 VDD VDD pch l=0.15 w=1 nf=1 m=1
M4 net4 net4 VDD VDD pch l=0.15 w=1 nf=1 m=1
M5 net3 net4 VDD VDD pch l=0.15 w=1 nf=1 m=1
M6 net4 INN net2 VSS nch l=0.15 w=1 nf=1 m=1
M7 net3 INP net2 VSS nch l=0.15 w=1 nf=1 m=1
M8 net2 VB2 VSS VSS nch l=0.15 w=1 nf=1 m=1
M9 OUT net3 VDD VDD pch l=0.15 w=1 nf=1 m=1
R1 VDD net5 1k
R2 VDD net1 1k
.ends opamp

.subckt dut VDD VSS vci phi1 phi2 vco
C1 vcx VSS 1p
C2 net0 vco 1p
M1 vci phi1 vcx VSS nch l=0.15 w=1 nf=1 m=1
M2 vcx phi2 net0 VSS nch l=0.15 w=1 nf=1 m=1
X1 VDD VSS net0 VSS vco opamp
.ends dut
