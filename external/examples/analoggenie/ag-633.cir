* official Analog Canvas netlist; PDK X cards rewritten by convert.py
.model nch nmos
.model pch pmos

.subckt dut Vcc VSS In Ref Out
Ibias Vcc net0 DC 20uA
M1 net4 In net1 VSS nch l=0.15 w=1 nf=1 m=1
M10 Out net5 VSS VSS nch l=0.15 w=1 nf=1 m=1
M11 net0 net0 VSS VSS nch l=0.15 w=1 nf=1 m=1
M12 net1 net0 VSS VSS nch l=0.15 w=1 nf=1 m=1
M13 net5 net0 VSS VSS nch l=0.15 w=1 nf=1 m=1
M2 net3 net2 net1 VSS nch l=0.15 w=1 nf=1 m=1
M3 net4 net4 Vcc Vcc pch l=0.15 w=1 nf=1 m=1
M4 net3 net4 Vcc Vcc pch l=0.15 w=1 nf=1 m=1
M5 net4 net3 Vcc Vcc pch l=0.15 w=1 nf=1 m=1
M6 net3 net3 Vcc Vcc pch l=0.15 w=1 nf=1 m=1
M7 net2 net3 Vcc Vcc pch l=0.15 w=1 nf=1 m=1
M8 net5 net3 Vcc Vcc pch l=0.15 w=1 nf=1 m=1
M9 Out net5 Vcc Vcc pch l=0.15 w=1 nf=1 m=1
R1 net2 Ref 1kΩ
.ends dut
