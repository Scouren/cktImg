* official Analog Canvas netlist; PDK X cards rewritten by convert.py
.model nch nmos
.model pch pmos

.subckt dut VDD VSS VIN VP VCONT1 VCONT2 VCONT3 VCONT4 VCONT5 VB4 VB1 VB2 VREF
.model DIODE D(IS=1e-14 N=1)
CFLY VX1 VX2 1p
CO VP VN 1p
COP VP VSS 1p
D1 VN VX2 DIODE
L1 VX1 net7 1n
M1 VX1 VCONT2 VIN VDD pch l=0.15 w=1 nf=1 m=1
M2 VX2 VCONT3 VIN VDD pch l=0.15 w=1 nf=1 m=1
M3 VP VCONT5 net7 VDD pch l=0.15 w=1 nf=1 m=1
M4 net7 VCONT4 VSS VSS nch l=0.15 w=1 nf=1 m=1
M5 VS VCONT1 VIN VDD pch l=0.15 w=1 nf=1 m=1
MN1 net4 VREF net1 VSS nch l=0.15 w=1 nf=1 m=1
MN10 VX1 VX4 VSS VSS nch l=0.15 w=1 nf=1 m=1
MN11 net5 VX4 VSS VSS nch l=0.15 w=1 nf=1 m=1
MN12 VBN VBN net6 VSS nch l=0.15 w=1 nf=1 m=1
MN13 net6 VBN VSS VSS nch l=0.15 w=1 nf=1 m=1
MN14 VBP VB3 VX2 VSS nch l=0.15 w=1 nf=1 m=1
MN15 VB3 VB3 VSS VSS nch l=0.15 w=1 nf=1 m=1
MN16 VS VS VSS VSS nch l=0.15 w=1 nf=1 m=1
MN17 VX2 VS VSS VSS nch l=0.15 w=1 nf=1 m=1
MN2 net3 VFP1 net1 VSS nch l=0.15 w=1 nf=1 m=1
MN3 net2 VB4 VSS VSS nch l=0.15 w=1 nf=1 m=1
MN4 net1 VB2 VSS VSS nch l=0.15 w=1 nf=1 m=1
MN6 VG net2 VSS VSS nch l=0.15 w=1 nf=1 m=1
MN7 net2 net2 VSS VSS nch l=0.15 w=1 nf=1 m=1
MN8 VX4 VBN VX1 VSS nch l=0.15 w=1 nf=1 m=1
MN9 VCTRL VBN net5 VSS nch l=0.15 w=1 nf=1 m=1
MP1 net8 net3 VDD VDD pch l=0.15 w=1 nf=1 m=1
MP10 VCTRL VB1 net0 VDD pch l=0.15 w=1 nf=1 m=1
MP11 net2 VCTRL VS VDD pch l=0.15 w=1 nf=1 m=1
MP12 VBN VBP VDD VDD pch l=0.15 w=1 nf=1 m=1
MP13 VBP VBP VDD VDD pch l=0.15 w=1 nf=1 m=1
MP14 VB3 VBP VDD VDD pch l=0.15 w=1 nf=1 m=1
MP15 VS VBP VDD VDD pch l=0.15 w=1 nf=1 m=1
MP2 VN net4 VDD VDD pch l=0.15 w=1 nf=1 m=1
MP3 VFP1 net3 VDD VDD pch l=0.15 w=1 nf=1 m=1
MP4 VG VG VS VDD pch l=0.15 w=1 nf=1 m=1
MP5 VX1 VG VS VDD pch l=0.15 w=1 nf=1 m=1
MP6 net0 net4 VDD VDD pch l=0.15 w=1 nf=1 m=1
MP7 net3 VB1 net8 VDD pch l=0.15 w=1 nf=1 m=1
MP8 net4 VB1 VN VDD pch l=0.15 w=1 nf=1 m=1
MP9 VX4 VB1 VFP1 VDD pch l=0.15 w=1 nf=1 m=1
R1 VP VFP1 1k
R2 VFP1 VSS 1k
.ends dut
