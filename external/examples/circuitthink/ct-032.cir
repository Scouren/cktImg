* official Analog Canvas netlist; PDK X cards rewritten by convert.py
.model nch nmos
.model pch pmos

.subckt dut VDD VSS + - out1 out2
ISS net0 VSS DC 1m
M1 out1 + net0 VSS nch l=0.15 w=1 nf=1 m=1
M2 out2 - net0 VSS nch l=0.15 w=1 nf=1 m=1
M3 out1 out2 VDD VDD pch l=0.15 w=1 nf=1 m=1
M4 out2 out1 VDD VDD pch l=0.15 w=1 nf=1 m=1
M5 out1 out1 VDD VDD pch l=0.15 w=1 nf=1 m=1
M6 out2 out2 VDD VDD pch l=0.15 w=1 nf=1 m=1
.ends dut
