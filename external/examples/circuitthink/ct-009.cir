* official Analog Canvas netlist; PDK X cards rewritten by convert.py
.model nch nmos

.subckt dut VDD VSS
C1 VDD net4 1p
CB net1 VSS 1p
IREF VDD net1 DC 1m
L1 VDD net4 1n
LB net3 VSS 1n
M1 net0 net1 net3 VSS nch l=0.15 w=1 nf=1 m=1
M2 net4 VDD net0 VSS nch l=0.15 w=1 nf=1 m=1
MB net1 net1 VSS VSS nch l=0.15 w=1 nf=1 m=1
R1 VDD net4 1k
RS net3 net2 1k
Vin net2 VSS DC 1
.ends dut
