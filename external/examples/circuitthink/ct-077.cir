* official Analog Canvas netlist; PDK X cards rewritten by convert.py
.model nch nmos
.model pch pmos

.subckt dut VDD VSS Vout
CF Vout X 1p
CL Vout VSS 1p
Ialpha net0 VSS DC 1m
Iin X VSS DC 1m
Mout Vout X VSS VSS nch l=0.15 w=1 nf=1 m=1
Mp1 Vout net0 VDD VDD pch l=0.15 w=1 nf=1 m=1
Mp2 net0 net0 VDD VDD pch l=0.15 w=1 nf=1 m=1
.ends dut
