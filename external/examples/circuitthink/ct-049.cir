* official Analog Canvas netlist; PDK X cards rewritten by convert.py
.model nch nmos
.model pch pmos

.subckt dut VDD VSS Vout Vin
CC net2 Vout 1p
I1 Vout VSS DC 1m
ISS net1 VSS DC 1m
M1 net2 Vin net1 VSS nch l=0.15 w=1 nf=1 m=1
M2 net0 Vout net1 VSS nch l=0.15 w=1 nf=1 m=1
M3 net2 net0 VDD VDD pch l=0.15 w=1 nf=1 m=1
M4 net0 net0 VDD VDD pch l=0.15 w=1 nf=1 m=1
M5 Vout net2 VDD VDD pch l=0.15 w=1 nf=1 m=1
.ends dut
