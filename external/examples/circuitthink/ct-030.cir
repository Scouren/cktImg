* official Analog Canvas netlist; PDK X cards rewritten by convert.py
.model nch nmos

.subckt dut VDD VSS
CB net3 VSS 1p
CT net2 VSS 1p
In net2 VSS DC 1m
ISS net2 VSS DC 1m
L1 VDD net0 1n
L2 VDD net1 1n
LT net3 net2 1n
M1 net0 net1 net3 VSS nch l=0.15 w=1 nf=1 m=1
M2 net1 net0 net3 VSS nch l=0.15 w=1 nf=1 m=1
.ends dut
