* official Analog Canvas netlist; PDK X cards rewritten by convert.py
.model nch nmos
.model pch pmos

.subckt dut VDD VSS Vcont
Is net2 VSS DC 1m
L1 net1 net2 1n
L2 net0 net2 1n
M3 net1 net0 VDD VDD pch l=0.15 w=1 nf=1 m=1
M4 net0 net1 VDD VDD pch l=0.15 w=1 nf=1 m=1
Mv1 Vcont net1 Vcont Vcont nch l=0.15 w=1 nf=1 m=1
Mv2 Vcont net0 Vcont Vcont nch l=0.15 w=1 nf=1 m=1
.ends dut
