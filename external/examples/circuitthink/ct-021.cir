* official Analog Canvas netlist; PDK X cards rewritten by convert.py
.model nch nmos
.model pch pmos

.subckt dut VDD VSS + -
CL net1 VSS 1p
CL2 net3 VSS 1p
M1 net3 + VSS VSS nch l=0.15 w=1 nf=1 m=1
M2 net3 net2 VDD VDD pch l=0.15 w=1 nf=1 m=1
M3 net1 - VSS VSS nch l=0.15 w=1 nf=1 m=1
M4 net1 net0 VDD VDD pch l=0.15 w=1 nf=1 m=1
M5 net0 + VSS VSS nch l=0.15 w=1 nf=1 m=1
M6 net2 - VSS VSS nch l=0.15 w=1 nf=1 m=1
M7 net2 net2 VDD VDD pch l=0.15 w=1 nf=1 m=1
M8 net0 net0 VDD VDD pch l=0.15 w=1 nf=1 m=1
.ends dut
