* official Analog Canvas netlist; PDK X cards rewritten by convert.py
.model nch nmos
.model pch pmos

.subckt dut VDD VSS Vout
C1 net2 VSS 1p
C2 Vout net5 1p
C3 net1 net3 1p
I1 VDD net2 DC 1m
I2 VDD Vout DC 1m
M1 net0 net1 VSS VSS nch l=0.15 w=1 nf=1 m=1
M2 net0 net1 net2 VDD pch l=0.15 w=1 nf=1 m=1
M3 VSS net0 Vout VDD pch l=0.15 w=1 nf=1 m=1
RF net0 net1 1k
RM net5 net1 1k
RS net3 net4 1k
Vin net4 VSS DC 1
.ends dut
