* official Analog Canvas netlist; PDK X cards rewritten by convert.py
.model nch nmos
.model pch pmos

.subckt dut VDD VSS Vout
C1 net3 VSS 1p
Cs net0 net2 1p
I1 VDD net3 DC 1m
M1 Vout net0 VSS VSS nch l=0.15 w=1 nf=1 m=1
M2 Vout net0 net3 VDD pch l=0.15 w=1 nf=1 m=1
RF Vout net0 1k
RS net2 net1 1k
Vin net1 VSS DC 1
.ends dut
