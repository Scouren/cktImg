* official Analog Canvas netlist; PDK X cards rewritten by convert.py
.model nch nmos
.model pch pmos

.subckt dut VDD VSS + - Vout1 Vout2
CL1 Vout1 VSS 1p
CL2 Vout2 VSS 1p
ISS net2 VSS DC 1m
M1 net0 + net2 VSS nch l=0.15 w=1 nf=1 m=1
M2 net1 - net2 VSS nch l=0.15 w=1 nf=1 m=1
M3 net0 net0 VDD VDD pch l=0.15 w=1 nf=1 m=1
M4 net1 net1 VDD VDD pch l=0.15 w=1 nf=1 m=1
M5 Vout1 net0 VDD VDD pch l=0.15 w=1 nf=1 m=1
M6 Vout2 net1 VDD VDD pch l=0.15 w=1 nf=1 m=1
RD1 Vout1 VSS 1k
RD2 Vout2 VSS 1k
.ends dut
