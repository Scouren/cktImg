* official Analog Canvas netlist; PDK X cards rewritten by convert.py
.model nch nmos

.subckt dut VDD VSS VF
CGS2 VF VSS 1p
M1 VF VSS net2 VSS nch l=0.15 w=1 nf=1 m=1
M2 net1 net0 VSS VSS nch l=0.15 w=1 nf=1 m=1
R1 net1 net2 1k
R2 net2 VSS 1k
RD1 VDD VF 1k
RD2 VDD net1 1k
Vt net0 VSS DC 1
.ends dut
