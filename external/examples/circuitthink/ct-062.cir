* official Analog Canvas netlist; PDK X cards rewritten by convert.py
.model nch nmos
.model pch pmos

.subckt dut VDD VSS
M1 net0 net0 VSS VSS nch l=0.15 w=1 nf=1 m=1
M2 net3 net0 net2 VSS nch l=0.15 w=1 nf=1 m=1
M3 net3 net3 VDD VDD pch l=0.15 w=1 nf=1 m=1
M4 net0 net3 VDD VDD pch l=0.15 w=1 nf=1 m=1
M5 net3 X VSS VSS nch l=0.15 w=1 nf=1 m=1
M6 X net1 VSS VSS nch l=0.15 w=1 nf=1 m=1
Ra VDD net1 1k
Rb net1 X 1k
RS net2 VSS 1k
.ends dut
