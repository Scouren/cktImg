* official Analog Canvas netlist; PDK X cards rewritten by convert.py
.model nch nmos
.model pch pmos

.subckt dut VDD VSS Vout Vin Vb
C1 net0 VSS 1p
C2 net1 VSS 1p
I1 VDD net0 DC 1m
I2a net1 VSS DC 1m
I2b Vin VSS DC 1m
M0 net0 net0 VSS VSS nch l=0.15 w=1 nf=1 m=1
M1 Vout Vb Vin VSS nch l=0.15 w=1 nf=1 m=1
M2 Vin net0 VSS VSS nch l=0.15 w=1 nf=1 m=1
M3 Vout net1 VDD VDD pch l=0.15 w=1 nf=1 m=1
M4 net1 net1 VDD VDD pch l=0.15 w=1 nf=1 m=1
.ends dut
