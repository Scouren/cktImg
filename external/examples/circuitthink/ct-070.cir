* official Analog Canvas netlist; PDK X cards rewritten by convert.py
.model nch nmos
.model pch pmos

.global VDD

.subckt dut VSS Vb Vb2 Vout
CC Vout net0 1p
CE VDD Vb 1p
CL Vout VSS 1p
I1 net1 VSS DC 1m
M11 Vout Vb2 VSS VSS nch l=0.15 w=1 nf=1 m=1
M13 net2 net2 VDD VDD pch l=0.15 w=1 nf=1 m=1
M14 net1 net1 net2 VDD pch l=0.15 w=1 nf=1 m=1
M15 net0 net1 Vb VDD pch l=0.15 w=1 nf=1 m=1
M9 Vout Vb VDD VDD pch l=0.15 w=1 nf=1 m=1
.ends dut
