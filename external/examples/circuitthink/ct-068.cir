* official Analog Canvas netlist; PDK X cards rewritten by convert.py
.model nch nmos
.model pch pmos

.global VDD

.subckt dut VSS in out
I1 net2 VSS DC 1m
I2 net3 VSS DC 1m
I3 VDD net0 DC 1m
I4 VDD net1 DC 1m
M1 net0 in net2 VSS nch l=0.15 w=1 nf=1 m=1
M2 net1 out net3 VSS nch l=0.15 w=1 nf=1 m=1
M3 net2 net0 VDD VDD pch l=0.15 w=1 nf=1 m=1
M4 net3 net1 VDD VDD pch l=0.15 w=1 nf=1 m=1
RS net3 net2 1k
.ends dut
