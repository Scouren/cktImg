* official Analog Canvas netlist; PDK X cards rewritten by convert.py
.model nch nmos
.model pch pmos

.subckt dut VDD VSS Vin1 Vin2 Vb
CL net3 VSS 1p
CL2 net2 VSS 1p
ISS VDD net4 DC 1m
M1 net2 net1 VSS VSS nch l=0.15 w=1 nf=1 m=1
M10 net0 Vin2 net4 VDD pch l=0.15 w=1 nf=1 m=1
M11 net1 Vb VSS VSS nch l=0.15 w=1 nf=1 m=1
M12 net0 Vb VSS VSS nch l=0.15 w=1 nf=1 m=1
M2 net2 X VDD VDD pch l=0.15 w=1 nf=1 m=1
M3 net3 net0 VSS VSS nch l=0.15 w=1 nf=1 m=1
M4 net3 Y VDD VDD pch l=0.15 w=1 nf=1 m=1
M5 Y net1 VSS VSS nch l=0.15 w=1 nf=1 m=1
M6 X net0 VSS VSS nch l=0.15 w=1 nf=1 m=1
M7 X X VDD VDD pch l=0.15 w=1 nf=1 m=1
M8 Y Y VDD VDD pch l=0.15 w=1 nf=1 m=1
M9 net1 Vin1 net4 VDD pch l=0.15 w=1 nf=1 m=1
.ends dut
