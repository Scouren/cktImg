* official Analog Canvas netlist; PDK X cards rewritten by convert.py
.model nch nmos

.subckt dut VDD VSS Vout
C1 VDD Vout 1p
L1 net2 VSS 1n
LD VDD Vout 1n
LG net3 net1 1n
M1 net4 net3 net2 VSS nch l=0.15 w=1 nf=1 m=1
M2 Vout VDD net4 VSS nch l=0.15 w=1 nf=1 m=1
R1 VDD Vout 1k
RS net1 net0 1k
Vin net0 VSS DC 1
.ends dut
