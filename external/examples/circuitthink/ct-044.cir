* official Analog Canvas netlist; PDK X cards rewritten by convert.py
.model nch nmos
.model pch pmos

.subckt dut VDD VSS Vout1 Vin1
C5 VDD net0 1p
CGD Vout1 net0 1p
CL Vout1 VSS 1p
M1 net0 net1 VSS VSS nch l=0.15 w=1 nf=1 m=1
M5 Vout1 net0 VDD VDD pch l=0.15 w=1 nf=1 m=1
R5 VDD net0 1k
RD Vout1 VSS 1k
RS net1 Vin1 1k
.ends dut
