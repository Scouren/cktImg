* official Analog Canvas netlist; PDK X cards rewritten by convert.py
.model nch nmos

.subckt dut VDD VSS Vb
C1 net0 net3 1p
C2 net2 net1 1p
CT net4 VSS 1p
In net4 VSS DC 1m
ISS net4 VSS DC 1m
L1 VDD net3 1n
L2 VDD net2 1n
M1 net3 net1 net4 VSS nch l=0.15 w=1 nf=1 m=1
M2 net2 net0 net4 VSS nch l=0.15 w=1 nf=1 m=1
R1 net0 Vb 1k
R2 net1 Vb 1k
.ends dut
