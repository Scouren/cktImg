* official Analog Canvas netlist; PDK X cards rewritten by convert.py
.model nch nmos
.model pch pmos

.subckt dut VDD VSS Vcont
ISS net0 VSS DC 1m
LXY net2 net1 1n
M1 net1 net2 net0 VSS nch l=0.15 w=1 nf=1 m=1
M2 net2 net1 net0 VSS nch l=0.15 w=1 nf=1 m=1
M3 net1 net2 VDD VDD pch l=0.15 w=1 nf=1 m=1
M4 net2 net1 VDD VDD pch l=0.15 w=1 nf=1 m=1
Mv1 Vcont net1 Vcont Vcont nch l=0.15 w=1 nf=1 m=1
Mv2 Vcont net2 Vcont Vcont nch l=0.15 w=1 nf=1 m=1
.ends dut
