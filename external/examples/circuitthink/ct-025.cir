* official Analog Canvas netlist; PDK X cards rewritten by convert.py
.model nch nmos
.model pch pmos

.subckt dut VDD VSS Vin1 Vin2 Vout1 Vout2
I1 net0 VSS DC 1m
I2 net1 VSS DC 1m
I3 VDD X DC 1m
I4 VDD Y DC 1m
M1 X Vin1 net0 VSS nch l=0.15 w=1 nf=1 m=1
M2 Y Vin2 net1 VSS nch l=0.15 w=1 nf=1 m=1
M3 net0 X VDD VDD pch l=0.15 w=1 nf=1 m=1
M4 net1 Y VDD VDD pch l=0.15 w=1 nf=1 m=1
M5 Vout1 Y VDD VDD pch l=0.15 w=1 nf=1 m=1
M6 Vout2 X VDD VDD pch l=0.15 w=1 nf=1 m=1
RD1 Vout1 VSS 1k
RD2 Vout2 VSS 1k
RS net1 net0 1k
.ends dut
