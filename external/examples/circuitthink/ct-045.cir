* official Analog Canvas netlist; PDK X cards rewritten by convert.py
.model nch nmos
.model pch pmos

.subckt dut VDD VSS V1 V2
I1 net0 VSS DC 1m
I2 net1 VSS DC 1m
I3 VDD net3 DC 1m
I4 VDD net2 DC 1m
M1 net3 V1 net0 VSS nch l=0.15 w=1 nf=1 m=1
M2 net2 V2 net1 VSS nch l=0.15 w=1 nf=1 m=1
M3 net0 net3 VDD VDD pch l=0.15 w=1 nf=1 m=1
M4 net1 net2 VDD VDD pch l=0.15 w=1 nf=1 m=1
RS net1 net0 1k
.ends dut
