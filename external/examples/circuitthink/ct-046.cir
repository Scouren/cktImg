* official Analog Canvas netlist; PDK X cards rewritten by convert.py
.model nch nmos
.model pch pmos

.subckt dut VDD VSS Vinp Vinn Vb S1
.model ideal_switch SW(RON=1 ROFF=1e12 VT=0.5 VH=0)
C1 net0 net3 1p
C2 net1 net0 1p
ID net4 VSS DC 1m
M1 net3 Vinp net2 VSS nch l=0.15 w=1 nf=1 m=1
M2 net1 Vinn net2 VSS nch l=0.15 w=1 nf=1 m=1
M3 net3 Vb VDD VDD pch l=0.15 w=1 nf=1 m=1
M4 net1 Vb VDD VDD pch l=0.15 w=1 nf=1 m=1
M5 net2 net0 VSS VSS nch l=0.15 w=1 nf=1 m=1
M6 VDD net1 net4 VSS nch l=0.15 w=1 nf=1 m=1
M7 VDD net3 net4 VSS nch l=0.15 w=1 nf=1 m=1
S1 net0 net4 S1 VSS ideal_switch
.ends dut
