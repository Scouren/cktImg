* official Analog Canvas netlist; PDK X cards rewritten by convert.py
.model nch nmos
.model pch pmos

.subckt dut VDD VSS Vin Vout
CB net2 Vin 1p
CG VDD net1 1p
IB1 VDD net0 DC 1m
M1 Vout net2 VSS VSS nch l=0.15 w=1 nf=1 m=1
M2 Vout net1 VDD VDD pch l=0.15 w=1 nf=1 m=1
MB net0 net0 VSS VSS nch l=0.15 w=1 nf=1 m=1
R net2 net0 1k
RG Vout net1 1k
.ends dut
