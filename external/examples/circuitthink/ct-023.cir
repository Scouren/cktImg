* official Analog Canvas netlist; PDK X cards rewritten by convert.py
.model nch nmos
.model pch pmos

.subckt dut VDD VSS
M1 net1 net1 VSS VSS nch l=0.15 w=1 nf=1 m=1
M2 net0 net1 net3 VSS nch l=0.15 w=1 nf=1 m=1
M3 net0 net0 VDD VDD pch l=0.15 w=1 nf=1 m=1
M4 net1 net0 VDD VDD pch l=0.15 w=1 nf=1 m=1
M5 net0 X VSS VSS nch l=0.15 w=1 nf=1 m=1
M6 X net2 VSS VSS nch l=0.15 w=1 nf=1 m=1
Ra VDD net2 1k
Rb net2 X 1k
RS net3 VSS 1k
.ends dut
