* official Analog Canvas netlist; PDK X cards rewritten by convert.py
.model nch nmos
.model pch pmos

.subckt dut VDD VSS Vout
C1 net2 net3 1p
C2 net4 VSS 1p
I1 VDD net4 DC 1m
M1 net3 net1 VSS VSS nch l=0.15 w=1 nf=1 m=1
M2 Vout net1 VSS VSS nch l=0.15 w=1 nf=1 m=1
M3 VDD net2 Vout VSS nch l=0.15 w=1 nf=1 m=1
M4 net3 net1 net4 VDD pch l=0.15 w=1 nf=1 m=1
RB VDD net2 1k
RF net3 net1 1k
RS net1 net0 1k
Vin net0 VSS DC 1
.ends dut
