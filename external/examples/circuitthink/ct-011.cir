* official Analog Canvas netlist; PDK X cards rewritten by convert.py
.model nch nmos
.model pch pmos
.model qpnp pnp

.subckt dut VDD VSS
M1 net3 net3 net4 VSS nch l=0.15 w=1 nf=1 m=1
M2 net0 net3 net5 VSS nch l=0.15 w=1 nf=1 m=1
M3 net3 net0 VDD VDD pch l=0.15 w=1 nf=1 m=1
M4 net0 net0 VDD VDD pch l=0.15 w=1 nf=1 m=1
M5 net2 net0 VDD VDD pch l=0.15 w=1 nf=1 m=1
M6 net1 net0 VDD VDD pch l=0.15 w=1 nf=1 m=1
Q1 VSS net2 net6 qpnp m=1
Q2 VSS net1 net5 qpnp m=1
Q3 VSS VSS net2 qpnp m=1
Q4 VSS VSS net1 qpnp m=1
R1 net4 net6 1k
.ends dut
