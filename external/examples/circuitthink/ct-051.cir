* official Analog Canvas netlist; PDK X cards rewritten by convert.py
.model nch nmos
.model pch pmos

.subckt dut VDD VSS Vout Vb
IF net1 VSS DC 1m
M1 net0 VSS net2 VSS nch l=0.15 w=1 nf=1 m=1
M5 Vout VSS net0 VDD pch l=0.15 w=1 nf=1 m=1
M9 net2 Vb net1 VSS nch l=0.15 w=1 nf=1 m=1
ro2 Vout VSS 1k
rO3 VSS net0 1k
Ron8 net1 VSS 1k
.ends dut
