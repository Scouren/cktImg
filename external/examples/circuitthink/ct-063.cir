* official Analog Canvas netlist; PDK X cards rewritten by convert.py
.model nch nmos
.model pch pmos

.subckt dut VDD VSS + - 1 2
CL1 1 VSS 1p
CL2 VSS 2 1p
I5 G VSS DC 1m
ISS net0 VSS DC 1m
M1 1 + net0 VSS nch l=0.15 w=1 nf=1 m=1
M2 2 - net0 VSS nch l=0.15 w=1 nf=1 m=1
M3 1 G VDD VDD pch l=0.15 w=1 nf=1 m=1
M4 2 G VDD VDD pch l=0.15 w=1 nf=1 m=1
M5 G G VDD VDD pch l=0.15 w=1 nf=1 m=1
.ends dut
