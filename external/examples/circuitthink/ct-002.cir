* official Analog Canvas netlist; PDK X cards rewritten by convert.py
.model nch nmos

.subckt dut VDD VSS VB1
Cu1 net1 net2 1p
Cu2 net0 net4 1p
ISS net3 VSS DC 1m
L1 VDD net1 1n
L2 VDD net0 1n
M1 net1 net0 net3 VSS nch l=0.15 w=1 nf=1 m=1
M2 net0 net1 net3 VSS nch l=0.15 w=1 nf=1 m=1
M3 net2 VB1 net4 VSS nch l=0.15 w=1 nf=1 m=1
M4 net2 VB1 VSS VSS nch l=0.15 w=1 nf=1 m=1
M5 net4 VB1 VSS VSS nch l=0.15 w=1 nf=1 m=1
.ends dut
