* official Analog Canvas netlist; PDK X cards rewritten by convert.py
.model nch nmos
.model pch pmos

.global VDD

.subckt dut VSS Vin1 Vin2 Vout
C1 Vout net1 1p
ISS net0 VSS DC 1m
M1 net1 Vin1 net0 VSS nch l=0.15 w=1 nf=1 m=1
M2 Vout Vin2 net0 VSS nch l=0.15 w=1 nf=1 m=1
M3 net1 net1 VDD VDD pch l=0.15 w=1 nf=1 m=1
M4 Vout net1 VDD VDD pch l=0.15 w=1 nf=1 m=1
.ends dut
