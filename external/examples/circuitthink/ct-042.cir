* official Analog Canvas netlist; PDK X cards rewritten by convert.py
.model nch nmos
.model pch pmos

.subckt dut VDD VSS Vout Vin
C1 net2 VSS 1p
C2 Vout VSS 1p
I1 net0 VSS DC 1m
I2 Vout VSS DC 1m
M1 net1 Vin net0 VSS nch l=0.15 w=1 nf=1 m=1
M2 net2 Vout net0 VSS nch l=0.15 w=1 nf=1 m=1
M3 net1 net1 VDD VDD pch l=0.15 w=1 nf=1 m=1
M4 net2 net1 VDD VDD pch l=0.15 w=1 nf=1 m=1
M5 VDD net2 Vout VSS nch l=0.15 w=1 nf=1 m=1
.ends dut
