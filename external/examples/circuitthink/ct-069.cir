* official Analog Canvas netlist; PDK X cards rewritten by convert.py
.model nch nmos
.model pch pmos

.global VDD

.subckt dut VSS Vout
CF Vout net0 1p
CL Vout VSS 1p
I1 net1 VSS DC 1m
I2 net0 VSS DC 1m
Mout Vout net0 VSS VSS nch l=0.15 w=1 nf=1 m=1
Mp1 Vout net1 VDD VDD pch l=0.15 w=1 nf=1 m=1
Mp2 net1 net1 VDD VDD pch l=0.15 w=1 nf=1 m=1
.ends dut
