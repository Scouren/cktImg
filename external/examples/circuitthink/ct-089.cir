* official Analog Canvas netlist; PDK X cards rewritten by convert.py
.model nch nmos
.model pch pmos

.subckt dut VDD VSS Vin+ Vin- Vout Vb
ISS net2 VSS DC 1m
M1 net3 Vin+ net2 VSS nch l=0.15 w=1 nf=1 m=1
M2 net0 Vin- net2 VSS nch l=0.15 w=1 nf=1 m=1
M3 net3 Vb VDD VDD pch l=0.15 w=1 nf=1 m=1
M4 net0 Vb VDD VDD pch l=0.15 w=1 nf=1 m=1
M5 net1 net3 VDD VDD pch l=0.15 w=1 nf=1 m=1
M6 Vout net0 VDD VDD pch l=0.15 w=1 nf=1 m=1
M7 net1 net1 VSS VSS nch l=0.15 w=1 nf=1 m=1
M8 Vout net1 VSS VSS nch l=0.15 w=1 nf=1 m=1
.ends dut
