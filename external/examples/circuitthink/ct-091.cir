* official Analog Canvas netlist; PDK X cards rewritten by convert.py
.model nch nmos
.model pch pmos

.subckt dut VDD VSS VinCM Vout
M1 Vout VinCM net0 VSS nch l=0.15 w=1 nf=1 m=1
M2 Vout VinCM net0 VSS nch l=0.15 w=1 nf=1 m=1
M3 Vout Vout VDD VDD pch l=0.15 w=1 nf=1 m=1
M4 Vout Vout VDD VDD pch l=0.15 w=1 nf=1 m=1
RSS net0 VSS 1k
.ends dut
