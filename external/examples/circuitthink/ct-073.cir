* official Analog Canvas netlist; PDK X cards rewritten by convert.py
.model nch nmos
.model pch pmos

.global VDD

.subckt dut VSS D Q CK
CL Q VSS 1p
M1 A D VDD VDD pch l=0.15 w=1 nf=1 m=1
M2 A CK E VSS nch l=0.15 w=1 nf=1 m=1
M3 E D VSS VSS nch l=0.15 w=1 nf=1 m=1
M4 B A VDD VDD pch l=0.15 w=1 nf=1 m=1
M5 C CK B VDD pch l=0.15 w=1 nf=1 m=1
M6 C E VSS VSS nch l=0.15 w=1 nf=1 m=1
M7 Q B VDD VDD pch l=0.15 w=1 nf=1 m=1
M8 Q C VSS VSS nch l=0.15 w=1 nf=1 m=1
.ends dut
