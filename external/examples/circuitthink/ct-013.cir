* official Analog Canvas netlist; PDK X cards rewritten by convert.py
.model nch nmos

.subckt dut VDD VSS Vcont
C1 VDD net0 1p
C1B VDD net2 1p
ISS net1 VSS DC 1m
L1 VDD net0 1n
L2 VDD net2 1n
M1 net0 net2 net1 VSS nch l=0.15 w=1 nf=1 m=1
M2 net2 net0 net1 VSS nch l=0.15 w=1 nf=1 m=1
Mv1 Vcont net0 Vcont Vcont nch l=0.15 w=1 nf=1 m=1
Mv2 Vcont net2 Vcont Vcont nch l=0.15 w=1 nf=1 m=1
RP VDD net0 1k
Rp2 VDD net2 1k
.ends dut
