* official Analog Canvas netlist; PDK X cards rewritten by convert.py
.model nch nmos
.model pch pmos

.global VDD

.subckt dut VSS Vin Vout Vb
C1 Vout net2 1p
C2 net1 VSS 1p
M1 net0 Vin VSS VSS nch l=0.15 w=1 nf=1 m=1
M2 Vout net2 net0 VSS nch l=0.15 w=1 nf=1 m=1
M3 Vout net1 VDD VDD pch l=0.15 w=1 nf=1 m=1
R1 net2 Vb 1k
R2 Vout net1 1k
.ends dut
