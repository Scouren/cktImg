* official Analog Canvas netlist; PDK X cards rewritten by convert.py
.model nch nmos
.model pch pmos

.subckt dut VDD VSS Vin Vin2
CL net0 VSS 1p
CL2 net1 VSS 1p
M1 net1 Vin VSS VSS nch l=0.15 w=1 nf=1 m=1
M2 net1 X VDD VDD pch l=0.15 w=1 nf=1 m=1
M3 net0 Vin2 VSS VSS nch l=0.15 w=1 nf=1 m=1
M4 net0 Y VDD VDD pch l=0.15 w=1 nf=1 m=1
M5 Y Vin VSS VSS nch l=0.15 w=1 nf=1 m=1
M6 X Vin2 VSS VSS nch l=0.15 w=1 nf=1 m=1
M7 X X VDD VDD pch l=0.15 w=1 nf=1 m=1
M8 Y Y VDD VDD pch l=0.15 w=1 nf=1 m=1
.ends dut
