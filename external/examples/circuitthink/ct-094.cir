* official Analog Canvas netlist; PDK X cards rewritten by convert.py
.model nch nmos

.subckt dut VDD VSS Vout
CGS2 net1 Vout 1p
I1 Vout VSS DC 1m
Iin VSS net0 DC 1m
M1 net1 net0 VSS VSS nch l=0.15 w=1 nf=1 m=1
M2 VDD net1 Vout VSS nch l=0.15 w=1 nf=1 m=1
RD VDD net1 1k
RF Vout net0 1k
.ends dut
