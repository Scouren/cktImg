* official Analog Canvas netlist; PDK X cards rewritten by convert.py
.model nch nmos
.model pch pmos

.subckt dut VDD VSS V1 V2 Vout
I1 net2 VSS DC 1m
ISS net0 VSS DC 1m
M1 net1 V1 net0 VSS nch l=0.15 w=1 nf=1 m=1
M2 Vout V2 net0 VSS nch l=0.15 w=1 nf=1 m=1
M3 net1 net2 VDD VDD pch l=0.15 w=1 nf=1 m=1
M4 Vout net2 VDD VDD pch l=0.15 w=1 nf=1 m=1
R1 net2 net1 1k
.ends dut
