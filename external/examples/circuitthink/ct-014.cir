* official Analog Canvas netlist; PDK X cards rewritten by convert.py
.model nch nmos
.model pch pmos
.model qpnp pnp

.subckt dut VDD VSS Vout
M1 net4 net4 net1 VSS nch l=0.15 w=1 nf=1 m=1
M2 net0 net4 net2 VSS nch l=0.15 w=1 nf=1 m=1
M3 net4 net0 VDD VDD pch l=0.15 w=1 nf=1 m=1
M4 net0 net0 VDD VDD pch l=0.15 w=1 nf=1 m=1
M5 Vout net0 VDD VDD pch l=0.15 w=1 nf=1 m=1
Q1 VSS VSS net1 qpnp m=1
Q2 VSS VSS net5 qpnp m=1
Q3 VSS VSS net3 qpnp m=1
R1 net2 net5 1k
R2 Vout net3 1k
.ends dut
