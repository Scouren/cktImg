* official Analog Canvas netlist; PDK X cards rewritten by convert.py
.model nch nmos
.model pch pmos
.model qpnp pnp

.subckt dut VDD VSS
ISS net4 VSS DC 1m
M3 net1 net2 VDD VDD pch l=0.15 w=1 nf=1 m=1
M4 net5 net2 VDD VDD pch l=0.15 w=1 nf=1 m=1
Ma net2 net1 net4 VSS nch l=0.15 w=1 nf=1 m=1
Mb net3 net5 net4 VSS nch l=0.15 w=1 nf=1 m=1
Mc net2 net3 VDD VDD pch l=0.15 w=1 nf=1 m=1
Md net3 net3 VDD VDD pch l=0.15 w=1 nf=1 m=1
Q1 VSS VSS net1 qpnp m=1
Q2 VSS VSS net0 qpnp m=1
R1 net5 net0 1k
R2 net5 VSS 1k
R3 net1 VSS 1k
.ends dut
