* official Analog Canvas netlist; PDK X cards rewritten by convert.py
.model nch nmos
.model pch pmos

.global VDD

.subckt dut VSS Vin+ Vin- Vout1 Vout2 Vb1
ISS net0 VSS DC 1m
M1 X Vin+ net0 VSS nch l=0.15 w=1 nf=1 m=1
M2 Y Vin- net0 VSS nch l=0.15 w=1 nf=1 m=1
M3 X Vb1 VDD VDD pch l=0.15 w=1 nf=1 m=1
M4 Y Vb1 VDD VDD pch l=0.15 w=1 nf=1 m=1
M5 Vout1 X VDD VDD pch l=0.15 w=1 nf=1 m=1
M6 Vout2 Y VDD VDD pch l=0.15 w=1 nf=1 m=1
M7 Vout1 Vb1 VSS VSS nch l=0.15 w=1 nf=1 m=1
M8 Vout2 Vb1 VSS VSS nch l=0.15 w=1 nf=1 m=1
.ends dut
