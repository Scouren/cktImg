* official Analog Canvas netlist; PDK X cards rewritten by convert.py
.model nch nmos
.model pch pmos

.subckt dut VDD VSS Vin V1 Vout
CL Vout VSS 1p
ISS net1 VSS DC 1m
M1 net0 Vin net1 VSS nch l=0.15 w=1 nf=1 m=1
M2 Vout V1 net1 VSS nch l=0.15 w=1 nf=1 m=1
M3 net0 net0 VDD VDD pch l=0.15 w=1 nf=1 m=1
M4 Vout net0 VDD VDD pch l=0.15 w=1 nf=1 m=1
.ends dut
