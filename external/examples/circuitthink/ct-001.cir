* official Analog Canvas netlist; PDK X cards rewritten by convert.py
.model nch nmos

.subckt dut VDD VSS Vout
CA net1 VSS 1p
CX net0 VSS 1p
CY Vout VSS 1p
I1 Vout VSS DC 1m
Iin VSS net1 DC 1m
M1 net0 net1 VSS VSS nch l=0.15 w=1 nf=1 m=1
M2 VDD net0 Vout VSS nch l=0.15 w=1 nf=1 m=1
RD VDD net0 1k
RF Vout net1 1k
.ends dut
