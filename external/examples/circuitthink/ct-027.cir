* official Analog Canvas netlist; PDK X cards rewritten by convert.py
.model nch nmos

.subckt dut VDD VSS
C1 A X 1p
C2 Y B 1p
C3 X VSS 1p
C4 Y VSS 1p
I1 X VSS DC 1m
I2 Y VSS DC 1m
L1 P A 1n
L2 B P 1n
M1 VDD A X VSS nch l=0.15 w=1 nf=1 m=1
M2 VDD B Y VSS nch l=0.15 w=1 nf=1 m=1
R1 VDD P 1k
.ends dut
