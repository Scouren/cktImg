* official Analog Canvas netlist; PDK X cards rewritten by convert.py
.model nch nmos
.model pch pmos

.subckt dut VDD VSS Vin Vout Vb
CL1 net0 VSS 1p
CL2 Vout VSS 1p
M1 net0 Vin VSS VSS nch l=0.15 w=1 nf=1 m=1
M2 net0 Vb VDD VDD pch l=0.15 w=1 nf=1 m=1
M3 Vout net0 VSS VSS nch l=0.15 w=1 nf=1 m=1
M4 Vout Vb VDD VDD pch l=0.15 w=1 nf=1 m=1
.ends dut
