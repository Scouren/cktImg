* official Analog Canvas netlist; PDK X cards rewritten by convert.py
.model nch nmos

.subckt dut VDD VSS
C1 VDD net0 1p
C2 VDD net1 1p
ISS net2 VSS DC 1m
L1 VDD net0 1n
L2 VDD net1 1n
M1 net0 net1 net2 VSS nch l=0.15 w=1 nf=1 m=1
M2 net1 net0 net2 VSS nch l=0.15 w=1 nf=1 m=1
RP1 VDD net0 1k
Rp2 VDD net1 1k
.ends dut
