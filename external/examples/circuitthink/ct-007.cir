* official Analog Canvas netlist; PDK X cards rewritten by convert.py
.model nch nmos

.subckt dut VDD VSS Vout
CP1 VDD net0 1p
CP2 VDD Vout 1p
LP1 VDD net0 1n
LP2 VDD Vout 1n
M1 net0 Vout VSS VSS nch l=0.15 w=1 nf=1 m=1
M2 Vout net0 VSS VSS nch l=0.15 w=1 nf=1 m=1
R1 VDD net0 1k
RP2 VDD Vout 1k
.ends dut
