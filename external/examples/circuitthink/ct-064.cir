* official Analog Canvas netlist; PDK X cards rewritten by convert.py
.model nch nmos
.model pch pmos

.global VDD

.subckt dut VSS + - Vout1 Vout2
CL1 Vout1 VSS 1p
CL2 Vout2 VSS 1p
ISS1 net0 VSS DC 1m
ISS2 tail2 VSS DC 1m
M1 Vout1 + net0 VSS nch l=0.15 w=1 nf=1 m=1
M2 Vout1 X VDD VDD pch l=0.15 w=1 nf=1 m=1
M3 Vout2 - net0 VSS nch l=0.15 w=1 nf=1 m=1
M4 Vout2 Y VDD VDD pch l=0.15 w=1 nf=1 m=1
M5 Y + tail2 VSS nch l=0.15 w=1 nf=1 m=1
M6 X - tail2 VSS nch l=0.15 w=1 nf=1 m=1
M7 X X VDD VDD pch l=0.15 w=1 nf=1 m=1
M8 Y Y VDD VDD pch l=0.15 w=1 nf=1 m=1
.ends dut
