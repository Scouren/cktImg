* official Analog Canvas netlist; PDK X cards rewritten by convert.py
.model nch nmos
.model pch pmos

.subckt dut VDD VSS Vb Vout
CC Vout net3 1p
CE VDD Vb 1p
CL Vout VSS 1p
M11 Vout net0 VSS VSS nch l=0.15 w=1 nf=1 m=1
M9 Vout Vb VDD VDD pch l=0.15 w=1 nf=1 m=1
Mb1 net0 net0 VSS VSS nch l=0.15 w=1 nf=1 m=1
Mb2 net1 net0 VSS VSS nch l=0.15 w=1 nf=1 m=1
Mb3 net0 net1 VDD VDD pch l=0.15 w=1 nf=1 m=1
Mb4 net1 net1 net2 VDD pch l=0.15 w=1 nf=1 m=1
RS VDD net2 1k
RZ net3 Vb 1k
.ends dut
