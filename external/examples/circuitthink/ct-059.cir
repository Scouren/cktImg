* official Analog Canvas netlist; PDK X cards rewritten by convert.py
.model nch nmos
.model pch pmos

.subckt dut VDD VSS V1 V2
ISS P VSS DC 1m
M1 F V1 P VSS nch l=0.15 w=1 nf=1 m=1
M2 X V2 P VSS nch l=0.15 w=1 nf=1 m=1
M3 F F VDD VDD pch l=0.15 w=1 nf=1 m=1
M4 X F VDD VDD pch l=0.15 w=1 nf=1 m=1
rO1 F P 1k
rO2 X P 1k
.ends dut
