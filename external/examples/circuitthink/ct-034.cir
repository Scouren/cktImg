* official Analog Canvas netlist; PDK X cards rewritten by convert.py
.model nch nmos
.model pch pmos

.subckt dut VDD VSS 1 2 Vout1 Vout2 Vb
Iin VDD net1 DC 1m
M1 X 1 net1 VDD pch l=0.15 w=1 nf=1 m=1
M10 net0 X VSS VSS nch l=0.15 w=1 nf=1 m=1
M11 net2 net2 VDD VDD pch l=0.15 w=1 nf=1 m=1
M12 net0 net0 VDD VDD pch l=0.15 w=1 nf=1 m=1
M2 Y 2 net1 VDD pch l=0.15 w=1 nf=1 m=1
M3 X Vb VSS VSS nch l=0.15 w=1 nf=1 m=1
M4 Y Vb VSS VSS nch l=0.15 w=1 nf=1 m=1
M5 Vout1 X VSS VSS nch l=0.15 w=1 nf=1 m=1
M6 Vout2 Y VSS VSS nch l=0.15 w=1 nf=1 m=1
M7 Vout1 net2 VDD VDD pch l=0.15 w=1 nf=1 m=1
M8 Vout2 net0 VDD VDD pch l=0.15 w=1 nf=1 m=1
M9 net2 Y VSS VSS nch l=0.15 w=1 nf=1 m=1
.ends dut
