* official Analog Canvas netlist; PDK X cards rewritten by convert.py
.model nch nmos

.subckt dut VDD VSS
CB net2 VSS 1p
CT net3 VSS 1p
In net3 VSS DC 1m
ISS net3 VSS DC 1m
L1 VDD net1 1n
L2 VDD net0 1n
LT net2 net3 1n
M1 net1 net0 net2 VSS nch l=0.15 w=1 nf=1 m=1
M2 net0 net1 net2 VSS nch l=0.15 w=1 nf=1 m=1
.ends dut
