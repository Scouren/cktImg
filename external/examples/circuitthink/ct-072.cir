* official Analog Canvas netlist; PDK X cards rewritten by convert.py
.model nch nmos
.model pch pmos

.global VDD

.subckt dut VSS 1 2
I7 net2 VSS DC 1m
M1 net0 1 P VSS nch l=0.15 w=1 nf=1 m=1
M2 net1 2 P VSS nch l=0.15 w=1 nf=1 m=1
M3 net0 net2 VDD VDD pch l=0.15 w=1 nf=1 m=1
M4 net1 net2 VDD VDD pch l=0.15 w=1 nf=1 m=1
M5 P net0 VSS VSS nch l=0.15 w=1 nf=1 m=1
M6 P net1 VSS VSS nch l=0.15 w=1 nf=1 m=1
M7 net2 net2 VDD VDD pch l=0.15 w=1 nf=1 m=1
.ends dut
