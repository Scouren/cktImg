* official Analog Canvas netlist; PDK X cards rewritten by convert.py
.model nch nmos

.global VDD

.subckt dut VSS A B C D Vout Vb
ISS1 net1 VSS DC 1m
ISS2 net0 VSS DC 1m
M1 VDD A net1 VSS nch l=0.15 w=1 nf=1 m=1
M2 VDD B net1 VSS nch l=0.15 w=1 nf=1 m=1
M3 Vout Vb net1 VSS nch l=0.15 w=1 nf=1 m=1
M4 VDD D net0 VSS nch l=0.15 w=1 nf=1 m=1
M5 VDD C net0 VSS nch l=0.15 w=1 nf=1 m=1
M6 Vout Vb net0 VSS nch l=0.15 w=1 nf=1 m=1
RD VDD Vout 1k
.ends dut
