Five-transistor OTA
* Golden figure: notes Amplifiers/Current Mirrors.md:625, after Razavi Figs. 5.26(b) and 5.27.
* `*% device x y gate` is the device's node in the figure (cm, y up) and the side its gate faces.
.model nch nmos level=1
.model pch pmos level=1
Vdd vdd 0 1.8
Vin1 vin1 0 dc 0.9 ac 1
Vin2 vin2 0 dc 0.9
Vb vb 0 0.7
M1 f vin1 p 0 nch
M2 vout vin2 p 0 nch
M3 f f vdd vdd pch
M4 vout f vdd vdd pch
M5 p vb 0 0 nch
*% M3 0 3.2 R
*% M4 2.6 3.2 L
*% M1 0 1.2 L
*% M2 2.6 1.2 R
*% M5 1.3 -1.2 L
*% labels
