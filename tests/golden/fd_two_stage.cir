Fully differential two-stage op amp
* Golden figure: notes Amplifiers/Operational Amplifiers.md:356, after Razavi Fig. 9.23.
.model nch nmos level=1
.model pch pmos level=1
Vdd vdd 0 1.8
Vin1 vin1 0 dc 0.9 ac 1
Vin2 vin2 0 dc 0.9
Vb1 vb1 0 1.0
Vb2 vb2 0 0.6
M1 x vin1 p 0 nch
M2 y vin2 p 0 nch
M3 x vb1 vdd vdd pch
M4 y vb1 vdd vdd pch
M5 vout1 x vdd vdd pch
M6 vout2 y vdd vdd pch
M7 vout1 vb2 0 0 nch
M8 vout2 vb2 0 0 nch
Iss p 0 200u
*% M1 2.5 0 L
*% M2 5.5 0 R
*% M3 2.5 2.2 R
*% M4 5.5 2.2 L
*% M5 -1 2.2 R
*% M6 9 2.2 L
*% M7 -1 0 R
*% M8 9 0 L
*% Iss 4 -1.535 -
*% labels vb2
