StrongARM latch with precharge switches
* Golden figure: notes Comparators/Comparators.md:384, after Razavi, Data Converters Fig. 5.37(c). The book's switches are PMOS with gate CK.
.model nch nmos level=1
.model pch pmos level=1
.model sw sw
Vdd vdd 0 1.8
Vin1 vin1 0 dc 0.9 ac 1
Vin2 vin2 0 dc 0.9
Vck ck 0 pulse(0 1.8 0 10p 10p 1n 2n)
MT t ck 0 0 nch
M1 p vin1 t 0 nch
M2 q vin2 t 0 nch
M5 x y p 0 nch
M6 y x q 0 nch
M3 x y vdd vdd pch
M4 y x vdd vdd pch
S1 vdd x ck 0 sw
S2 vdd y ck 0 sw
S3 vdd p ck 0 sw
S4 vdd q ck 0 sw
*% M1 0 0 L
*% M2 4 0 R
*% MT 2 -2 L
*% M5 0 2 R
*% M6 4 2 L
*% M3 0 4.4 R
*% M4 4 4.4 L
*% S1 -1 4.4 -
*% S2 5 4.4 -
*% S3 -1.8 3.3 -
*% S4 5.8 3.3 -
*% labels ck
