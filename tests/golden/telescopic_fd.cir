Fully differential telescopic cascode
* Golden figure: notes Amplifiers/Operational Amplifiers.md:172, after Razavi Figs. 9.8(b) and 9.11.
.model nch nmos level=1
.model pch pmos level=1
Vdd vdd 0 1.8
Vin1 vin1 0 dc 0.9 ac 1
Vin2 vin2 0 dc 0.9
Vb1 vb1 0 1.0
Vb2 vb2 0 1.0
Vb3 vb3 0 1.2
M1 x vin1 p 0 nch
M2 y vin2 p 0 nch
M3 vout1 vb1 x 0 nch
M4 vout2 vb1 y 0 nch
M5 vout1 vb2 a vdd pch
M6 vout2 vb2 b vdd pch
M7 a vb3 vdd vdd pch
M8 b vb3 vdd vdd pch
Iss p 0 200u
*% M1 0 0 L
*% M2 3 0 R
*% M3 0 1.8 R
*% M4 3 1.8 L
*% M5 0 3.6 R
*% M6 3 3.6 L
*% M7 0 5.4 R
*% M8 3 5.4 L
*% Iss 1.5 -1.535 -
*% labels
