Differential pair with resistive loads
* Golden figure: notes Amplifiers/Differential Amplifiers.md:15, after Razavi Figs. 4.7 and 4.8.
.model nch nmos level=1
Vdd vdd 0 1.8
Vin1 vin1 0 dc 0.9 ac 0.5
Vin2 vin2 0 dc 0.9 ac -0.5
Rd1 vdd vout1 5k
Rd2 vdd vout2 5k
M1 vout1 vin1 p 0 nch
M2 vout2 vin2 p 0 nch
Iss p 0 200u
*% M1 0 0 L
*% M2 2.6 0 R
*% Iss 1.3 -2 -
*% Rd1 0 1.635 -
*% Rd2 2.6 1.635 -
*% labels
