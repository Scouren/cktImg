Supply-independent bias with a start-up device
* Golden figure: notes Amplifiers/Biasing.md:562, after Razavi Figs. 12.3(a) and 12.5.
.model nch nmos level=1
.model pch pmos level=1
Vdd vdd 0 1.8
M4 a b vdd vdd pch
M3 b b vdd vdd pch
M1 a a 0 0 nch
M2 b a s 0 nch
Rs s 0 2k
M5 b b a 0 nch
*% M4 0 3 R
*% M3 3 3 L
*% M1 0 0 R
*% M2 3 0 L
*% M5 1.7 1.6 L
*% Rs 3 -1.47 -
*% labels
