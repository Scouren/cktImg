Cascode current mirror
* Golden figure: notes Amplifiers/Current Mirrors.md:298, after Razavi Fig. 5.12(c) and Carusone, Johns and Martin Fig. 3.14.
.model nch nmos level=1
Vdd vdd 0 1.8
Iref vdd n 100u
M0 n n x 0 nch
M1 x x 0 0 nch
M3 out n y 0 nch
M2 y x 0 0 nch
*% M1 0 0 R
*% M0 0 1.8 R
*% M2 2.6 0 L
*% M3 2.6 1.8 L
*% Iref 0 3.82 -
*% labels
