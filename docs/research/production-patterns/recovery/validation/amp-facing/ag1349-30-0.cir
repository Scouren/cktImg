* official Analog Canvas netlist; PDK X cards rewritten by convert.py
.model nch nmos
.model pch pmos

.subckt EA VDD VSS INN INP OUT
MN1 net3 INN net5 VSS nch l=0.15 w=1 nf=1 m=1
MN2 OUT INP net5 VSS nch l=0.15 w=1 nf=1 m=1
MN3 net2 net2 VSS VSS nch l=0.15 w=1 nf=1 m=1
MN4 net5 net2 VSS VSS nch l=0.15 w=1 nf=1 m=1
MN5 net0 net4 net1 VSS nch l=0.15 w=1 nf=1 m=1
MN6 net4 net1 VSS VSS nch l=0.15 w=1 nf=1 m=1
MP1 net3 net3 VDD VDD pch l=0.15 w=1 nf=1 m=1
MP2 OUT net3 VDD VDD pch l=0.15 w=1 nf=1 m=1
MP3 net2 net0 VDD VDD pch l=0.15 w=1 nf=1 m=1
MP4 net0 net0 VDD VDD pch l=0.15 w=1 nf=1 m=1
MP5 net4 net0 VDD VDD pch l=0.15 w=1 nf=1 m=1
RBIAS net1 VSS 1k
.ends EA

.subckt ISR VDD VSS TOP OUT CTRL VB3
MN7 net1 net1 VSS VSS nch l=0.15 w=1 nf=1 m=1
MN8 net0 net1 VSS VSS nch l=0.15 w=1 nf=1 m=1
MN9 net1 VB3 VSS VSS nch l=0.15 w=1 nf=1 m=1
MP6 net0 net0 TOP VDD pch l=0.15 w=1 nf=1 m=1
MP7 OUT net0 TOP VDD pch l=0.15 w=1 nf=1 m=1
MP8 net1 CTRL TOP VDD pch l=0.15 w=1 nf=1 m=1
.ends ISR

.subckt dut VDD VSS VCONT1 VREF VCONT2 VCONT5 VP VCONT3 VIN VB3 VCONT4
.model DIODE D(IS=1e-14 N=1)
CFLY VX1 VX2 1p
CO VP VN 1p
COP VP VSS 1p
D1 VN VX2 DIODE
L1 VX1 VX3 1n
M1 VX1 VCONT2 VIN VDD pch l=0.15 w=1 nf=1 m=1
M2 VX2 VCONT3 VIN VDD pch l=0.15 w=1 nf=1 m=1
M3 VX3 VCONT5 VP VDD pch l=0.15 w=1 nf=1 m=1
M4 VX3 VCONT4 VSS VSS nch l=0.15 w=1 nf=1 m=1
M5 net0 VCONT1 VIN VDD pch l=0.15 w=1 nf=1 m=1
R1 VP VFP1 1k
R2 VFP1 VSS 1k
X1 VDD VSS net0 VX1 net1 VB3 ISR
X2 VDD VSS VFP1 VREF net1 EA
*@ at x1 4.25 7.75 MR0
*@ at x2 11.75 8.25 MR0
.ends dut
