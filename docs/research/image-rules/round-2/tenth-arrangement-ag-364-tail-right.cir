* official analog canvas netlist; pdk x cards rewritten by convert.py
.model nch nmos
.model pch pmos

.subckt dut vdd vss vb3 vb2 vb1 vin1 vin2 vb4 vb5 vout1 vout2
m1 net0 vin1 p vss nch l=0.15 w=1 nf=1 m=1
m10 vout2 y ptail vdd pch l=0.15 w=1 nf=1 m=1
m11 vout1 vb5 vss vss nch l=0.15 w=1 nf=1 m=1
m12 vout2 vb5 vss vss nch l=0.15 w=1 nf=1 m=1
m13 p vb4 vss vss nch l=0.15 w=1 nf=1 m=1
m2 net2 vin2 p vss nch l=0.15 w=1 nf=1 m=1
m3 x vb1 net0 vss nch l=0.15 w=1 nf=1 m=1
m4 y vb1 net2 vss nch l=0.15 w=1 nf=1 m=1
m5 x vb2 net3 vdd pch l=0.15 w=1 nf=1 m=1
m6 y vb2 net1 vdd pch l=0.15 w=1 nf=1 m=1
m7 net3 vb3 vdd vdd pch l=0.15 w=1 nf=1 m=1
m8 net1 vb3 vdd vdd pch l=0.15 w=1 nf=1 m=1
m9 vout1 x ptail vdd pch l=0.15 w=1 nf=1 m=1
m14 ptail vb3 vdd vdd pch l=0.15 w=1 nf=1 m=1
*@ at m1 9 5.5 r270
*@ at m10 38.25 3 mr270
*@ at m11 31.75 7.5 mr90
*@ at m12 38.25 7.5 r270
*@ at m13 10 7.5 r270
*@ at m14 35 -2.5 mr270
*@ at m2 11 5.5 mr90
*@ at m3 9 4 mr90
*@ at m4 11 4 r270
*@ at m5 9 2 r90
*@ at m6 11 2 mr270
*@ at m7 9 0.5 r90
*@ at m8 11 0.5 mr270
*@ at m9 31.75 3 r90
.ends dut
