* official Analog Canvas netlist; PDK X cards rewritten by convert.py
.model nch nmos

.subckt DAC O1 O2
*@ right O1
*@ right O2
.ends DAC

.subckt dut VDD VSS LO LO_bar VRF+ VRF-
I1 A VSS DC 1m
L1 VDD VRF+ 1n
L2 VDD VRF- 1n
M1 net3 net0 A VSS nch l=0.15 w=1 nf=1 m=1
M2 net1 net2 A VSS nch l=0.15 w=1 nf=1 m=1
M3 VRF- LO net3 VSS nch l=0.15 w=1 nf=1 m=1
M4 VRF+ LO net1 VSS nch l=0.15 w=1 nf=1 m=1
M5 VRF+ LO_bar net3 VSS nch l=0.15 w=1 nf=1 m=1
M6 VRF- LO_bar net1 VSS nch l=0.15 w=1 nf=1 m=1
X1 net0 net2 DAC
.ends dut
