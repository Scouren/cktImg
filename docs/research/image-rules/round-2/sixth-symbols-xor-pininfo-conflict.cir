* Digital complete-contract probe.
.subckt xor_gate VDD VSS A B Y
*.PININFO A:O B:I Y:I VDD:B VSS:B
.ends xor_gate
.subckt dut VDD VSS I J O
X1 VDD VSS I J O xor_gate
.ends dut
