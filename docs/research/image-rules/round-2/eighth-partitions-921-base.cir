* official Analog Canvas netlist; PDK X cards rewritten by convert.py
.model nch nmos
.model pch pmos

.subckt dut VDD VSS Vo1 Vi1 Vo2 Vi2 VBIAS VB2 VCM
M1 Vo1 Vi1 net0 VSS nch l=0.15 w=1 nf=1 m=1
M10 net1 net1 VSS VSS nch l=0.15 w=1 nf=1 m=1
M2 Vo2 Vi2 net0 VSS nch l=0.15 w=1 nf=1 m=1
M3 Vo1 VBIAS VDD VDD pch l=0.15 w=1 nf=1 m=1
M4 Vo2 VBIAS VDD VDD pch l=0.15 w=1 nf=1 m=1
M5 net0 Vcmc VSS VSS nch l=0.15 w=1 nf=1 m=1
M6 net2 VB2 VDD VDD pch l=0.15 w=1 nf=1 m=1
M7 Vcmc VCM net2 VDD pch l=0.15 w=1 nf=1 m=1
M8 net1 net3 net2 VDD pch l=0.15 w=1 nf=1 m=1
M9 Vcmc Vcmc VSS VSS nch l=0.15 w=1 nf=1 m=1
R1 Vo1 net3 1k
R2 net3 Vo2 1k
.ends dut
