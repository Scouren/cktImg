* One amplifier has two complete, private bias-peer embeddings.
.subckt opamp VDD VSS INN INP OUT VB1 VB2
.ends opamp
.subckt bias VDD VSS NB
.ends bias
.subckt dut VDD VSS INN INP OUT VB2
XAMP VDD VSS INN INP OUT ba VB2 opamp
XBA VDD VSS ba bias
RX VDD VSS 1k
*@ at RX -30 -30 r90
.ends dut
